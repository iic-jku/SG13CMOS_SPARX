* sparx_core_le - lumped-element equivalent (Ngspice / SPICE3)
* generated by snp2le
* EQUIVALENT CIRCUIT FOR VECTOR FITTED S-MATRIX
* Created using scikit-rf vectorFitting.py
*
*
* thermal noise of the passive: kT(I - S S^H) at the ports, from a spectral factor of this fit
* sources Rnz_e1..Rnz_e7 (0.25 ohm, the only noisy elements), 161 states nz_x*, controlled sources Gnz_*
.SUBCKT sparx_core_le p1 p2 p3 p4 p5 p6 p7
V1 p1 s1 0
R1 s1 0 50 noisy=0
Gd1_1 0 s1 p1 0 -0.002913191401
Fd1_1 0 s1 V1 -0.14565957
Gr1_re_1_1 0 s1 x1_re_a1 0 -681684.6204
Gr1_im_1_1 0 s1 x1_im_a1 0 -193017.7012
Gr2_1_1 0 s1 x2_a1 0 1.690031537
Gr3_re_1_1 0 s1 x3_re_a1 0 218871.3477
Gr3_im_1_1 0 s1 x3_im_a1 0 28370.06673
Gr4_re_1_1 0 s1 x4_re_a1 0 -55709.83268
Gr4_im_1_1 0 s1 x4_im_a1 0 358585.0299
Gr5_re_1_1 0 s1 x5_re_a1 0 -386285.1597
Gr5_im_1_1 0 s1 x5_im_a1 0 530108.9632
Gr6_re_1_1 0 s1 x6_re_a1 0 -911288.5966
Gr6_im_1_1 0 s1 x6_im_a1 0 -1477332.821
Gr7_re_1_1 0 s1 x7_re_a1 0 175365.6199
Gr7_im_1_1 0 s1 x7_im_a1 0 193816.5488
Gr8_re_1_1 0 s1 x8_re_a1 0 -337453.7
Gr8_im_1_1 0 s1 x8_im_a1 0 639438.242
Gr9_re_1_1 0 s1 x9_re_a1 0 539783.5979
Gr9_im_1_1 0 s1 x9_im_a1 0 1987898.741
Gr10_re_1_1 0 s1 x10_re_a1 0 347917.4973
Gr10_im_1_1 0 s1 x10_im_a1 0 -109390.5837
Gr11_re_1_1 0 s1 x11_re_a1 0 175974.6261
Gr11_im_1_1 0 s1 x11_im_a1 0 -630844.6317
Gr12_re_1_1 0 s1 x12_re_a1 0 527543.177
Gr12_im_1_1 0 s1 x12_im_a1 0 -251256.5977
Gd1_2 0 s1 p2 0 -7.062813979e-06
Fd1_2 0 s1 V2 -0.000353140699
Gr1_re_1_2 0 s1 x1_re_a2 0 153.5139962
Gr1_im_1_2 0 s1 x1_im_a2 0 -2387.842054
Gr2_1_2 0 s1 x2_a2 0 0.009781703208
Gr3_re_1_2 0 s1 x3_re_a2 0 -662.4299963
Gr3_im_1_2 0 s1 x3_im_a2 0 -506.2243993
Gr4_re_1_2 0 s1 x4_re_a2 0 2248.0517
Gr4_im_1_2 0 s1 x4_im_a2 0 1017.356158
Gr5_re_1_2 0 s1 x5_re_a2 0 801.0884656
Gr5_im_1_2 0 s1 x5_im_a2 0 5732.588121
Gr6_re_1_2 0 s1 x6_re_a2 0 -8355.391369
Gr6_im_1_2 0 s1 x6_im_a2 0 -24696.76827
Gr7_re_1_2 0 s1 x7_re_a2 0 6592.169676
Gr7_im_1_2 0 s1 x7_im_a2 0 5902.328072
Gr8_re_1_2 0 s1 x8_re_a2 0 -31610.07219
Gr8_im_1_2 0 s1 x8_im_a2 0 -21750.81322
Gr9_re_1_2 0 s1 x9_re_a2 0 -2847.31381
Gr9_im_1_2 0 s1 x9_im_a2 0 28427.6135
Gr10_re_1_2 0 s1 x10_re_a2 0 -52962.5418
Gr10_im_1_2 0 s1 x10_im_a2 0 118526.4732
Gr11_re_1_2 0 s1 x11_re_a2 0 45975.31078
Gr11_im_1_2 0 s1 x11_im_a2 0 86832.38434
Gr12_re_1_2 0 s1 x12_re_a2 0 -29343.76811
Gr12_im_1_2 0 s1 x12_im_a2 0 -143933.4768
Gd1_3 0 s1 p3 0 3.833027889e-06
Fd1_3 0 s1 V3 0.0001916513944
Gr1_re_1_3 0 s1 x1_re_a3 0 -208.4166436
Gr1_im_1_3 0 s1 x1_im_a3 0 7898.047738
Gr2_1_3 0 s1 x2_a3 0 -0.02166394947
Gr3_re_1_3 0 s1 x3_re_a3 0 -51.35907877
Gr3_im_1_3 0 s1 x3_im_a3 0 107.8709508
Gr4_re_1_3 0 s1 x4_re_a3 0 -5383.467065
Gr4_im_1_3 0 s1 x4_im_a3 0 -230.1935049
Gr5_re_1_3 0 s1 x5_re_a3 0 -5186.660011
Gr5_im_1_3 0 s1 x5_im_a3 0 -19222.62348
Gr6_re_1_3 0 s1 x6_re_a3 0 18820.80565
Gr6_im_1_3 0 s1 x6_im_a3 0 58196.37115
Gr7_re_1_3 0 s1 x7_re_a3 0 -10312.31713
Gr7_im_1_3 0 s1 x7_im_a3 0 -9936.194598
Gr8_re_1_3 0 s1 x8_re_a3 0 43534.34041
Gr8_im_1_3 0 s1 x8_im_a3 0 -24389.35094
Gr9_re_1_3 0 s1 x9_re_a3 0 38633.43902
Gr9_im_1_3 0 s1 x9_im_a3 0 -69747.29033
Gr10_re_1_3 0 s1 x10_re_a3 0 39557.9348
Gr10_im_1_3 0 s1 x10_im_a3 0 -187956.6405
Gr11_re_1_3 0 s1 x11_re_a3 0 -289602.941
Gr11_im_1_3 0 s1 x11_im_a3 0 -128879.6007
Gr12_re_1_3 0 s1 x12_re_a3 0 47308.95956
Gr12_im_1_3 0 s1 x12_im_a3 0 267632.6762
Gd1_4 0 s1 p4 0 0.0001492883444
Fd1_4 0 s1 V4 0.00746441722
Gr1_re_1_4 0 s1 x1_re_a4 0 19615.79725
Gr1_im_1_4 0 s1 x1_im_a4 0 -5054.44834
Gr2_1_4 0 s1 x2_a4 0 -0.004339368746
Gr3_re_1_4 0 s1 x3_re_a4 0 -2155.796538
Gr3_im_1_4 0 s1 x3_im_a4 0 671.7361416
Gr4_re_1_4 0 s1 x4_re_a4 0 -1186.333142
Gr4_im_1_4 0 s1 x4_im_a4 0 6851.489524
Gr5_re_1_4 0 s1 x5_re_a4 0 -25478.95108
Gr5_im_1_4 0 s1 x5_im_a4 0 -44.9365859
Gr6_re_1_4 0 s1 x6_re_a4 0 76129.08525
Gr6_im_1_4 0 s1 x6_im_a4 0 -22964.1521
Gr7_re_1_4 0 s1 x7_re_a4 0 -18403.12207
Gr7_im_1_4 0 s1 x7_im_a4 0 8479.513736
Gr8_re_1_4 0 s1 x8_re_a4 0 -40186.43276
Gr8_im_1_4 0 s1 x8_im_a4 0 -60337.20999
Gr9_re_1_4 0 s1 x9_re_a4 0 -74319.41733
Gr9_im_1_4 0 s1 x9_im_a4 0 -37801.58976
Gr10_re_1_4 0 s1 x10_re_a4 0 -195079.6473
Gr10_im_1_4 0 s1 x10_im_a4 0 -112639.2078
Gr11_re_1_4 0 s1 x11_re_a4 0 -150964.2287
Gr11_im_1_4 0 s1 x11_im_a4 0 312536.5181
Gr12_re_1_4 0 s1 x12_re_a4 0 304293.1259
Gr12_im_1_4 0 s1 x12_im_a4 0 -15130.25124
Gd1_5 0 s1 p5 0 0.0001497233242
Fd1_5 0 s1 V5 0.007486166211
Gr1_re_1_5 0 s1 x1_re_a5 0 21215.29707
Gr1_im_1_5 0 s1 x1_im_a5 0 -4729.84722
Gr2_1_5 0 s1 x2_a5 0 -0.006867277331
Gr3_re_1_5 0 s1 x3_re_a5 0 -1974.170516
Gr3_im_1_5 0 s1 x3_im_a5 0 655.6750007
Gr4_re_1_5 0 s1 x4_re_a5 0 -400.3462151
Gr4_im_1_5 0 s1 x4_im_a5 0 6710.082283
Gr5_re_1_5 0 s1 x5_re_a5 0 -27381.16732
Gr5_im_1_5 0 s1 x5_im_a5 0 -1308.458274
Gr6_re_1_5 0 s1 x6_re_a5 0 78812.07427
Gr6_im_1_5 0 s1 x6_im_a5 0 -25286.50151
Gr7_re_1_5 0 s1 x7_re_a5 0 -18334.78009
Gr7_im_1_5 0 s1 x7_im_a5 0 8778.51112
Gr8_re_1_5 0 s1 x8_re_a5 0 -42715.25468
Gr8_im_1_5 0 s1 x8_im_a5 0 -55826.57438
Gr9_re_1_5 0 s1 x9_re_a5 0 -77320.61079
Gr9_im_1_5 0 s1 x9_im_a5 0 -37394.83587
Gr10_re_1_5 0 s1 x10_re_a5 0 -199180.0731
Gr10_im_1_5 0 s1 x10_im_a5 0 -101780.7228
Gr11_re_1_5 0 s1 x11_re_a5 0 -125342.92
Gr11_im_1_5 0 s1 x11_im_a5 0 308378.2354
Gr12_re_1_5 0 s1 x12_re_a5 0 296363.1423
Gr12_im_1_5 0 s1 x12_im_a5 0 -35649.46523
Gd1_6 0 s1 p6 0 -7.367340682e-07
Fd1_6 0 s1 V6 -3.683670341e-05
Gr1_re_1_6 0 s1 x1_re_a6 0 -1798.935043
Gr1_im_1_6 0 s1 x1_im_a6 0 10070.27135
Gr2_1_6 0 s1 x2_a6 0 -0.0179863749
Gr3_re_1_6 0 s1 x3_re_a6 0 -237.1789856
Gr3_im_1_6 0 s1 x3_im_a6 0 209.3938384
Gr4_re_1_6 0 s1 x4_re_a6 0 -3392.158225
Gr4_im_1_6 0 s1 x4_im_a6 0 61.96972119
Gr5_re_1_6 0 s1 x5_re_a6 0 -5613.515338
Gr5_im_1_6 0 s1 x5_im_a6 0 -15349.33328
Gr6_re_1_6 0 s1 x6_re_a6 0 21328.46312
Gr6_im_1_6 0 s1 x6_im_a6 0 53712.11006
Gr7_re_1_6 0 s1 x7_re_a6 0 -10893.59891
Gr7_im_1_6 0 s1 x7_im_a6 0 -10069.48324
Gr8_re_1_6 0 s1 x8_re_a6 0 40207.48895
Gr8_im_1_6 0 s1 x8_im_a6 0 -29713.83187
Gr9_re_1_6 0 s1 x9_re_a6 0 29277.98019
Gr9_im_1_6 0 s1 x9_im_a6 0 -62364.67679
Gr10_re_1_6 0 s1 x10_re_a6 0 36289.52742
Gr10_im_1_6 0 s1 x10_im_a6 0 -193598.7534
Gr11_re_1_6 0 s1 x11_re_a6 0 -305548.298
Gr11_im_1_6 0 s1 x11_im_a6 0 -107424.6447
Gr12_re_1_6 0 s1 x12_re_a6 0 72154.57607
Gr12_im_1_6 0 s1 x12_im_a6 0 269192.5979
Gd1_7 0 s1 p7 0 -1.02458219e-05
Fd1_7 0 s1 V7 -0.0005122910949
Gr1_re_1_7 0 s1 x1_re_a7 0 257.8672534
Gr1_im_1_7 0 s1 x1_im_a7 0 -1595.180455
Gr2_1_7 0 s1 x2_a7 0 0.007574674273
Gr3_re_1_7 0 s1 x3_re_a7 0 -518.1905582
Gr3_im_1_7 0 s1 x3_im_a7 0 -405.9163692
Gr4_re_1_7 0 s1 x4_re_a7 0 1884.392858
Gr4_im_1_7 0 s1 x4_im_a7 0 727.0694319
Gr5_re_1_7 0 s1 x5_re_a7 0 879.2900317
Gr5_im_1_7 0 s1 x5_im_a7 0 4269.066847
Gr6_re_1_7 0 s1 x6_re_a7 0 -4882.057638
Gr6_im_1_7 0 s1 x6_im_a7 0 -20288.56215
Gr7_re_1_7 0 s1 x7_re_a7 0 5409.393734
Gr7_im_1_7 0 s1 x7_im_a7 0 6333.844326
Gr8_re_1_7 0 s1 x8_re_a7 0 -33851.19912
Gr8_im_1_7 0 s1 x8_im_a7 0 -20481.01315
Gr9_re_1_7 0 s1 x9_re_a7 0 -3287.262785
Gr9_im_1_7 0 s1 x9_im_a7 0 27361.49561
Gr10_re_1_7 0 s1 x10_re_a7 0 -52451.46995
Gr10_im_1_7 0 s1 x10_im_a7 0 114875.7703
Gr11_re_1_7 0 s1 x11_re_a7 0 74058.52327
Gr11_im_1_7 0 s1 x11_im_a7 0 69655.87896
Gr12_re_1_7 0 s1 x12_re_a7 0 -41377.85679
Gr12_im_1_7 0 s1 x12_im_a7 0 -140541.9912
Cx1_re_a1 x1_re_a1 0 3.89287585e-12
Gx1_re_a1 0 x1_re_a1 p1 0 3.201417807e-08
Fx1_re_a1 0 x1_re_a1 V1 1.600708904e-06
Rp1_re_re_a1 0 x1_re_a1 1 noisy=0
Gp1_re_im_a1 0 x1_re_a1 x1_im_a1 0 6.237829681
Cx1_im_a1 x1_im_a1 0 3.89287585e-12
Gp1_im_re_a1 0 x1_im_a1 x1_re_a1 0 -6.237829681
Rp1_im_im_a1 0 x1_im_a1 1 noisy=0
Cx2_a1 x2_a1 0 1.818528442e-12
Gx2_a1 0 x2_a1 p1 0 0.03380063074
Fx2_a1 0 x2_a1 V1 1.690031537
Rp2_a1 0 x2_a1 1 noisy=0
Cx3_re_a1 x3_re_a1 0 1.3261597e-11
Gx3_re_a1 0 x3_re_a1 p1 0 8.300861844e-09
Fx3_re_a1 0 x3_re_a1 V1 4.150430922e-07
Rp3_re_re_a1 0 x3_re_a1 1 noisy=0
Gp3_re_im_a1 0 x3_re_a1 x3_im_a1 0 17.80378221
Cx3_im_a1 x3_im_a1 0 1.3261597e-11
Gp3_im_re_a1 0 x3_im_a1 x3_re_a1 0 -17.80378221
Rp3_im_im_a1 0 x3_im_a1 1 noisy=0
Cx4_re_a1 x4_re_a1 0 3.619491499e-12
Gx4_re_a1 0 x4_re_a1 p1 0 4.111660365e-08
Fx4_re_a1 0 x4_re_a1 V1 2.055830182e-06
Rp4_re_re_a1 0 x4_re_a1 1 noisy=0
Gp4_re_im_a1 0 x4_re_a1 x4_im_a1 0 1.759573164
Cx4_im_a1 x4_im_a1 0 3.619491499e-12
Gp4_im_re_a1 0 x4_im_a1 x4_re_a1 0 -1.759573164
Rp4_im_im_a1 0 x4_im_a1 1 noisy=0
Cx5_re_a1 x5_re_a1 0 2.551196837e-12
Gx5_re_a1 0 x5_re_a1 p1 0 8.757704428e-08
Fx5_re_a1 0 x5_re_a1 V1 4.378852214e-06
Rp5_re_re_a1 0 x5_re_a1 1 noisy=0
Gp5_re_im_a1 0 x5_re_a1 x5_im_a1 0 1.86425479
Cx5_im_a1 x5_im_a1 0 2.551196837e-12
Gp5_im_re_a1 0 x5_im_a1 x5_re_a1 0 -1.86425479
Rp5_im_im_a1 0 x5_im_a1 1 noisy=0
Cx6_re_a1 x6_re_a1 0 4.347339998e-12
Gx6_re_a1 0 x6_re_a1 p1 0 1.414420037e-07
Fx6_re_a1 0 x6_re_a1 V1 7.072100185e-06
Rp6_re_re_a1 0 x6_re_a1 1 noisy=0
Gp6_re_im_a1 0 x6_re_a1 x6_im_a1 0 5.043445659
Cx6_im_a1 x6_im_a1 0 4.347339998e-12
Gp6_im_re_a1 0 x6_im_a1 x6_re_a1 0 -5.043445659
Rp6_im_im_a1 0 x6_im_a1 1 noisy=0
Cx7_re_a1 x7_re_a1 0 8.303908788e-12
Gx7_re_a1 0 x7_re_a1 p1 0 2.994289639e-08
Fx7_re_a1 0 x7_re_a1 V1 1.49714482e-06
Rp7_re_re_a1 0 x7_re_a1 1 noisy=0
Gp7_re_im_a1 0 x7_re_a1 x7_im_a1 0 7.230551368
Cx7_im_a1 x7_im_a1 0 8.303908788e-12
Gp7_im_re_a1 0 x7_im_a1 x7_re_a1 0 -7.230551368
Rp7_im_im_a1 0 x7_im_a1 1 noisy=0
Cx8_re_a1 x8_re_a1 0 1.359672759e-11
Gx8_re_a1 0 x8_re_a1 p1 0 5.696166647e-08
Fx8_re_a1 0 x8_re_a1 V1 2.848083324e-06
Rp8_re_re_a1 0 x8_re_a1 1 noisy=0
Gp8_re_im_a1 0 x8_re_a1 x8_im_a1 0 15.68097665
Cx8_im_a1 x8_im_a1 0 1.359672759e-11
Gp8_im_re_a1 0 x8_im_a1 x8_re_a1 0 -15.68097665
Rp8_im_im_a1 0 x8_im_a1 1 noisy=0
Cx9_re_a1 x9_re_a1 0 6.291227666e-12
Gx9_re_a1 0 x9_re_a1 p1 0 1.335866024e-07
Fx9_re_a1 0 x9_re_a1 V1 6.679330118e-06
Rp9_re_re_a1 0 x9_re_a1 1 noisy=0
Gp9_re_im_a1 0 x9_re_a1 x9_im_a1 0 6.899132195
Cx9_im_a1 x9_im_a1 0 6.291227666e-12
Gp9_im_re_a1 0 x9_im_a1 x9_re_a1 0 -6.899132195
Rp9_im_im_a1 0 x9_im_a1 1 noisy=0
Cx10_re_a1 x10_re_a1 0 3.245362601e-11
Gx10_re_a1 0 x10_re_a1 p1 0 3.514804992e-08
Fx10_re_a1 0 x10_re_a1 V1 1.757402496e-06
Rp10_re_re_a1 0 x10_re_a1 1 noisy=0
Gp10_re_im_a1 0 x10_re_a1 x10_im_a1 0 30.09488123
Cx10_im_a1 x10_im_a1 0 3.245362601e-11
Gp10_im_re_a1 0 x10_im_a1 x10_re_a1 0 -30.09488123
Rp10_im_im_a1 0 x10_im_a1 1 noisy=0
Cx11_re_a1 x11_re_a1 0 2.341034518e-11
Gx11_re_a1 0 x11_re_a1 p1 0 4.688923216e-08
Fx11_re_a1 0 x11_re_a1 V1 2.344461608e-06
Rp11_re_re_a1 0 x11_re_a1 1 noisy=0
Gp11_re_im_a1 0 x11_re_a1 x11_im_a1 0 25.09850718
Cx11_im_a1 x11_im_a1 0 2.341034518e-11
Gp11_im_re_a1 0 x11_im_a1 x11_re_a1 0 -25.09850718
Rp11_im_im_a1 0 x11_im_a1 1 noisy=0
Cx12_re_a1 x12_re_a1 0 2.361018525e-11
Gx12_re_a1 0 x12_re_a1 p1 0 5.191775056e-08
Fx12_re_a1 0 x12_re_a1 V1 2.595887528e-06
Rp12_re_re_a1 0 x12_re_a1 1 noisy=0
Gp12_re_im_a1 0 x12_re_a1 x12_im_a1 0 23.41457436
Cx12_im_a1 x12_im_a1 0 2.361018525e-11
Gp12_im_re_a1 0 x12_im_a1 x12_re_a1 0 -23.41457436
Rp12_im_im_a1 0 x12_im_a1 1 noisy=0
V2 p2 s2 0
R2 s2 0 50 noisy=0
Gd2_1 0 s2 p1 0 -7.06281398e-06
Fd2_1 0 s2 V1 -0.000353140699
Gr1_re_2_1 0 s2 x1_re_a1 0 202.8643012
Gr1_im_2_1 0 s2 x1_im_a1 0 -3155.464136
Gr2_2_1 0 s2 x2_a1 0 0.007860097085
Gr3_re_2_1 0 s2 x3_re_a1 0 -1638.763281
Gr3_im_2_1 0 s2 x3_im_a1 0 -1252.33151
Gr4_re_2_1 0 s2 x4_re_a1 0 5172.836106
Gr4_im_2_1 0 s2 x4_im_a1 0 2340.967811
Gr5_re_2_1 0 s2 x5_re_a1 0 983.6502327
Gr5_im_2_1 0 s2 x5_im_a1 0 7038.999912
Gr6_re_2_1 0 s2 x6_re_a1 0 -3795.591313
Gr6_im_2_1 0 s2 x6_im_a1 0 -11218.96449
Gr7_re_2_1 0 s2 x7_re_a1 0 11449.25103
Gr7_im_2_1 0 s2 x7_im_a1 0 10251.13719
Gr8_re_2_1 0 s2 x8_re_a1 0 -13718.14592
Gr8_im_2_1 0 s2 x8_im_a1 0 -9439.422595
Gr9_re_2_1 0 s2 x9_re_a1 0 -1547.148423
Gr9_im_2_1 0 s2 x9_im_a1 0 15446.74747
Gr10_re_2_1 0 s2 x10_re_a1 0 -23705.54691
Gr10_im_2_1 0 s2 x10_im_a1 0 53051.35998
Gr11_re_2_1 0 s2 x11_re_a1 0 11859.05356
Gr11_im_2_1 0 s2 x11_im_a1 0 22397.88876
Gr12_re_2_1 0 s2 x12_re_a1 0 -8284.296469
Gr12_im_2_1 0 s2 x12_im_a1 0 -40635.12187
Gd2_2 0 s2 p2 0 0.003167193434
Fd2_2 0 s2 V2 0.1583596717
Gr1_re_2_2 0 s2 x1_re_a2 0 -197784.7356
Gr1_im_2_2 0 s2 x1_im_a2 0 -359918.2124
Gr2_2_2 0 s2 x2_a2 0 -1.358026478
Gr3_re_2_2 0 s2 x3_re_a2 0 9554.203691
Gr3_im_2_2 0 s2 x3_im_a2 0 12289.53207
Gr4_re_2_2 0 s2 x4_re_a2 0 -369259.9736
Gr4_im_2_2 0 s2 x4_im_a2 0 175069.4275
Gr5_re_2_2 0 s2 x5_re_a2 0 -21151.18698
Gr5_im_2_2 0 s2 x5_im_a2 0 -748419.9706
Gr6_re_2_2 0 s2 x6_re_a2 0 283596.3859
Gr6_im_2_2 0 s2 x6_im_a2 0 391002.0225
Gr7_re_2_2 0 s2 x7_re_a2 0 15627.03452
Gr7_im_2_2 0 s2 x7_im_a2 0 229006.7955
Gr8_re_2_2 0 s2 x8_re_a2 0 148883.3358
Gr8_im_2_2 0 s2 x8_im_a2 0 8479.895532
Gr9_re_2_2 0 s2 x9_re_a2 0 204589.1985
Gr9_im_2_2 0 s2 x9_im_a2 0 -562380.1185
Gr10_re_2_2 0 s2 x10_re_a2 0 17537.53217
Gr10_im_2_2 0 s2 x10_im_a2 0 -14817.33782
Gr11_re_2_2 0 s2 x11_re_a2 0 -85090.26403
Gr11_im_2_2 0 s2 x11_im_a2 0 69125.92557
Gr12_re_2_2 0 s2 x12_re_a2 0 2602.818625
Gr12_im_2_2 0 s2 x12_im_a2 0 -81915.20704
Gd2_3 0 s2 p3 0 -0.0002736417406
Fd2_3 0 s2 V3 -0.01368208703
Gr1_re_2_3 0 s2 x1_re_a3 0 -507296.5486
Gr1_im_2_3 0 s2 x1_im_a3 0 -399735.227
Gr2_2_3 0 s2 x2_a3 0 0.5194675733
Gr3_re_2_3 0 s2 x3_re_a3 0 -4433.762119
Gr3_im_2_3 0 s2 x3_im_a3 0 120260.2795
Gr4_re_2_3 0 s2 x4_re_a3 0 136894.5186
Gr4_im_2_3 0 s2 x4_im_a3 0 -220757.9638
Gr5_re_2_3 0 s2 x5_re_a3 0 -74474.77047
Gr5_im_2_3 0 s2 x5_im_a3 0 558890.8353
Gr6_re_2_3 0 s2 x6_re_a3 0 -320763.1559
Gr6_im_2_3 0 s2 x6_im_a3 0 224305.0896
Gr7_re_2_3 0 s2 x7_re_a3 0 11400.36637
Gr7_im_2_3 0 s2 x7_im_a3 0 -208117.8045
Gr8_re_2_3 0 s2 x8_re_a3 0 45260.56718
Gr8_im_2_3 0 s2 x8_im_a3 0 42375.63922
Gr9_re_2_3 0 s2 x9_re_a3 0 346940.4073
Gr9_im_2_3 0 s2 x9_im_a3 0 103323.0892
Gr10_re_2_3 0 s2 x10_re_a3 0 16230.65756
Gr10_im_2_3 0 s2 x10_im_a3 0 28708.55487
Gr11_re_2_3 0 s2 x11_re_a3 0 38784.26732
Gr11_im_2_3 0 s2 x11_im_a3 0 -28080.30378
Gr12_re_2_3 0 s2 x12_re_a3 0 34072.69035
Gr12_im_2_3 0 s2 x12_im_a3 0 27887.01838
Gd2_4 0 s2 p4 0 -0.0007928046261
Fd2_4 0 s2 V4 -0.0396402313
Gr1_re_2_4 0 s2 x1_re_a4 0 452369.1204
Gr1_im_2_4 0 s2 x1_im_a4 0 348656.2035
Gr2_2_4 0 s2 x2_a4 0 0.1490806586
Gr3_re_2_4 0 s2 x3_re_a4 0 93714.86153
Gr3_im_2_4 0 s2 x3_im_a4 0 -93609.92997
Gr4_re_2_4 0 s2 x4_re_a4 0 12212.24548
Gr4_im_2_4 0 s2 x4_im_a4 0 -205926.6012
Gr5_re_2_4 0 s2 x5_re_a4 0 -66372.61702
Gr5_im_2_4 0 s2 x5_im_a4 0 288101.0005
Gr6_re_2_4 0 s2 x6_re_a4 0 281477.0661
Gr6_im_2_4 0 s2 x6_im_a4 0 -316833.7606
Gr7_re_2_4 0 s2 x7_re_a4 0 -207724.6848
Gr7_im_2_4 0 s2 x7_im_a4 0 -196329.458
Gr8_re_2_4 0 s2 x8_re_a4 0 64751.64913
Gr8_im_2_4 0 s2 x8_im_a4 0 -123355.3468
Gr9_re_2_4 0 s2 x9_re_a4 0 -406750.2674
Gr9_im_2_4 0 s2 x9_im_a4 0 83386.97476
Gr10_re_2_4 0 s2 x10_re_a4 0 47594.75156
Gr10_im_2_4 0 s2 x10_im_a4 0 -22448.66865
Gr11_re_2_4 0 s2 x11_re_a4 0 -1758.169889
Gr11_im_2_4 0 s2 x11_im_a4 0 -8360.422161
Gr12_re_2_4 0 s2 x12_re_a4 0 -120.0582146
Gr12_im_2_4 0 s2 x12_im_a4 0 -54080.99288
Gd2_5 0 s2 p5 0 0.0008053404884
Fd2_5 0 s2 V5 0.04026702442
Gr1_re_2_5 0 s2 x1_re_a5 0 -179078.1996
Gr1_im_2_5 0 s2 x1_im_a5 0 -365465.2218
Gr2_2_5 0 s2 x2_a5 0 0.2161899621
Gr3_re_2_5 0 s2 x3_re_a5 0 86241.66393
Gr3_im_2_5 0 s2 x3_im_a5 0 -89399.48158
Gr4_re_2_5 0 s2 x4_re_a5 0 -96486.20229
Gr4_im_2_5 0 s2 x4_im_a5 0 -119863.317
Gr5_re_2_5 0 s2 x5_re_a5 0 -93635.48365
Gr5_im_2_5 0 s2 x5_im_a5 0 180077.6466
Gr6_re_2_5 0 s2 x6_re_a5 0 41059.48312
Gr6_im_2_5 0 s2 x6_im_a5 0 92683.34574
Gr7_re_2_5 0 s2 x7_re_a5 0 -186199.9885
Gr7_im_2_5 0 s2 x7_im_a5 0 -263494.4514
Gr8_re_2_5 0 s2 x8_re_a5 0 48299.55913
Gr8_im_2_5 0 s2 x8_im_a5 0 -66179.48314
Gr9_re_2_5 0 s2 x9_re_a5 0 107034.6795
Gr9_im_2_5 0 s2 x9_im_a5 0 -37550.19684
Gr10_re_2_5 0 s2 x10_re_a5 0 43051.40434
Gr10_im_2_5 0 s2 x10_im_a5 0 -35889.24029
Gr11_re_2_5 0 s2 x11_re_a5 0 -20785.31968
Gr11_im_2_5 0 s2 x11_im_a5 0 -27907.85394
Gr12_re_2_5 0 s2 x12_re_a5 0 -3035.172704
Gr12_im_2_5 0 s2 x12_im_a5 0 -41394.81173
Gd2_6 0 s2 p6 0 -1.366513674e-05
Fd2_6 0 s2 V6 -0.0006832568369
Gr1_re_2_6 0 s2 x1_re_a6 0 206136.9726
Gr1_im_2_6 0 s2 x1_im_a6 0 334494.4445
Gr2_2_6 0 s2 x2_a6 0 0.4982380937
Gr3_re_2_6 0 s2 x3_re_a6 0 3336.762689
Gr3_im_2_6 0 s2 x3_im_a6 0 80947.71566
Gr4_re_2_6 0 s2 x4_re_a6 0 21453.48586
Gr4_im_2_6 0 s2 x4_im_a6 0 -92494.48964
Gr5_re_2_6 0 s2 x5_re_a6 0 -375051.9104
Gr5_im_2_6 0 s2 x5_im_a6 0 396326.8493
Gr6_re_2_6 0 s2 x6_re_a6 0 312883.5603
Gr6_im_2_6 0 s2 x6_im_a6 0 -504222.8775
Gr7_re_2_6 0 s2 x7_re_a6 0 48223.82365
Gr7_im_2_6 0 s2 x7_im_a6 0 -198532.1744
Gr8_re_2_6 0 s2 x8_re_a6 0 60658.46683
Gr8_im_2_6 0 s2 x8_im_a6 0 20564.78718
Gr9_re_2_6 0 s2 x9_re_a6 0 -146390.2211
Gr9_im_2_6 0 s2 x9_im_a6 0 -180455.9644
Gr10_re_2_6 0 s2 x10_re_a6 0 38690.24651
Gr10_im_2_6 0 s2 x10_im_a6 0 22236.24355
Gr11_re_2_6 0 s2 x11_re_a6 0 21115.12152
Gr11_im_2_6 0 s2 x11_im_a6 0 -3250.928356
Gr12_re_2_6 0 s2 x12_re_a6 0 32028.25687
Gr12_im_2_6 0 s2 x12_im_a6 0 -19561.60099
Gd2_7 0 s2 p7 0 0.003379576858
Fd2_7 0 s2 V7 0.1689788429
Gr1_re_2_7 0 s2 x1_re_a7 0 296214.9072
Gr1_im_2_7 0 s2 x1_im_a7 0 107226.9583
Gr2_2_7 0 s2 x2_a7 0 -1.215652375
Gr3_re_2_7 0 s2 x3_re_a7 0 27001.11972
Gr3_im_2_7 0 s2 x3_im_a7 0 -89059.20117
Gr4_re_2_7 0 s2 x4_re_a7 0 -424787.0996
Gr4_im_2_7 0 s2 x4_im_a7 0 102164.9422
Gr5_re_2_7 0 s2 x5_re_a7 0 18093.93339
Gr5_im_2_7 0 s2 x5_im_a7 0 -926846.0758
Gr6_re_2_7 0 s2 x6_re_a7 0 452050.5966
Gr6_im_2_7 0 s2 x6_im_a7 0 -313014.6308
Gr7_re_2_7 0 s2 x7_re_a7 0 -59831.33155
Gr7_im_2_7 0 s2 x7_im_a7 0 77720.53999
Gr8_re_2_7 0 s2 x8_re_a7 0 -32489.59706
Gr8_im_2_7 0 s2 x8_im_a7 0 -89220.56843
Gr9_re_2_7 0 s2 x9_re_a7 0 88828.93275
Gr9_im_2_7 0 s2 x9_im_a7 0 66986.20711
Gr10_re_2_7 0 s2 x10_re_a7 0 -26308.91928
Gr10_im_2_7 0 s2 x10_im_a7 0 -38946.4172
Gr11_re_2_7 0 s2 x11_re_a7 0 39184.47026
Gr11_im_2_7 0 s2 x11_im_a7 0 -13720.46867
Gr12_re_2_7 0 s2 x12_re_a7 0 -52234.5973
Gr12_im_2_7 0 s2 x12_im_a7 0 30656.12028
Cx1_re_a2 x1_re_a2 0 3.89287585e-12
Gx1_re_a2 0 x1_re_a2 p2 0 4.230580937e-08
Fx1_re_a2 0 x1_re_a2 V2 2.115290469e-06
Rp1_re_re_a2 0 x1_re_a2 1 noisy=0
Gp1_re_im_a2 0 x1_re_a2 x1_im_a2 0 6.237829681
Cx1_im_a2 x1_im_a2 0 3.89287585e-12
Gp1_im_re_a2 0 x1_im_a2 x1_re_a2 0 -6.237829681
Rp1_im_im_a2 0 x1_im_a2 1 noisy=0
Cx2_a2 x2_a2 0 1.818528442e-12
Gx2_a2 0 x2_a2 p2 0 0.02716052956
Fx2_a2 0 x2_a2 V2 1.358026478
Rp2_a2 0 x2_a2 1 noisy=0
Cx3_re_a2 x3_re_a2 0 1.3261597e-11
Gx3_re_a2 0 x3_re_a2 p2 0 2.053522284e-08
Fx3_re_a2 0 x3_re_a2 V2 1.026761142e-06
Rp3_re_re_a2 0 x3_re_a2 1 noisy=0
Gp3_re_im_a2 0 x3_re_a2 x3_im_a2 0 17.80378221
Cx3_im_a2 x3_im_a2 0 1.3261597e-11
Gp3_im_re_a2 0 x3_im_a2 x3_re_a2 0 -17.80378221
Rp3_im_im_a2 0 x3_im_a2 1 noisy=0
Cx4_re_a2 x4_re_a2 0 3.619491499e-12
Gx4_re_a2 0 x4_re_a2 p2 0 9.461056963e-08
Fx4_re_a2 0 x4_re_a2 V2 4.730528482e-06
Rp4_re_re_a2 0 x4_re_a2 1 noisy=0
Gp4_re_im_a2 0 x4_re_a2 x4_im_a2 0 1.759573164
Cx4_im_a2 x4_im_a2 0 3.619491499e-12
Gp4_im_re_a2 0 x4_im_a2 x4_re_a2 0 -1.759573164
Rp4_im_im_a2 0 x4_im_a2 1 noisy=0
Cx5_re_a2 x5_re_a2 0 2.551196837e-12
Gx5_re_a2 0 x5_re_a2 p2 0 1.075351646e-07
Fx5_re_a2 0 x5_re_a2 V2 5.376758228e-06
Rp5_re_re_a2 0 x5_re_a2 1 noisy=0
Gp5_re_im_a2 0 x5_re_a2 x5_im_a2 0 1.86425479
Cx5_im_a2 x5_im_a2 0 2.551196837e-12
Gp5_im_re_a2 0 x5_im_a2 x5_re_a2 0 -1.86425479
Rp5_im_im_a2 0 x5_im_a2 1 noisy=0
Cx6_re_a2 x6_re_a2 0 4.347339998e-12
Gx6_re_a2 0 x6_re_a2 p2 0 6.425265039e-08
Fx6_re_a2 0 x6_re_a2 V2 3.21263252e-06
Rp6_re_re_a2 0 x6_re_a2 1 noisy=0
Gp6_re_im_a2 0 x6_re_a2 x6_im_a2 0 5.043445659
Cx6_im_a2 x6_im_a2 0 4.347339998e-12
Gp6_im_re_a2 0 x6_im_a2 x6_re_a2 0 -5.043445659
Rp6_im_im_a2 0 x6_im_a2 1 noisy=0
Cx7_re_a2 x7_re_a2 0 8.303908788e-12
Gx7_re_a2 0 x7_re_a2 p2 0 5.200468952e-08
Fx7_re_a2 0 x7_re_a2 V2 2.600234476e-06
Rp7_re_re_a2 0 x7_re_a2 1 noisy=0
Gp7_re_im_a2 0 x7_re_a2 x7_im_a2 0 7.230551368
Cx7_im_a2 x7_im_a2 0 8.303908788e-12
Gp7_im_re_a2 0 x7_im_a2 x7_re_a2 0 -7.230551368
Rp7_im_im_a2 0 x7_im_a2 1 noisy=0
Cx8_re_a2 x8_re_a2 0 1.359672759e-11
Gx8_re_a2 0 x8_re_a2 p2 0 2.472023626e-08
Fx8_re_a2 0 x8_re_a2 V2 1.236011813e-06
Rp8_re_re_a2 0 x8_re_a2 1 noisy=0
Gp8_re_im_a2 0 x8_re_a2 x8_im_a2 0 15.68097665
Cx8_im_a2 x8_im_a2 0 1.359672759e-11
Gp8_im_re_a2 0 x8_im_a2 x8_re_a2 0 -15.68097665
Rp8_im_im_a2 0 x8_im_a2 1 noisy=0
Cx9_re_a2 x9_re_a2 0 6.291227666e-12
Gx9_re_a2 0 x9_re_a2 p2 0 7.258711717e-08
Fx9_re_a2 0 x9_re_a2 V2 3.629355859e-06
Rp9_re_re_a2 0 x9_re_a2 1 noisy=0
Gp9_re_im_a2 0 x9_re_a2 x9_im_a2 0 6.899132195
Cx9_im_a2 x9_im_a2 0 6.291227666e-12
Gp9_im_re_a2 0 x9_im_a2 x9_re_a2 0 -6.899132195
Rp9_im_im_a2 0 x9_im_a2 1 noisy=0
Cx10_re_a2 x10_re_a2 0 3.245362601e-11
Gx10_re_a2 0 x10_re_a2 p2 0 1.573194408e-08
Fx10_re_a2 0 x10_re_a2 V2 7.86597204e-07
Rp10_re_re_a2 0 x10_re_a2 1 noisy=0
Gp10_re_im_a2 0 x10_re_a2 x10_im_a2 0 30.09488123
Cx10_im_a2 x10_im_a2 0 3.245362601e-11
Gp10_im_re_a2 0 x10_im_a2 x10_re_a2 0 -30.09488123
Rp10_im_im_a2 0 x10_im_a2 1 noisy=0
Cx11_re_a2 x11_re_a2 0 2.341034518e-11
Gx11_re_a2 0 x11_re_a2 p2 0 1.209479406e-08
Fx11_re_a2 0 x11_re_a2 V2 6.047397028e-07
Rp11_re_re_a2 0 x11_re_a2 1 noisy=0
Gp11_re_im_a2 0 x11_re_a2 x11_im_a2 0 25.09850718
Cx11_im_a2 x11_im_a2 0 2.341034518e-11
Gp11_im_re_a2 0 x11_im_a2 x11_re_a2 0 -25.09850718
Rp11_im_im_a2 0 x11_im_a2 1 noisy=0
Cx12_re_a2 x12_re_a2 0 2.361018525e-11
Gx12_re_a2 0 x12_re_a2 p2 0 1.465735539e-08
Fx12_re_a2 0 x12_re_a2 V2 7.328677695e-07
Rp12_re_re_a2 0 x12_re_a2 1 noisy=0
Gp12_re_im_a2 0 x12_re_a2 x12_im_a2 0 23.41457436
Cx12_im_a2 x12_im_a2 0 2.361018525e-11
Gp12_im_re_a2 0 x12_im_a2 x12_re_a2 0 -23.41457436
Rp12_im_im_a2 0 x12_im_a2 1 noisy=0
V3 p3 s3 0
R3 s3 0 50 noisy=0
Gd3_1 0 s3 p1 0 3.833027888e-06
Fd3_1 0 s3 V1 0.0001916513944
Gr1_re_3_1 0 s3 x1_re_a1 0 -293.1708958
Gr1_im_3_1 0 s3 x1_im_a1 0 11109.85039
Gr2_3_1 0 s3 x2_a1 0 -0.01837457509
Gr3_re_3_1 0 s3 x3_re_a1 0 -211.3465373
Gr3_im_3_1 0 s3 x3_im_a1 0 443.8972131
Gr4_re_3_1 0 s3 x4_re_a1 0 -15238.1987
Gr4_im_3_1 0 s3 x4_im_a1 0 -651.5753369
Gr5_re_3_1 0 s3 x5_re_a1 0 -5656.432586
Gr5_im_3_1 0 s3 x5_im_a1 0 -20963.67867
Gr6_re_3_1 0 s3 x6_re_a1 0 10591.40246
Gr6_im_3_1 0 s3 x6_im_a1 0 32749.98956
Gr7_re_3_1 0 s3 x7_re_a1 0 -24051.54293
Gr7_im_3_1 0 s3 x7_im_a1 0 -23174.30777
Gr8_re_3_1 0 s3 x8_re_a1 0 37534.12214
Gr8_im_3_1 0 s3 x8_im_a1 0 -21027.83385
Gr9_re_3_1 0 s3 x9_re_a1 0 22605.16978
Gr9_im_3_1 0 s3 x9_im_a1 0 -40810.48386
Gr10_re_3_1 0 s3 x10_re_a1 0 29460.47139
Gr10_im_3_1 0 s3 x10_im_a1 0 -139979.28
Gr11_re_3_1 0 s3 x11_re_a1 0 -186482.5135
Gr11_im_3_1 0 s3 x11_im_a1 0 -82988.77003
Gr12_re_3_1 0 s3 x12_re_a1 0 28579.55519
Gr12_im_3_1 0 s3 x12_im_a1 0 161678.103
Gd3_2 0 s3 p2 0 -0.0002736417406
Fd3_2 0 s3 V2 -0.01368208703
Gr1_re_3_2 0 s3 x1_re_a2 0 -539998.6969
Gr1_im_3_2 0 s3 x1_im_a2 0 -425503.5881
Gr2_3_2 0 s3 x2_a2 0 0.5483081292
Gr3_re_3_2 0 s3 x3_re_a2 0 -7375.204485
Gr3_im_3_2 0 s3 x3_im_a2 0 200043.243
Gr4_re_3_2 0 s3 x4_re_a2 0 168397.3323
Gr4_im_3_2 0 s3 x4_im_a2 0 -271559.8298
Gr5_re_3_2 0 s3 x5_re_a2 0 -66146.03066
Gr5_im_3_2 0 s3 x5_im_a2 0 496388.3755
Gr6_re_3_2 0 s3 x6_re_a2 0 -397362.6945
Gr6_im_3_2 0 s3 x6_im_a2 0 277870.052
Gr7_re_3_2 0 s3 x7_re_a2 0 15309.35135
Gr7_im_3_2 0 s3 x7_im_a2 0 -279477.7367
Gr8_re_3_2 0 s3 x8_re_a2 0 89917.5273
Gr8_im_3_2 0 s3 x8_im_a2 0 84186.14555
Gr9_re_3_2 0 s3 x9_re_a2 0 373596.3663
Gr9_im_3_2 0 s3 x9_im_a2 0 111261.5592
Gr10_re_3_2 0 s3 x10_re_a2 0 27006.04809
Gr10_im_3_2 0 s3 x10_im_a2 0 47767.91147
Gr11_re_3_2 0 s3 x11_re_a2 0 96820.06745
Gr11_im_3_2 0 s3 x11_im_a2 0 -70098.96263
Gr12_re_3_2 0 s3 x12_re_a2 0 72908.5975
Gr12_im_3_2 0 s3 x12_im_a2 0 59672.523
Gd3_3 0 s3 p3 0 0.001722142148
Fd3_3 0 s3 V3 0.08610710742
Gr1_re_3_3 0 s3 x1_re_a3 0 192628.1206
Gr1_im_3_3 0 s3 x1_im_a3 0 -232485.5992
Gr2_3_3 0 s3 x2_a3 0 -1.433423366
Gr3_re_3_3 0 s3 x3_re_a3 0 22065.6561
Gr3_im_3_3 0 s3 x3_im_a3 0 -226037.0567
Gr4_re_3_3 0 s3 x4_re_a3 0 91177.27024
Gr4_im_3_3 0 s3 x4_im_a3 0 -183535.6869
Gr5_re_3_3 0 s3 x5_re_a3 0 -73178.01696
Gr5_im_3_3 0 s3 x5_im_a3 0 -127351.7659
Gr6_re_3_3 0 s3 x6_re_a3 0 389333.1013
Gr6_im_3_3 0 s3 x6_im_a3 0 -615469.9779
Gr7_re_3_3 0 s3 x7_re_a3 0 -163497.2136
Gr7_im_3_3 0 s3 x7_im_a3 0 392929.7806
Gr8_re_3_3 0 s3 x8_re_a3 0 -194128.0854
Gr8_im_3_3 0 s3 x8_im_a3 0 -8329.825737
Gr9_re_3_3 0 s3 x9_re_a3 0 -493860.8077
Gr9_im_3_3 0 s3 x9_im_a3 0 -21895.1951
Gr10_re_3_3 0 s3 x10_re_a3 0 -156742.1411
Gr10_im_3_3 0 s3 x10_im_a3 0 -8559.583503
Gr11_re_3_3 0 s3 x11_re_a3 0 65033.06413
Gr11_im_3_3 0 s3 x11_im_a3 0 139185.1512
Gr12_re_3_3 0 s3 x12_re_a3 0 -161740.834
Gr12_im_3_3 0 s3 x12_im_a3 0 130131.3604
Gd3_4 0 s3 p4 0 0.002738539257
Fd3_4 0 s3 V4 0.1369269629
Gr1_re_3_4 0 s3 x1_re_a4 0 -346044.0758
Gr1_im_3_4 0 s3 x1_im_a4 0 -77741.89914
Gr2_3_4 0 s3 x2_a4 0 -1.13708125
Gr3_re_3_4 0 s3 x3_re_a4 0 -177025.0908
Gr3_im_3_4 0 s3 x3_im_a4 0 294872.8165
Gr4_re_3_4 0 s3 x4_re_a4 0 21479.97393
Gr4_im_3_4 0 s3 x4_im_a4 0 -262969.3473
Gr5_re_3_4 0 s3 x5_re_a4 0 16027.52384
Gr5_im_3_4 0 s3 x5_im_a4 0 -512270.3219
Gr6_re_3_4 0 s3 x6_re_a4 0 320073.4558
Gr6_im_3_4 0 s3 x6_im_a4 0 -157784.3859
Gr7_re_3_4 0 s3 x7_re_a4 0 216163.693
Gr7_im_3_4 0 s3 x7_im_a4 0 278174.5627
Gr8_re_3_4 0 s3 x8_re_a4 0 222736.8474
Gr8_im_3_4 0 s3 x8_im_a4 0 181331.0512
Gr9_re_3_4 0 s3 x9_re_a4 0 -188178.9683
Gr9_im_3_4 0 s3 x9_im_a4 0 30060.38688
Gr10_re_3_4 0 s3 x10_re_a4 0 -135494.0095
Gr10_im_3_4 0 s3 x10_im_a4 0 94066.83907
Gr11_re_3_4 0 s3 x11_re_a4 0 238647.9039
Gr11_im_3_4 0 s3 x11_im_a4 0 54689.02151
Gr12_re_3_4 0 s3 x12_re_a4 0 -23449.20163
Gr12_im_3_4 0 s3 x12_im_a4 0 240282.1562
Gd3_5 0 s3 p5 0 -0.000664518971
Fd3_5 0 s3 V5 -0.03322594855
Gr1_re_3_5 0 s3 x1_re_a5 0 -553215.1757
Gr1_im_3_5 0 s3 x1_im_a5 0 -21590.92122
Gr2_3_5 0 s3 x2_a5 0 0.5375774716
Gr3_re_3_5 0 s3 x3_re_a5 0 -228829.2026
Gr3_im_3_5 0 s3 x3_im_a5 0 277160.4852
Gr4_re_3_5 0 s3 x4_re_a5 0 -336143.8364
Gr4_im_3_5 0 s3 x4_im_a5 0 338687.4815
Gr5_re_3_5 0 s3 x5_re_a5 0 109755.5709
Gr5_im_3_5 0 s3 x5_im_a5 0 -545843.2056
Gr6_re_3_5 0 s3 x6_re_a5 0 -132834.36
Gr6_im_3_5 0 s3 x6_im_a5 0 892539.8415
Gr7_re_3_5 0 s3 x7_re_a5 0 449868.2913
Gr7_im_3_5 0 s3 x7_im_a5 0 196116.2898
Gr8_re_3_5 0 s3 x8_re_a5 0 332589.9767
Gr8_im_3_5 0 s3 x8_im_a5 0 396344.2962
Gr9_re_3_5 0 s3 x9_re_a5 0 257091.289
Gr9_im_3_5 0 s3 x9_im_a5 0 -591558.0657
Gr10_re_3_5 0 s3 x10_re_a5 0 -17307.43147
Gr10_im_3_5 0 s3 x10_im_a5 0 49133.40426
Gr11_re_3_5 0 s3 x11_re_a5 0 52654.89998
Gr11_im_3_5 0 s3 x11_im_a5 0 115754.0652
Gr12_re_3_5 0 s3 x12_re_a5 0 5995.277323
Gr12_im_3_5 0 s3 x12_im_a5 0 39447.10232
Gd3_6 0 s3 p6 0 -0.0001345027134
Fd3_6 0 s3 V6 -0.006725135668
Gr1_re_3_6 0 s3 x1_re_a6 0 691161.6441
Gr1_im_3_6 0 s3 x1_im_a6 0 219844.3338
Gr2_3_6 0 s3 x2_a6 0 0.06912252645
Gr3_re_3_6 0 s3 x3_re_a6 0 -78046.24809
Gr3_im_3_6 0 s3 x3_im_a6 0 -319522.8531
Gr4_re_3_6 0 s3 x4_re_a6 0 -433297.4176
Gr4_im_3_6 0 s3 x4_im_a6 0 369386.5281
Gr5_re_3_6 0 s3 x5_re_a6 0 -74104.65218
Gr5_im_3_6 0 s3 x5_im_a6 0 -741733.1154
Gr6_re_3_6 0 s3 x6_re_a6 0 97624.38916
Gr6_im_3_6 0 s3 x6_im_a6 0 152012.3075
Gr7_re_3_6 0 s3 x7_re_a6 0 -15829.00957
Gr7_im_3_6 0 s3 x7_im_a6 0 176013.1979
Gr8_re_3_6 0 s3 x8_re_a6 0 -162785.1787
Gr8_im_3_6 0 s3 x8_im_a6 0 263122.5479
Gr9_re_3_6 0 s3 x9_re_a6 0 301398.5194
Gr9_im_3_6 0 s3 x9_im_a6 0 -555552.3115
Gr10_re_3_6 0 s3 x10_re_a6 0 -72553.7626
Gr10_im_3_6 0 s3 x10_im_a6 0 -76072.63926
Gr11_re_3_6 0 s3 x11_re_a6 0 -108967.6999
Gr11_im_3_6 0 s3 x11_im_a6 0 177707.0883
Gr12_re_3_6 0 s3 x12_re_a6 0 -152891.5667
Gr12_im_3_6 0 s3 x12_im_a6 0 -19104.95746
Gd3_7 0 s3 p7 0 2.023576631e-05
Fd3_7 0 s3 V7 0.001011788315
Gr1_re_3_7 0 s3 x1_re_a7 0 243029.5751
Gr1_im_3_7 0 s3 x1_im_a7 0 263501.1486
Gr2_3_7 0 s3 x2_a7 0 0.4614024716
Gr3_re_3_7 0 s3 x3_re_a7 0 -22339.32865
Gr3_im_3_7 0 s3 x3_im_a7 0 134294.5036
Gr4_re_3_7 0 s3 x4_re_a7 0 28310.35074
Gr4_im_3_7 0 s3 x4_im_a7 0 -86642.54853
Gr5_re_3_7 0 s3 x5_re_a7 0 -291628.3807
Gr5_im_3_7 0 s3 x5_im_a7 0 316507.9678
Gr6_re_3_7 0 s3 x6_re_a7 0 278776.5358
Gr6_im_3_7 0 s3 x6_im_a7 0 -500497.9855
Gr7_re_3_7 0 s3 x7_re_a7 0 49434.39449
Gr7_im_3_7 0 s3 x7_im_a7 0 -217864.2907
Gr8_re_3_7 0 s3 x8_re_a7 0 105658.2153
Gr8_im_3_7 0 s3 x8_im_a7 0 33598.17736
Gr9_re_3_7 0 s3 x9_re_a7 0 -149244.4038
Gr9_im_3_7 0 s3 x9_im_a7 0 -266861.2173
Gr10_re_3_7 0 s3 x10_re_a7 0 49068.10895
Gr10_im_3_7 0 s3 x10_im_a7 0 47569.02238
Gr11_re_3_7 0 s3 x11_re_a7 0 54896.33775
Gr11_im_3_7 0 s3 x11_im_a7 0 -42806.35984
Gr12_re_3_7 0 s3 x12_re_a7 0 80607.83308
Gr12_im_3_7 0 s3 x12_im_a7 0 -12179.19236
Cx1_re_a3 x1_re_a3 0 3.89287585e-12
Gx1_re_a3 0 x1_re_a3 p3 0 4.503299303e-08
Fx1_re_a3 0 x1_re_a3 V3 2.251649651e-06
Rp1_re_re_a3 0 x1_re_a3 1 noisy=0
Gp1_re_im_a3 0 x1_re_a3 x1_im_a3 0 6.237829681
Cx1_im_a3 x1_im_a3 0 3.89287585e-12
Gp1_im_re_a3 0 x1_im_a3 x1_re_a3 0 -6.237829681
Rp1_im_im_a3 0 x1_im_a3 1 noisy=0
Cx2_a3 x2_a3 0 1.818528442e-12
Gx2_a3 0 x2_a3 p3 0 0.02866846733
Fx2_a3 0 x2_a3 V3 1.433423366
Rp2_a3 0 x2_a3 1 noisy=0
Cx3_re_a3 x3_re_a3 0 1.3261597e-11
Gx3_re_a3 0 x3_re_a3 p3 0 3.415868139e-08
Fx3_re_a3 0 x3_re_a3 V3 1.707934069e-06
Rp3_re_re_a3 0 x3_re_a3 1 noisy=0
Gp3_re_im_a3 0 x3_re_a3 x3_im_a3 0 17.80378221
Cx3_im_a3 x3_im_a3 0 1.3261597e-11
Gp3_im_re_a3 0 x3_im_a3 x3_re_a3 0 -17.80378221
Rp3_im_im_a3 0 x3_im_a3 1 noisy=0
Cx4_re_a3 x4_re_a3 0 3.619491499e-12
Gx4_re_a3 0 x4_re_a3 p3 0 1.163828011e-07
Fx4_re_a3 0 x4_re_a3 V3 5.819140054e-06
Rp4_re_re_a3 0 x4_re_a3 1 noisy=0
Gp4_re_im_a3 0 x4_re_a3 x4_im_a3 0 1.759573164
Cx4_im_a3 x4_im_a3 0 3.619491499e-12
Gp4_im_re_a3 0 x4_im_a3 x4_re_a3 0 -1.759573164
Rp4_im_im_a3 0 x4_im_a3 1 noisy=0
Cx5_re_a3 x5_re_a3 0 2.551196837e-12
Gx5_re_a3 0 x5_re_a3 p3 0 9.550918047e-08
Fx5_re_a3 0 x5_re_a3 V3 4.775459023e-06
Rp5_re_re_a3 0 x5_re_a3 1 noisy=0
Gp5_re_im_a3 0 x5_re_a3 x5_im_a3 0 1.86425479
Cx5_im_a3 x5_im_a3 0 2.551196837e-12
Gp5_im_re_a3 0 x5_im_a3 x5_re_a3 0 -1.86425479
Rp5_im_im_a3 0 x5_im_a3 1 noisy=0
Cx6_re_a3 x6_re_a3 0 4.347339998e-12
Gx6_re_a3 0 x6_re_a3 p3 0 7.959644309e-08
Fx6_re_a3 0 x6_re_a3 V3 3.979822155e-06
Rp6_re_re_a3 0 x6_re_a3 1 noisy=0
Gp6_re_im_a3 0 x6_re_a3 x6_im_a3 0 5.043445659
Cx6_im_a3 x6_im_a3 0 4.347339998e-12
Gp6_im_re_a3 0 x6_im_a3 x6_re_a3 0 -5.043445659
Rp6_im_im_a3 0 x6_im_a3 1 noisy=0
Cx7_re_a3 x7_re_a3 0 8.303908788e-12
Gx7_re_a3 0 x7_re_a3 p3 0 6.983618223e-08
Fx7_re_a3 0 x7_re_a3 V3 3.491809112e-06
Rp7_re_re_a3 0 x7_re_a3 1 noisy=0
Gp7_re_im_a3 0 x7_re_a3 x7_im_a3 0 7.230551368
Cx7_im_a3 x7_im_a3 0 8.303908788e-12
Gp7_im_re_a3 0 x7_im_a3 x7_re_a3 0 -7.230551368
Rp7_im_im_a3 0 x7_im_a3 1 noisy=0
Cx8_re_a3 x8_re_a3 0 1.359672759e-11
Gx8_re_a3 0 x8_re_a3 p3 0 4.911079682e-08
Fx8_re_a3 0 x8_re_a3 V3 2.455539841e-06
Rp8_re_re_a3 0 x8_re_a3 1 noisy=0
Gp8_re_im_a3 0 x8_re_a3 x8_im_a3 0 15.68097665
Cx8_im_a3 x8_im_a3 0 1.359672759e-11
Gp8_im_re_a3 0 x8_im_a3 x8_re_a3 0 -15.68097665
Rp8_im_im_a3 0 x8_im_a3 1 noisy=0
Cx9_re_a3 x9_re_a3 0 6.291227666e-12
Gx9_re_a3 0 x9_re_a3 p3 0 7.816409574e-08
Fx9_re_a3 0 x9_re_a3 V3 3.908204787e-06
Rp9_re_re_a3 0 x9_re_a3 1 noisy=0
Gp9_re_im_a3 0 x9_re_a3 x9_im_a3 0 6.899132195
Cx9_im_a3 x9_im_a3 0 6.291227666e-12
Gp9_im_re_a3 0 x9_im_a3 x9_re_a3 0 -6.899132195
Rp9_im_im_a3 0 x9_im_a3 1 noisy=0
Cx10_re_a3 x10_re_a3 0 3.245362601e-11
Gx10_re_a3 0 x10_re_a3 p3 0 2.617624313e-08
Fx10_re_a3 0 x10_re_a3 V3 1.308812156e-06
Rp10_re_re_a3 0 x10_re_a3 1 noisy=0
Gp10_re_im_a3 0 x10_re_a3 x10_im_a3 0 30.09488123
Cx10_im_a3 x10_im_a3 0 3.245362601e-11
Gp10_im_re_a3 0 x10_im_a3 x10_re_a3 0 -30.09488123
Rp10_im_im_a3 0 x10_im_a3 1 noisy=0
Cx11_re_a3 x11_re_a3 0 2.341034518e-11
Gx11_re_a3 0 x11_re_a3 p3 0 3.019313905e-08
Fx11_re_a3 0 x11_re_a3 V3 1.509656953e-06
Rp11_re_re_a3 0 x11_re_a3 1 noisy=0
Gp11_re_im_a3 0 x11_re_a3 x11_im_a3 0 25.09850718
Cx11_im_a3 x11_im_a3 0 2.341034518e-11
Gp11_im_re_a3 0 x11_im_a3 x11_re_a3 0 -25.09850718
Rp11_im_im_a3 0 x11_im_a3 1 noisy=0
Cx12_re_a3 x12_re_a3 0 2.361018525e-11
Gx12_re_a3 0 x12_re_a3 p3 0 3.136374655e-08
Fx12_re_a3 0 x12_re_a3 V3 1.568187328e-06
Rp12_re_re_a3 0 x12_re_a3 1 noisy=0
Gp12_re_im_a3 0 x12_re_a3 x12_im_a3 0 23.41457436
Cx12_im_a3 x12_im_a3 0 2.361018525e-11
Gp12_im_re_a3 0 x12_im_a3 x12_re_a3 0 -23.41457436
Rp12_im_im_a3 0 x12_im_a3 1 noisy=0
V4 p4 s4 0
R4 s4 0 50 noisy=0
Gd4_1 0 s4 p1 0 0.0001492883444
Fd4_1 0 s4 V1 0.00746441722
Gr1_re_4_1 0 s4 x1_re_a1 0 24019.68951
Gr1_im_4_1 0 s4 x1_im_a1 0 -6189.209556
Gr2_4_1 0 s4 x2_a1 0 -0.003663316884
Gr3_re_4_1 0 s4 x3_re_a1 0 -10810.68936
Gr3_im_4_1 0 s4 x3_im_a1 0 3368.560356
Gr4_re_4_1 0 s4 x4_re_a1 0 -2984.673987
Gr4_im_4_1 0 s4 x4_im_a1 0 17237.53795
Gr5_re_4_1 0 s4 x5_re_a1 0 -29020.10465
Gr5_im_4_1 0 s4 x5_im_a1 0 -51.18202835
Gr6_re_4_1 0 s4 x6_re_a1 0 52565.92164
Gr6_im_4_1 0 s4 x6_im_a1 0 -15856.38151
Gr7_re_4_1 0 s4 x7_re_a1 0 -42625.25675
Gr7_im_4_1 0 s4 x7_im_a1 0 19640.22457
Gr8_re_4_1 0 s4 x8_re_a1 0 -38592.06158
Gr8_im_4_1 0 s4 x8_im_a1 0 -57943.36954
Gr9_re_4_1 0 s4 x9_re_a1 0 -55930.45672
Gr9_im_4_1 0 s4 x9_im_a1 0 -28448.28789
Gr10_re_4_1 0 s4 x10_re_a1 0 -164707.0923
Gr10_im_4_1 0 s4 x10_im_a1 0 -95102.06037
Gr11_re_4_1 0 s4 x11_re_a1 0 -115985.8615
Gr11_im_4_1 0 s4 x11_im_a1 0 240121.8991
Gr12_re_4_1 0 s4 x12_re_a1 0 226001.4524
Gr12_im_4_1 0 s4 x12_im_a1 0 -11237.38417
Gd4_2 0 s4 p2 0 -0.0007928046261
Fd4_2 0 s4 V2 -0.0396402313
Gr1_re_4_2 0 s4 x1_re_a2 0 419176.3048
Gr1_im_4_2 0 s4 x1_im_a2 0 323073.3762
Gr2_4_2 0 s4 x2_a2 0 0.1566230962
Gr3_re_4_2 0 s4 x3_re_a2 0 189966.8632
Gr3_im_4_2 0 s4 x3_im_a2 0 -189754.1592
Gr4_re_4_2 0 s4 x4_re_a2 0 13352.52313
Gr4_im_4_2 0 s4 x4_im_a2 0 -225154.3101
Gr5_re_4_2 0 s4 x5_re_a2 0 -61566.73898
Gr5_im_4_2 0 s4 x5_im_a2 0 267240.3153
Gr6_re_4_2 0 s4 x6_re_a2 0 427842.6156
Gr6_im_4_2 0 s4 x6_im_a2 0 -481584.4742
Gr7_re_4_2 0 s4 x7_re_a2 0 -277022.414
Gr7_im_4_2 0 s4 x7_im_a2 0 -261825.6971
Gr8_re_4_2 0 s4 x8_re_a2 0 143284.5703
Gr8_im_4_2 0 s4 x8_im_a2 0 -272964.7523
Gr9_re_4_2 0 s4 x9_re_a2 0 -563348.6687
Gr9_im_4_2 0 s4 x9_im_a2 0 115490.8675
Gr10_re_4_2 0 s4 x10_re_a2 0 89779.71933
Gr10_im_4_2 0 s4 x10_im_a2 0 -42345.7441
Gr11_re_4_2 0 s4 x11_re_a2 0 -5236.80594
Gr11_im_4_2 0 s4 x11_im_a2 0 -24901.97833
Gr12_re_4_2 0 s4 x12_re_a2 0 -315.842974
Gr12_im_4_2 0 s4 x12_im_a2 0 -142273.493
Gd4_3 0 s4 p3 0 0.002738539257
Fd4_3 0 s4 V3 0.1369269629
Gr1_re_4_3 0 s4 x1_re_a3 0 -301234.2768
Gr1_im_4_3 0 s4 x1_im_a3 0 -67674.97669
Gr2_4_3 0 s4 x2_a3 0 -1.13177412
Gr3_re_4_3 0 s4 x3_re_a3 0 -215726.0204
Gr3_im_4_3 0 s4 x3_im_a3 0 359337.4191
Gr4_re_4_3 0 s4 x4_re_a3 0 19092.0435
Gr4_im_4_3 0 s4 x4_im_a3 0 -233735.0238
Gr5_re_4_3 0 s4 x5_re_a3 0 16738.98137
Gr5_im_4_3 0 s4 x5_im_a3 0 -535009.8656
Gr6_re_4_3 0 s4 x6_re_a3 0 392724.5674
Gr6_im_4_3 0 s4 x6_im_a3 0 -193598.6992
Gr7_re_4_3 0 s4 x7_re_a3 0 214670.1059
Gr7_im_4_3 0 s4 x7_im_a3 0 276252.5104
Gr8_re_4_3 0 s4 x8_re_a3 0 248094.0203
Gr8_im_4_3 0 s4 x8_im_a3 0 201974.4376
Gr9_re_4_3 0 s4 x9_re_a3 0 -242031.9774
Gr9_im_4_3 0 s4 x9_im_a3 0 38663.06071
Gr10_re_4_3 0 s4 x10_re_a3 0 -153608.183
Gr10_im_4_3 0 s4 x10_im_a3 0 106642.6204
Gr11_re_4_3 0 s4 x11_re_a3 0 284743.2765
Gr11_im_4_3 0 s4 x11_im_a3 0 65252.32746
Gr12_re_4_3 0 s4 x12_re_a3 0 -28829.36532
Gr12_im_4_3 0 s4 x12_im_a3 0 295412.2775
Gd4_4 0 s4 p4 0 0.003155030644
Fd4_4 0 s4 V4 0.1577515322
Gr1_re_4_4 0 s4 x1_re_a4 0 324600.1731
Gr1_im_4_4 0 s4 x1_im_a4 0 -89334.11424
Gr2_4_4 0 s4 x2_a4 0 -1.42673311
Gr3_re_4_4 0 s4 x3_re_a4 0 529548.5304
Gr3_im_4_4 0 s4 x3_im_a4 0 -121288.9662
Gr4_re_4_4 0 s4 x4_re_a4 0 46000.60485
Gr4_im_4_4 0 s4 x4_im_a4 0 -211395.0095
Gr5_re_4_4 0 s4 x5_re_a4 0 -387457.751
Gr5_im_4_4 0 s4 x5_im_a4 0 -108574.119
Gr6_re_4_4 0 s4 x6_re_a4 0 606759.9031
Gr6_im_4_4 0 s4 x6_im_a4 0 -1057851.613
Gr7_re_4_4 0 s4 x7_re_a4 0 492182.9619
Gr7_im_4_4 0 s4 x7_im_a4 0 10206.62871
Gr8_re_4_4 0 s4 x8_re_a4 0 352411.3059
Gr8_im_4_4 0 s4 x8_im_a4 0 -564676.8877
Gr9_re_4_4 0 s4 x9_re_a4 0 -979127.8772
Gr9_im_4_4 0 s4 x9_im_a4 0 562178.5898
Gr10_re_4_4 0 s4 x10_re_a4 0 19301.03919
Gr10_im_4_4 0 s4 x10_im_a4 0 194097.527
Gr11_re_4_4 0 s4 x11_re_a4 0 209759.1338
Gr11_im_4_4 0 s4 x11_im_a4 0 -251332.917
Gr12_re_4_4 0 s4 x12_re_a4 0 229538.6461
Gr12_im_4_4 0 s4 x12_im_a4 0 127906.5079
Gd4_5 0 s4 p5 0 0.001034899246
Fd4_5 0 s4 V5 0.05174496232
Gr1_re_4_5 0 s4 x1_re_a5 0 323726.8192
Gr1_im_4_5 0 s4 x1_im_a5 0 42448.70716
Gr2_4_5 0 s4 x2_a5 0 -0.0347437261
Gr3_re_4_5 0 s4 x3_re_a5 0 482694.6422
Gr3_im_4_5 0 s4 x3_im_a5 0 -181277.7965
Gr4_re_4_5 0 s4 x4_re_a5 0 -375662.9232
Gr4_im_4_5 0 s4 x4_im_a5 0 259279.7143
Gr5_re_4_5 0 s4 x5_re_a5 0 -165286.3619
Gr5_im_4_5 0 s4 x5_im_a5 0 -699227.6726
Gr6_re_4_5 0 s4 x6_re_a5 0 -41497.93259
Gr6_im_4_5 0 s4 x6_im_a5 0 -189692.1371
Gr7_re_4_5 0 s4 x7_re_a5 0 622371.0349
Gr7_im_4_5 0 s4 x7_im_a5 0 -244676.9627
Gr8_re_4_5 0 s4 x8_re_a5 0 281790.0237
Gr8_im_4_5 0 s4 x8_im_a5 0 -387860.9295
Gr9_re_4_5 0 s4 x9_re_a5 0 -12068.08021
Gr9_im_4_5 0 s4 x9_im_a5 0 634844.7379
Gr10_re_4_5 0 s4 x10_re_a5 0 69607.6319
Gr10_im_4_5 0 s4 x10_im_a5 0 129807.334
Gr11_re_4_5 0 s4 x11_re_a5 0 92892.91345
Gr11_im_4_5 0 s4 x11_im_a5 0 -259520.1857
Gr12_re_4_5 0 s4 x12_re_a5 0 217265.4462
Gr12_im_4_5 0 s4 x12_im_a5 0 47126.77544
Gd4_6 0 s4 p6 0 -0.000743905629
Fd4_6 0 s4 V6 -0.03719528145
Gr1_re_4_6 0 s4 x1_re_a6 0 -522725.3502
Gr1_im_4_6 0 s4 x1_im_a6 0 -11218.05097
Gr2_4_6 0 s4 x2_a6 0 0.5985480403
Gr3_re_4_6 0 s4 x3_re_a6 0 -251148.7208
Gr3_im_4_6 0 s4 x3_im_a6 0 362831.0514
Gr4_re_4_6 0 s4 x4_re_a6 0 -289744.4501
Gr4_im_4_6 0 s4 x4_im_a6 0 298248.5341
Gr5_re_4_6 0 s4 x5_re_a6 0 121309.2764
Gr5_im_4_6 0 s4 x5_im_a6 0 -483192.1117
Gr6_re_4_6 0 s4 x6_re_a6 0 -163030.6854
Gr6_im_4_6 0 s4 x6_im_a6 0 963121.4817
Gr7_re_4_6 0 s4 x7_re_a6 0 455743.4811
Gr7_im_4_6 0 s4 x7_im_a6 0 241754.9128
Gr8_re_4_6 0 s4 x8_re_a6 0 387137.7704
Gr8_im_4_6 0 s4 x8_im_a6 0 423355.2806
Gr9_re_4_6 0 s4 x9_re_a6 0 215223.5688
Gr9_im_4_6 0 s4 x9_im_a6 0 -619939.7655
Gr10_re_4_6 0 s4 x10_re_a6 0 -29420.31714
Gr10_im_4_6 0 s4 x10_im_a6 0 54308.74505
Gr11_re_4_6 0 s4 x11_re_a6 0 91679.76529
Gr11_im_4_6 0 s4 x11_im_a6 0 141475.6009
Gr12_re_4_6 0 s4 x12_re_a6 0 -2598.549252
Gr12_im_4_6 0 s4 x12_im_a6 0 66946.50015
Gd4_7 0 s4 p7 0 0.0006671250525
Fd4_7 0 s4 V7 0.03335625263
Gr1_re_4_7 0 s4 x1_re_a7 0 -185233.8889
Gr1_im_4_7 0 s4 x1_im_a7 0 -265502.5411
Gr2_4_7 0 s4 x2_a7 0 0.1760467052
Gr3_re_4_7 0 s4 x3_re_a7 0 178451.9653
Gr3_im_4_7 0 s4 x3_im_a7 0 -157132.2352
Gr4_re_4_7 0 s4 x4_re_a7 0 -89372.43725
Gr4_im_4_7 0 s4 x4_im_a7 0 -102407.1079
Gr5_re_4_7 0 s4 x5_re_a7 0 -82515.90159
Gr5_im_4_7 0 s4 x5_im_a7 0 109721.5279
Gr6_re_4_7 0 s4 x6_re_a7 0 52552.94731
Gr6_im_4_7 0 s4 x6_im_a7 0 134737.9153
Gr7_re_4_7 0 s4 x7_re_a7 0 -219050.649
Gr7_im_4_7 0 s4 x7_im_a7 0 -365568.3513
Gr8_re_4_7 0 s4 x8_re_a7 0 70531.09098
Gr8_im_4_7 0 s4 x8_im_a7 0 -163978.366
Gr9_re_4_7 0 s4 x9_re_a7 0 237676.8361
Gr9_im_4_7 0 s4 x9_im_a7 0 -51469.08283
Gr10_re_4_7 0 s4 x10_re_a7 0 69866.76959
Gr10_im_4_7 0 s4 x10_im_a7 0 -50546.72808
Gr11_re_4_7 0 s4 x11_re_a7 0 -59179.27797
Gr11_im_4_7 0 s4 x11_im_a7 0 -100240.1063
Gr12_re_4_7 0 s4 x12_re_a7 0 2974.614189
Gr12_im_4_7 0 s4 x12_im_a7 0 -82563.97669
Cx1_re_a4 x1_re_a4 0 3.89287585e-12
Gx1_re_a4 0 x1_re_a4 p4 0 3.920159897e-08
Fx1_re_a4 0 x1_re_a4 V4 1.960079949e-06
Rp1_re_re_a4 0 x1_re_a4 1 noisy=0
Gp1_re_im_a4 0 x1_re_a4 x1_im_a4 0 6.237829681
Cx1_im_a4 x1_im_a4 0 3.89287585e-12
Gp1_im_re_a4 0 x1_im_a4 x1_re_a4 0 -6.237829681
Rp1_im_im_a4 0 x1_im_a4 1 noisy=0
Cx2_a4 x2_a4 0 1.818528442e-12
Gx2_a4 0 x2_a4 p4 0 0.0285346622
Fx2_a4 0 x2_a4 V4 1.42673311
Rp2_a4 0 x2_a4 1 noisy=0
Cx3_re_a4 x3_re_a4 0 1.3261597e-11
Gx3_re_a4 0 x3_re_a4 p4 0 4.162639525e-08
Fx3_re_a4 0 x3_re_a4 V4 2.081319763e-06
Rp3_re_re_a4 0 x3_re_a4 1 noisy=0
Gp3_re_im_a4 0 x3_re_a4 x3_im_a4 0 17.80378221
Cx3_im_a4 x3_im_a4 0 1.3261597e-11
Gp3_im_re_a4 0 x3_im_a4 x3_re_a4 0 -17.80378221
Rp3_im_im_a4 0 x3_im_a4 1 noisy=0
Cx4_re_a4 x4_re_a4 0 3.619491499e-12
Gx4_re_a4 0 x4_re_a4 p4 0 1.034445157e-07
Fx4_re_a4 0 x4_re_a4 V4 5.172225786e-06
Rp4_re_re_a4 0 x4_re_a4 1 noisy=0
Gp4_re_im_a4 0 x4_re_a4 x4_im_a4 0 1.759573164
Cx4_im_a4 x4_im_a4 0 3.619491499e-12
Gp4_im_re_a4 0 x4_im_a4 x4_re_a4 0 -1.759573164
Rp4_im_im_a4 0 x4_im_a4 1 noisy=0
Cx5_re_a4 x5_re_a4 0 2.551196837e-12
Gx5_re_a4 0 x5_re_a4 p4 0 9.974880764e-08
Fx5_re_a4 0 x5_re_a4 V4 4.987440382e-06
Rp5_re_re_a4 0 x5_re_a4 1 noisy=0
Gp5_re_im_a4 0 x5_re_a4 x5_im_a4 0 1.86425479
Cx5_im_a4 x5_im_a4 0 2.551196837e-12
Gp5_im_re_a4 0 x5_im_a4 x5_re_a4 0 -1.86425479
Rp5_im_im_a4 0 x5_im_a4 1 noisy=0
Cx6_re_a4 x6_re_a4 0 4.347339998e-12
Gx6_re_a4 0 x6_re_a4 p4 0 9.766345227e-08
Fx6_re_a4 0 x6_re_a4 V4 4.883172613e-06
Rp6_re_re_a4 0 x6_re_a4 1 noisy=0
Gp6_re_im_a4 0 x6_re_a4 x6_im_a4 0 5.043445659
Cx6_im_a4 x6_im_a4 0 4.347339998e-12
Gp6_im_re_a4 0 x6_im_a4 x6_re_a4 0 -5.043445659
Rp6_im_im_a4 0 x6_im_a4 1 noisy=0
Cx7_re_a4 x7_re_a4 0 8.303908788e-12
Gx7_re_a4 0 x7_re_a4 p4 0 6.935364781e-08
Fx7_re_a4 0 x7_re_a4 V4 3.467682391e-06
Rp7_re_re_a4 0 x7_re_a4 1 noisy=0
Gp7_re_im_a4 0 x7_re_a4 x7_im_a4 0 7.230551368
Cx7_im_a4 x7_im_a4 0 8.303908788e-12
Gp7_im_re_a4 0 x7_im_a4 x7_re_a4 0 -7.230551368
Rp7_im_im_a4 0 x7_im_a4 1 noisy=0
Cx8_re_a4 x8_re_a4 0 1.359672759e-11
Gx8_re_a4 0 x8_re_a4 p4 0 5.470174856e-08
Fx8_re_a4 0 x8_re_a4 V4 2.735087428e-06
Rp8_re_re_a4 0 x8_re_a4 1 noisy=0
Gp8_re_im_a4 0 x8_re_a4 x8_im_a4 0 15.68097665
Cx8_im_a4 x8_im_a4 0 1.359672759e-11
Gp8_im_re_a4 0 x8_im_a4 x8_re_a4 0 -15.68097665
Rp8_im_im_a4 0 x8_im_a4 1 noisy=0
Cx9_re_a4 x9_re_a4 0 6.291227666e-12
Gx9_re_a4 0 x9_re_a4 p4 0 1.005330767e-07
Fx9_re_a4 0 x9_re_a4 V4 5.026653835e-06
Rp9_re_re_a4 0 x9_re_a4 1 noisy=0
Gp9_re_im_a4 0 x9_re_a4 x9_im_a4 0 6.899132195
Cx9_im_a4 x9_im_a4 0 6.291227666e-12
Gp9_im_re_a4 0 x9_im_a4 x9_re_a4 0 -6.899132195
Rp9_im_im_a4 0 x9_im_a4 1 noisy=0
Cx10_re_a4 x10_re_a4 0 3.245362601e-11
Gx10_re_a4 0 x10_re_a4 p4 0 2.967574108e-08
Fx10_re_a4 0 x10_re_a4 V4 1.483787054e-06
Rp10_re_re_a4 0 x10_re_a4 1 noisy=0
Gp10_re_im_a4 0 x10_re_a4 x10_im_a4 0 30.09488123
Cx10_im_a4 x10_im_a4 0 3.245362601e-11
Gp10_im_re_a4 0 x10_im_a4 x10_re_a4 0 -30.09488123
Rp10_im_im_a4 0 x10_im_a4 1 noisy=0
Cx11_re_a4 x11_re_a4 0 2.341034518e-11
Gx11_re_a4 0 x11_re_a4 p4 0 3.602501091e-08
Fx11_re_a4 0 x11_re_a4 V4 1.801250545e-06
Rp11_re_re_a4 0 x11_re_a4 1 noisy=0
Gp11_re_im_a4 0 x11_re_a4 x11_im_a4 0 25.09850718
Cx11_im_a4 x11_im_a4 0 2.341034518e-11
Gp11_im_re_a4 0 x11_im_a4 x11_re_a4 0 -25.09850718
Rp11_im_im_a4 0 x11_im_a4 1 noisy=0
Cx12_re_a4 x12_re_a4 0 2.361018525e-11
Gx12_re_a4 0 x12_re_a4 p4 0 3.855981629e-08
Fx12_re_a4 0 x12_re_a4 V4 1.927990814e-06
Rp12_re_re_a4 0 x12_re_a4 1 noisy=0
Gp12_re_im_a4 0 x12_re_a4 x12_im_a4 0 23.41457436
Cx12_im_a4 x12_im_a4 0 2.361018525e-11
Gp12_im_re_a4 0 x12_im_a4 x12_re_a4 0 -23.41457436
Rp12_im_im_a4 0 x12_im_a4 1 noisy=0
V5 p5 s5 0
R5 s5 0 50 noisy=0
Gd5_1 0 s5 p1 0 0.0001497233242
Fd5_1 0 s5 V1 0.007486166211
Gr1_re_5_1 0 s5 x1_re_a1 0 26298.37235
Gr1_im_5_1 0 s5 x1_im_a1 0 -5863.094114
Gr2_5_1 0 s5 x2_a1 0 -0.00605167877
Gr3_re_5_1 0 s5 x3_re_a1 0 -10388.52226
Gr3_im_5_1 0 s5 x3_im_a1 0 3450.306994
Gr4_re_5_1 0 s5 x4_re_a1 0 -1010.351433
Gr4_im_5_1 0 s5 x4_im_a1 0 16934.19594
Gr5_re_5_1 0 s5 x5_re_a1 0 -30579.7871
Gr5_im_5_1 0 s5 x5_im_a1 0 -1461.310066
Gr6_re_5_1 0 s5 x6_re_a1 0 53945.73834
Gr6_im_5_1 0 s5 x6_im_a1 0 -17308.24885
Gr7_re_5_1 0 s5 x7_re_a1 0 -44727.09924
Gr7_im_5_1 0 s5 x7_im_a1 0 21414.89214
Gr8_re_5_1 0 s5 x8_re_a1 0 -40624.41345
Gr8_im_5_1 0 s5 x8_im_a1 0 -53093.95569
Gr9_re_5_1 0 s5 x9_re_a1 0 -56890.59653
Gr9_im_5_1 0 s5 x9_im_a1 0 -27514.19703
Gr10_re_5_1 0 s5 x10_re_a1 0 -169226.4728
Gr10_im_5_1 0 s5 x10_im_a1 0 -86474.47732
Gr11_re_5_1 0 s5 x11_re_a1 0 -98305.63593
Gr11_im_5_1 0 s5 x11_im_a1 0 241859.0419
Gr12_re_5_1 0 s5 x12_re_a1 0 223308.6092
Gr12_im_5_1 0 s5 x12_im_a1 0 -26861.74953
Gd5_2 0 s5 p2 0 0.0008053404884
Fd5_2 0 s5 V2 0.04026702442
Gr1_re_5_2 0 s5 x1_re_a2 0 -167982.8017
Gr1_im_5_2 0 s5 x1_im_a2 0 -342821.5831
Gr2_5_2 0 s5 x2_a2 0 0.2370900767
Gr3_re_5_2 0 s5 x3_re_a2 0 183446.7432
Gr3_im_5_2 0 s5 x3_im_a2 0 -190163.814
Gr4_re_5_2 0 s5 x4_re_a2 0 -105822.8671
Gr4_im_5_2 0 s5 x4_im_a2 0 -131462.1112
Gr5_re_5_2 0 s5 x5_re_a2 0 -85165.31086
Gr5_im_5_2 0 s5 x5_im_a2 0 163788.0017
Gr6_re_5_2 0 s5 x6_re_a2 0 61867.87718
Gr6_im_5_2 0 s5 x6_im_a2 0 139654.0194
Gr7_re_5_2 0 s5 x7_re_a2 0 -261532.688
Gr7_im_5_2 0 s5 x7_im_a2 0 -370098.9065
Gr8_re_5_2 0 s5 x8_re_a2 0 105846.7042
Gr8_im_5_2 0 s5 x8_im_a2 0 -145029.8988
Gr9_re_5_2 0 s5 x9_re_a2 0 144934.935
Gr9_im_5_2 0 s5 x9_im_a2 0 -50846.46737
Gr10_re_5_2 0 s5 x10_re_a2 0 81720.04147
Gr10_im_5_2 0 s5 x10_im_a2 0 -68124.844
Gr11_re_5_2 0 s5 x11_re_a2 0 -63198.96425
Gr11_im_5_2 0 s5 x11_im_a2 0 -84855.4408
Gr12_re_5_2 0 s5 x12_re_a2 0 -8100.744471
Gr12_im_5_2 0 s5 x12_im_a2 0 -110480.9594
Gd5_3 0 s5 p3 0 -0.000664518971
Fd5_3 0 s5 V3 -0.03322594855
Gr1_re_5_3 0 s5 x1_re_a3 0 -487512.0802
Gr1_im_5_3 0 s5 x1_im_a3 0 -19026.65614
Gr2_5_3 0 s5 x2_a3 0 0.5585379286
Gr3_re_5_3 0 s5 x3_re_a3 0 -292619.0854
Gr3_im_5_3 0 s5 x3_im_a3 0 354423.5035
Gr4_re_5_3 0 s5 x4_re_a3 0 -299702.4651
Gr4_im_5_3 0 s5 x4_im_a3 0 301970.3535
Gr5_re_5_3 0 s5 x5_re_a3 0 112396.875
Gr5_im_5_3 0 s5 x5_im_a3 0 -558979.1028
Gr6_re_5_3 0 s5 x6_re_a3 0 -161569.5631
Gr6_im_5_3 0 s5 x6_im_a3 0 1085617.246
Gr7_re_5_3 0 s5 x7_re_a3 0 470536.9456
Gr7_im_5_3 0 s5 x7_im_a3 0 205126.6154
Gr8_re_5_3 0 s5 x8_re_a3 0 366875.716
Gr8_im_5_3 0 s5 x8_im_a3 0 437202.2841
Gr9_re_5_3 0 s5 x9_re_a3 0 323286.9466
Gr9_im_5_3 0 s5 x9_im_a3 0 -743871.959
Gr10_re_5_3 0 s5 x10_re_a3 0 -19744.62794
Gr10_im_5_3 0 s5 x10_im_a3 0 56052.26796
Gr11_re_5_3 0 s5 x11_re_a3 0 64133.10329
Gr11_im_5_3 0 s5 x11_im_a3 0 140987.2096
Gr12_re_5_3 0 s5 x12_re_a3 0 7477.87988
Gr12_im_5_3 0 s5 x12_im_a3 0 49202.17645
Gd5_4 0 s5 p4 0 0.001034899246
Fd5_4 0 s5 V4 0.05174496232
Gr1_re_5_4 0 s5 x1_re_a4 0 327715.5188
Gr1_im_5_4 0 s5 x1_im_a4 0 42971.72572
Gr2_5_4 0 s5 x2_a4 0 -0.03626767724
Gr3_re_5_4 0 s5 x3_re_a4 0 506519.2714
Gr3_im_5_4 0 s5 x3_im_a4 0 -190225.226
Gr4_re_5_4 0 s5 x4_re_a4 0 -376829.4453
Gr4_im_5_4 0 s5 x4_im_a4 0 260084.839
Gr5_re_5_4 0 s5 x5_re_a4 0 -162069.7975
Gr5_im_5_4 0 s5 x5_im_a4 0 -685620.3138
Gr6_re_5_4 0 s5 x6_re_a4 0 -41137.43154
Gr6_im_5_4 0 s5 x6_im_a4 0 -188044.2426
Gr7_re_5_4 0 s5 x7_re_a4 0 655494.269
Gr7_im_5_4 0 s5 x7_im_a4 0 -257698.9253
Gr8_re_5_4 0 s5 x8_re_a4 0 279068.742
Gr8_im_5_4 0 s5 x8_im_a4 0 -384115.3078
Gr9_re_5_4 0 s5 x9_re_a4 0 -11798.78616
Gr9_im_5_4 0 s5 x9_im_a4 0 620678.4488
Gr10_re_5_4 0 s5 x10_re_a4 0 70045.28963
Gr10_im_5_4 0 s5 x10_im_a4 0 130623.4972
Gr11_re_5_4 0 s5 x11_re_a4 0 94826.60308
Gr11_im_5_4 0 s5 x11_im_a4 0 -264922.4438
Gr12_re_5_4 0 s5 x12_re_a4 0 220420.9394
Gr12_im_5_4 0 s5 x12_im_a4 0 47811.22952
Gd5_5 0 s5 p5 0 0.003299783679
Fd5_5 0 s5 V5 0.164989184
Gr1_re_5_5 0 s5 x1_re_a5 0 339458.8347
Gr1_im_5_5 0 s5 x1_im_a5 0 -37852.7672
Gr2_5_5 0 s5 x2_a5 0 -1.489313374
Gr3_re_5_5 0 s5 x3_re_a5 0 549755.2089
Gr3_im_5_5 0 s5 x3_im_a5 0 -129514.4606
Gr4_re_5_5 0 s5 x4_re_a5 0 10206.63275
Gr4_im_5_5 0 s5 x4_im_a5 0 -244252.6833
Gr5_re_5_5 0 s5 x5_re_a5 0 -365274.6726
Gr5_im_5_5 0 s5 x5_im_a5 0 -168115.0213
Gr6_re_5_5 0 s5 x6_re_a5 0 613469.0027
Gr6_im_5_5 0 s5 x6_im_a5 0 -1028183.016
Gr7_re_5_5 0 s5 x7_re_a5 0 466414.5822
Gr7_im_5_5 0 s5 x7_im_a5 0 -9425.668197
Gr8_re_5_5 0 s5 x8_re_a5 0 273826.0483
Gr8_im_5_5 0 s5 x8_im_a5 0 -586829.3824
Gr9_re_5_5 0 s5 x9_re_a5 0 -915033.1781
Gr9_im_5_5 0 s5 x9_im_a5 0 548724.924
Gr10_re_5_5 0 s5 x10_re_a5 0 21286.61608
Gr10_im_5_5 0 s5 x10_im_a5 0 192499.7763
Gr11_re_5_5 0 s5 x11_re_a5 0 180378.7561
Gr11_im_5_5 0 s5 x11_im_a5 0 -259929.5778
Gr12_re_5_5 0 s5 x12_re_a5 0 235268.6834
Gr12_im_5_5 0 s5 x12_im_a5 0 115788.4209
Gd5_6 0 s5 p6 0 0.002987775514
Fd5_6 0 s5 V6 0.1493887757
Gr1_re_5_6 0 s5 x1_re_a6 0 -314976.3512
Gr1_im_5_6 0 s5 x1_im_a6 0 -142260.065
Gr2_5_6 0 s5 x2_a6 0 -1.171548584
Gr3_re_5_6 0 s5 x3_re_a6 0 -190564.4086
Gr3_im_5_6 0 s5 x3_im_a6 0 406098.0806
Gr4_re_5_6 0 s5 x4_re_a6 0 -33.06859519
Gr4_im_5_6 0 s5 x4_im_a6 0 -264250.8194
Gr5_re_5_6 0 s5 x5_re_a6 0 75826.33851
Gr5_im_5_6 0 s5 x5_im_a6 0 -461779.8097
Gr6_re_5_6 0 s5 x6_re_a6 0 366263.4994
Gr6_im_5_6 0 s5 x6_im_a6 0 -314458.774
Gr7_re_5_6 0 s5 x7_re_a6 0 214794.2118
Gr7_im_5_6 0 s5 x7_im_a6 0 332106.4668
Gr8_re_5_6 0 s5 x8_re_a6 0 282056.0861
Gr8_im_5_6 0 s5 x8_im_a6 0 139408.8481
Gr9_re_5_6 0 s5 x9_re_a6 0 -383749.3433
Gr9_im_5_6 0 s5 x9_im_a6 0 164425.3332
Gr10_re_5_6 0 s5 x10_re_a6 0 -147587.8798
Gr10_im_5_6 0 s5 x10_im_a6 0 117679.5593
Gr11_re_5_6 0 s5 x11_re_a6 0 301546.5676
Gr11_im_5_6 0 s5 x11_im_a6 0 35303.08203
Gr12_re_5_6 0 s5 x12_re_a6 0 2768.749083
Gr12_im_5_6 0 s5 x12_im_a6 0 295730.082
Gd5_7 0 s5 p7 0 -0.0003313005548
Fd5_7 0 s5 V7 -0.01656502774
Gr1_re_5_7 0 s5 x1_re_a7 0 457546.2236
Gr1_im_5_7 0 s5 x1_im_a7 0 202247.6065
Gr2_5_7 0 s5 x2_a7 0 0.06206444522
Gr3_re_5_7 0 s5 x3_re_a7 0 186406.866
Gr3_im_5_7 0 s5 x3_im_a7 0 -168222.4041
Gr4_re_5_7 0 s5 x4_re_a7 0 22023.33759
Gr4_im_5_7 0 s5 x4_im_a7 0 -178226.3112
Gr5_re_5_7 0 s5 x5_re_a7 0 -100072.4619
Gr5_im_5_7 0 s5 x5_im_a7 0 180459.4121
Gr6_re_5_7 0 s5 x6_re_a7 0 363907.7572
Gr6_im_5_7 0 s5 x6_im_a7 0 -334021.1381
Gr7_re_5_7 0 s5 x7_re_a7 0 -224897.7445
Gr7_im_5_7 0 s5 x7_im_a7 0 -290555.0686
Gr8_re_5_7 0 s5 x8_re_a7 0 106868.8651
Gr8_im_5_7 0 s5 x8_im_a7 0 -238432.08
Gr9_re_5_7 0 s5 x9_re_a7 0 -449232.255
Gr9_im_5_7 0 s5 x9_im_a7 0 48619.74992
Gr10_re_5_7 0 s5 x10_re_a7 0 85950.82615
Gr10_im_5_7 0 s5 x10_im_a7 0 -42474.87365
Gr11_re_5_7 0 s5 x11_re_a7 0 -58090.44492
Gr11_im_5_7 0 s5 x11_im_a7 0 -19320.3777
Gr12_re_5_7 0 s5 x12_re_a7 0 -1412.345883
Gr12_im_5_7 0 s5 x12_im_a7 0 -137926.2931
Cx1_re_a5 x1_re_a5 0 3.89287585e-12
Gx1_re_a5 0 x1_re_a5 p5 0 3.968460931e-08
Fx1_re_a5 0 x1_re_a5 V5 1.984230465e-06
Rp1_re_re_a5 0 x1_re_a5 1 noisy=0
Gp1_re_im_a5 0 x1_re_a5 x1_im_a5 0 6.237829681
Cx1_im_a5 x1_im_a5 0 3.89287585e-12
Gp1_im_re_a5 0 x1_im_a5 x1_re_a5 0 -6.237829681
Rp1_im_im_a5 0 x1_im_a5 1 noisy=0
Cx2_a5 x2_a5 0 1.818528442e-12
Gx2_a5 0 x2_a5 p5 0 0.02978626748
Fx2_a5 0 x2_a5 V5 1.489313374
Rp2_a5 0 x2_a5 1 noisy=0
Cx3_re_a5 x3_re_a5 0 1.3261597e-11
Gx3_re_a5 0 x3_re_a5 p5 0 4.36809725e-08
Fx3_re_a5 0 x3_re_a5 V5 2.184048625e-06
Rp3_re_re_a5 0 x3_re_a5 1 noisy=0
Gp3_re_im_a5 0 x3_re_a5 x3_im_a5 0 17.80378221
Cx3_im_a5 x3_im_a5 0 1.3261597e-11
Gp3_im_re_a5 0 x3_im_a5 x3_re_a5 0 -17.80378221
Rp3_im_im_a5 0 x3_im_a5 1 noisy=0
Cx4_re_a5 x4_re_a5 0 3.619491499e-12
Gx4_re_a5 0 x4_re_a5 p5 0 1.037657354e-07
Fx4_re_a5 0 x4_re_a5 V5 5.188286768e-06
Rp4_re_re_a5 0 x4_re_a5 1 noisy=0
Gp4_re_im_a5 0 x4_re_a5 x4_im_a5 0 1.759573164
Cx4_im_a5 x4_im_a5 0 3.619491499e-12
Gp4_im_re_a5 0 x4_im_a5 x4_re_a5 0 -1.759573164
Rp4_im_im_a5 0 x4_im_a5 1 noisy=0
Cx5_re_a5 x5_re_a5 0 2.551196837e-12
Gx5_re_a5 0 x5_re_a5 p5 0 9.780764046e-08
Fx5_re_a5 0 x5_re_a5 V5 4.890382023e-06
Rp5_re_re_a5 0 x5_re_a5 1 noisy=0
Gp5_re_im_a5 0 x5_re_a5 x5_im_a5 0 1.86425479
Cx5_im_a5 x5_im_a5 0 2.551196837e-12
Gp5_im_re_a5 0 x5_im_a5 x5_re_a5 0 -1.86425479
Rp5_im_im_a5 0 x5_im_a5 1 noisy=0
Cx6_re_a5 x6_re_a5 0 4.347339998e-12
Gx6_re_a5 0 x6_re_a5 p5 0 9.681502983e-08
Fx6_re_a5 0 x6_re_a5 V5 4.840751492e-06
Rp6_re_re_a5 0 x6_re_a5 1 noisy=0
Gp6_re_im_a5 0 x6_re_a5 x6_im_a5 0 5.043445659
Cx6_im_a5 x6_im_a5 0 4.347339998e-12
Gp6_im_re_a5 0 x6_im_a5 x6_re_a5 0 -5.043445659
Rp6_im_im_a5 0 x6_im_a5 1 noisy=0
Cx7_re_a5 x7_re_a5 0 8.303908788e-12
Gx7_re_a5 0 x7_re_a5 p5 0 7.304472112e-08
Fx7_re_a5 0 x7_re_a5 V5 3.652236056e-06
Rp7_re_re_a5 0 x7_re_a5 1 noisy=0
Gp7_re_im_a5 0 x7_re_a5 x7_im_a5 0 7.230551368
Cx7_im_a5 x7_im_a5 0 8.303908788e-12
Gp7_im_re_a5 0 x7_im_a5 x7_re_a5 0 -7.230551368
Rp7_im_im_a5 0 x7_im_a5 1 noisy=0
Cx8_re_a5 x8_re_a5 0 1.359672759e-11
Gx8_re_a5 0 x8_re_a5 p5 0 5.41734869e-08
Fx8_re_a5 0 x8_re_a5 V5 2.708674345e-06
Rp8_re_re_a5 0 x8_re_a5 1 noisy=0
Gp8_re_im_a5 0 x8_re_a5 x8_im_a5 0 15.68097665
Cx8_im_a5 x8_im_a5 0 1.359672759e-11
Gp8_im_re_a5 0 x8_im_a5 x8_re_a5 0 -15.68097665
Rp8_im_im_a5 0 x8_im_a5 1 noisy=0
Cx9_re_a5 x9_re_a5 0 6.291227666e-12
Gx9_re_a5 0 x9_re_a5 p5 0 9.828972403e-08
Fx9_re_a5 0 x9_re_a5 V5 4.914486202e-06
Rp9_re_re_a5 0 x9_re_a5 1 noisy=0
Gp9_re_im_a5 0 x9_re_a5 x9_im_a5 0 6.899132195
Cx9_im_a5 x9_im_a5 0 6.291227666e-12
Gp9_im_re_a5 0 x9_im_a5 x9_re_a5 0 -6.899132195
Rp9_im_im_a5 0 x9_im_a5 1 noisy=0
Cx10_re_a5 x10_re_a5 0 3.245362601e-11
Gx10_re_a5 0 x10_re_a5 p5 0 2.986232719e-08
Fx10_re_a5 0 x10_re_a5 V5 1.49311636e-06
Rp10_re_re_a5 0 x10_re_a5 1 noisy=0
Gp10_re_im_a5 0 x10_re_a5 x10_im_a5 0 30.09488123
Cx10_im_a5 x10_im_a5 0 3.245362601e-11
Gp10_im_re_a5 0 x10_im_a5 x10_re_a5 0 -30.09488123
Rp10_im_im_a5 0 x10_im_a5 1 noisy=0
Cx11_re_a5 x11_re_a5 0 2.341034518e-11
Gx11_re_a5 0 x11_re_a5 p5 0 3.677491946e-08
Fx11_re_a5 0 x11_re_a5 V5 1.838745973e-06
Rp11_re_re_a5 0 x11_re_a5 1 noisy=0
Gp11_re_im_a5 0 x11_re_a5 x11_im_a5 0 25.09850718
Cx11_im_a5 x11_im_a5 0 2.341034518e-11
Gp11_im_re_a5 0 x11_im_a5 x11_re_a5 0 -25.09850718
Rp11_im_im_a5 0 x11_im_a5 1 noisy=0
Cx12_re_a5 x12_re_a5 0 2.361018525e-11
Gx12_re_a5 0 x12_re_a5 p5 0 3.911984662e-08
Fx12_re_a5 0 x12_re_a5 V5 1.955992331e-06
Rp12_re_re_a5 0 x12_re_a5 1 noisy=0
Gp12_re_im_a5 0 x12_re_a5 x12_im_a5 0 23.41457436
Cx12_im_a5 x12_im_a5 0 2.361018525e-11
Gp12_im_re_a5 0 x12_im_a5 x12_re_a5 0 -23.41457436
Rp12_im_im_a5 0 x12_im_a5 1 noisy=0
V6 p6 s6 0
R6 s6 0 50 noisy=0
Gd6_1 0 s6 p1 0 -7.367340667e-07
Fd6_1 0 s6 V1 -3.683670333e-05
Gr1_re_6_1 0 s6 x1_re_a1 0 -2384.566473
Gr1_im_6_1 0 s6 x1_im_a1 0 13348.58173
Gr2_6_1 0 s6 x2_a1 0 -0.01520586064
Gr3_re_6_1 0 s6 x3_re_a1 0 -961.2415302
Gr3_im_6_1 0 s6 x3_im_a1 0 848.6335886
Gr4_re_6_1 0 s6 x4_re_a1 0 -9601.68985
Gr4_im_6_1 0 s6 x4_im_a1 0 175.4086938
Gr5_re_6_1 0 s6 x5_re_a1 0 -6542.863402
Gr5_im_6_1 0 s6 x5_im_a1 0 -17890.49908
Gr6_re_6_1 0 s6 x6_re_a1 0 12477.4316
Gr6_im_6_1 0 s6 x6_im_a1 0 31422.2912
Gr7_re_6_1 0 s6 x7_re_a1 0 -26005.49174
Gr7_im_6_1 0 s6 x7_im_a1 0 -24038.14069
Gr8_re_6_1 0 s6 x8_re_a1 0 35041.75219
Gr8_im_6_1 0 s6 x8_im_a1 0 -25896.28848
Gr9_re_6_1 0 s6 x9_re_a1 0 18676.22529
Gr9_im_6_1 0 s6 x9_im_a1 0 -39782.00499
Gr10_re_6_1 0 s6 x10_re_a1 0 28617.63709
Gr10_im_6_1 0 s6 x10_im_a1 0 -152670.4606
Gr11_re_6_1 0 s6 x11_re_a1 0 -200296.7867
Gr11_im_6_1 0 s6 x11_im_a1 0 -70420.32726
Gr12_re_6_1 0 s6 x12_re_a1 0 46683.50949
Gr12_im_6_1 0 s6 x12_im_a1 0 174165.7409
Gd6_2 0 s6 p2 0 -1.366513676e-05
Fd6_2 0 s6 V2 -0.0006832568382
Gr1_re_6_2 0 s6 x1_re_a2 0 206772.2213
Gr1_im_6_2 0 s6 x1_im_a2 0 335525.2502
Gr2_6_2 0 s6 x2_a2 0 0.5241925748
Gr3_re_6_2 0 s6 x3_re_a2 0 5466.450317
Gr3_im_6_2 0 s6 x3_im_a2 0 132612.5671
Gr4_re_6_2 0 s6 x4_re_a2 0 26390.46342
Gr4_im_6_2 0 s6 x4_im_a2 0 -113779.7587
Gr5_re_6_2 0 s6 x5_re_a2 0 -356011.5611
Gr5_im_6_2 0 s6 x5_im_a2 0 376206.4301
Gr6_re_6_2 0 s6 x6_re_a2 0 402935.6868
Gr6_im_6_2 0 s6 x6_im_a2 0 -649345.0512
Gr7_re_6_2 0 s6 x7_re_a2 0 66283.68298
Gr7_im_6_2 0 s6 x7_im_a2 0 -272882.6275
Gr8_re_6_2 0 s6 x8_re_a2 0 121814.8855
Gr8_im_6_2 0 s6 x8_im_a2 0 41298.39291
Gr9_re_6_2 0 s6 x9_re_a2 0 -171855.4914
Gr9_im_6_2 0 s6 x9_im_a2 0 -211847.1316
Gr10_re_6_2 0 s6 x10_re_a2 0 68166.78268
Gr10_im_6_2 0 s6 x10_im_a2 0 39177.13941
Gr11_re_6_2 0 s6 x11_re_a2 0 53661.44231
Gr11_im_6_2 0 s6 x11_im_a2 0 -8261.82811
Gr12_re_6_2 0 s6 x12_re_a2 0 73399.5116
Gr12_im_6_2 0 s6 x12_im_a2 0 -44829.53801
Gd6_3 0 s6 p3 0 -0.0001345027133
Fd6_3 0 s6 V3 -0.006725135667
Gr1_re_6_3 0 s6 x1_re_a3 0 651306.0683
Gr1_im_6_3 0 s6 x1_im_a3 0 207167.0932
Gr2_6_3 0 s6 x2_a3 0 0.06889810814
Gr3_re_6_3 0 s6 x3_re_a3 0 -76865.31961
Gr3_im_6_3 0 s6 x3_im_a3 0 -314688.109
Gr4_re_6_3 0 s6 x4_re_a3 0 -433297.4176
Gr4_im_6_3 0 s6 x4_im_a3 0 369386.5281
Gr5_re_6_3 0 s6 x5_re_a3 0 -79199.7076
Gr5_im_6_3 0 s6 x5_im_a3 0 -792730.8762
Gr6_re_6_3 0 s6 x6_re_a3 0 101486.6002
Gr6_im_6_3 0 s6 x6_im_a3 0 158026.2106
Gr7_re_6_3 0 s6 x7_re_a3 0 -16201.70607
Gr7_im_6_3 0 s6 x7_im_a3 0 180157.4561
Gr8_re_6_3 0 s6 x8_re_a3 0 -164550.5845
Gr8_im_6_3 0 s6 x8_im_a3 0 265976.1128
Gr9_re_6_3 0 s6 x9_re_a3 0 328582.7063
Gr9_im_6_3 0 s6 x9_im_a3 0 -605659.5181
Gr10_re_6_3 0 s6 x10_re_a3 0 -76825.66315
Gr10_im_6_3 0 s6 x10_im_a3 0 -80551.72813
Gr11_re_6_3 0 s6 x11_re_a3 0 -110931.9764
Gr11_im_6_3 0 s6 x11_im_a3 0 180910.4767
Gr12_re_6_3 0 s6 x12_re_a3 0 -163746.1435
Gr12_im_6_3 0 s6 x12_im_a3 0 -20461.31893
Gd6_4 0 s6 p4 0 -0.000743905629
Fd6_4 0 s6 V4 -0.03719528145
Gr1_re_6_4 0 s6 x1_re_a4 0 -565856.2128
Gr1_im_6_4 0 s6 x1_im_a4 0 -12143.66939
Gr2_6_4 0 s6 x2_a4 0 0.5994023571
Gr3_re_6_4 0 s6 x3_re_a4 0 -202974.5894
Gr3_im_6_4 0 s6 x3_im_a4 0 293234.5562
Gr4_re_6_4 0 s6 x4_re_a4 0 -325984.1324
Gr4_im_6_4 0 s6 x4_im_a4 0 335551.8615
Gr5_re_6_4 0 s6 x5_re_a4 0 124139.3659
Gr5_im_6_4 0 s6 x5_im_a4 0 -494464.761
Gr6_re_6_4 0 s6 x6_re_a4 0 -138127.871
Gr6_im_6_4 0 s6 x6_im_a4 0 816005.4005
Gr7_re_6_4 0 s6 x7_re_a4 0 469719.5687
Gr7_im_6_4 0 s6 x7_im_a4 0 249168.7058
Gr8_re_6_4 0 s6 x8_re_a4 0 351338.6149
Gr8_im_6_4 0 s6 x8_im_a4 0 384207.0428
Gr9_re_6_4 0 s6 x9_re_a4 0 182428.1065
Gr9_im_6_4 0 s6 x9_im_a4 0 -525474.223
Gr10_re_6_4 0 s6 x10_re_a4 0 -27478.90804
Gr10_im_6_4 0 s6 x10_im_a4 0 50724.98042
Gr11_re_6_4 0 s6 x11_re_a4 0 78223.38507
Gr11_im_6_4 0 s6 x11_im_a4 0 120710.392
Gr12_re_6_4 0 s6 x12_re_a4 0 -2263.661487
Gr12_im_6_4 0 s6 x12_im_a4 0 58318.77688
Gd6_5 0 s6 p5 0 0.002987775514
Fd6_5 0 s6 V5 0.1493887757
Gr1_re_6_5 0 s6 x1_re_a5 0 -336815.56
Gr1_im_6_5 0 s6 x1_im_a5 0 -152123.8127
Gr2_6_5 0 s6 x2_a5 0 -1.123922556
Gr3_re_6_5 0 s6 x3_re_a5 0 -146767.1961
Gr3_im_6_5 0 s6 x3_im_a5 0 312764.9966
Gr4_re_6_5 0 s6 x4_re_a5 0 -37.08946472
Gr4_im_6_5 0 s6 x4_im_a5 0 -296381.5602
Gr5_re_6_5 0 s6 x5_re_a5 0 79135.34989
Gr5_im_6_5 0 s6 x5_im_a5 0 -481931.5759
Gr6_re_6_5 0 s6 x6_re_a5 0 313036.4373
Gr6_im_6_5 0 s6 x6_im_a5 0 -268760.2081
Gr7_re_6_5 0 s6 x7_re_a5 0 210194.4456
Gr7_im_6_5 0 s6 x7_im_a5 0 324994.4869
Gr8_re_6_5 0 s6 x8_re_a5 0 258470.0545
Gr8_im_6_5 0 s6 x8_im_a5 0 127751.2323
Gr9_re_6_5 0 s6 x9_re_a5 0 -332698.1802
Gr9_im_6_5 0 s6 x9_im_a5 0 142551.4078
Gr10_re_6_5 0 s6 x10_re_a5 0 -136987.4363
Gr10_im_6_5 0 s6 x10_im_a5 0 109227.2696
Gr11_re_6_5 0 s6 x11_re_a5 0 252040.2451
Gr11_im_6_5 0 s6 x11_im_a5 0 29507.20851
Gr12_re_6_5 0 s6 x12_re_a5 0 2377.398268
Gr12_im_6_5 0 s6 x12_im_a5 0 253929.9024
Gd6_6 0 s6 p6 0 0.001417872614
Fd6_6 0 s6 V6 0.07089363072
Gr1_re_6_6 0 s6 x1_re_a6 0 200218.0525
Gr1_im_6_6 0 s6 x1_im_a6 0 -168007.4966
Gr2_6_6 0 s6 x2_a6 0 -1.428769508
Gr3_re_6_6 0 s6 x3_re_a6 0 -18538.26562
Gr3_im_6_6 0 s6 x3_im_a6 0 -215872.2536
Gr4_re_6_6 0 s6 x4_re_a6 0 77857.12785
Gr4_im_6_6 0 s6 x4_im_a6 0 -229783.242
Gr5_re_6_6 0 s6 x5_re_a6 0 22295.09862
Gr5_im_6_6 0 s6 x5_im_a6 0 -18449.52533
Gr6_re_6_6 0 s6 x6_re_a6 0 478392.6331
Gr6_im_6_6 0 s6 x6_im_a6 0 -836308.2983
Gr7_re_6_6 0 s6 x7_re_a6 0 -210742.8039
Gr7_im_6_6 0 s6 x7_im_a6 0 425013.0097
Gr8_re_6_6 0 s6 x8_re_a6 0 -164701.1833
Gr8_im_6_6 0 s6 x8_im_a6 0 -5695.669503
Gr9_re_6_6 0 s6 x9_re_a6 0 -704304.4477
Gr9_im_6_6 0 s6 x9_im_a6 0 169983.4652
Gr10_re_6_6 0 s6 x10_re_a6 0 -170621.458
Gr10_im_6_6 0 s6 x10_im_a6 0 -12193.36504
Gr11_re_6_6 0 s6 x11_re_a6 0 112919.9349
Gr11_im_6_6 0 s6 x11_im_a6 0 167230.2461
Gr12_re_6_6 0 s6 x12_re_a6 0 -187620.0368
Gr12_im_6_6 0 s6 x12_im_a6 0 158735.1382
Gd6_7 0 s6 p7 0 -9.1444533e-05
Fd6_7 0 s6 V7 -0.00457222665
Gr1_re_6_7 0 s6 x1_re_a7 0 -536104.0262
Gr1_im_6_7 0 s6 x1_im_a7 0 -249205.7257
Gr2_6_7 0 s6 x2_a7 0 0.3258798497
Gr3_re_6_7 0 s6 x3_re_a7 0 2538.179631
Gr3_im_6_7 0 s6 x3_im_a7 0 181264.9263
Gr4_re_6_7 0 s6 x4_re_a7 0 135362.089
Gr4_im_6_7 0 s6 x4_im_a7 0 -209344.5006
Gr5_re_6_7 0 s6 x5_re_a7 0 -119613.6425
Gr5_im_6_7 0 s6 x5_im_a7 0 286375.0669
Gr6_re_6_7 0 s6 x6_re_a7 0 -64865.07605
Gr6_im_6_7 0 s6 x6_im_a7 0 330093.8888
Gr7_re_6_7 0 s6 x7_re_a7 0 71717.31221
Gr7_im_6_7 0 s6 x7_im_a7 0 -270395.0949
Gr8_re_6_7 0 s6 x8_re_a7 0 126351.954
Gr8_im_6_7 0 s6 x8_im_a7 0 58679.48545
Gr9_re_6_7 0 s6 x9_re_a7 0 339846.0874
Gr9_im_6_7 0 s6 x9_im_a7 0 -45456.36632
Gr10_re_6_7 0 s6 x10_re_a7 0 34779.70323
Gr10_im_6_7 0 s6 x10_im_a7 0 48409.20425
Gr11_re_6_7 0 s6 x11_re_a7 0 65359.03212
Gr11_im_6_7 0 s6 x11_im_a7 0 -79211.33306
Gr12_re_6_7 0 s6 x12_re_a7 0 84428.45114
Gr12_im_6_7 0 s6 x12_im_a7 0 26741.25594
Cx1_re_a6 x1_re_a6 0 3.89287585e-12
Gx1_re_a6 0 x1_re_a6 p6 0 4.243618245e-08
Fx1_re_a6 0 x1_re_a6 V6 2.121809123e-06
Rp1_re_re_a6 0 x1_re_a6 1 noisy=0
Gp1_re_im_a6 0 x1_re_a6 x1_im_a6 0 6.237829681
Cx1_im_a6 x1_im_a6 0 3.89287585e-12
Gp1_im_re_a6 0 x1_im_a6 x1_re_a6 0 -6.237829681
Rp1_im_im_a6 0 x1_im_a6 1 noisy=0
Cx2_a6 x2_a6 0 1.818528442e-12
Gx2_a6 0 x2_a6 p6 0 0.02857539017
Fx2_a6 0 x2_a6 V6 1.428769508
Rp2_a6 0 x2_a6 1 noisy=0
Cx3_re_a6 x3_re_a6 0 1.3261597e-11
Gx3_re_a6 0 x3_re_a6 p6 0 3.364182169e-08
Fx3_re_a6 0 x3_re_a6 V6 1.682091085e-06
Rp3_re_re_a6 0 x3_re_a6 1 noisy=0
Gp3_re_im_a6 0 x3_re_a6 x3_im_a6 0 17.80378221
Cx3_im_a6 x3_im_a6 0 1.3261597e-11
Gp3_im_re_a6 0 x3_im_a6 x3_re_a6 0 -17.80378221
Rp3_im_im_a6 0 x3_im_a6 1 noisy=0
Cx4_re_a6 x4_re_a6 0 3.619491499e-12
Gx4_re_a6 0 x4_re_a6 p6 0 1.163828011e-07
Fx4_re_a6 0 x4_re_a6 V6 5.819140054e-06
Rp4_re_re_a6 0 x4_re_a6 1 noisy=0
Gp4_re_im_a6 0 x4_re_a6 x4_im_a6 0 1.759573164
Cx4_im_a6 x4_im_a6 0 3.619491499e-12
Gp4_im_re_a6 0 x4_im_a6 x4_re_a6 0 -1.759573164
Rp4_im_im_a6 0 x4_im_a6 1 noisy=0
Cx5_re_a6 x5_re_a6 0 2.551196837e-12
Gx5_re_a6 0 x5_re_a6 p6 0 1.020759014e-07
Fx5_re_a6 0 x5_re_a6 V6 5.103795068e-06
Rp5_re_re_a6 0 x5_re_a6 1 noisy=0
Gp5_re_im_a6 0 x5_re_a6 x5_im_a6 0 1.86425479
Cx5_im_a6 x5_im_a6 0 2.551196837e-12
Gp5_im_re_a6 0 x5_im_a6 x5_re_a6 0 -1.86425479
Rp5_im_im_a6 0 x5_im_a6 1 noisy=0
Cx6_re_a6 x6_re_a6 0 4.347339998e-12
Gx6_re_a6 0 x6_re_a6 p6 0 8.274543346e-08
Fx6_re_a6 0 x6_re_a6 V6 4.137271673e-06
Rp6_re_re_a6 0 x6_re_a6 1 noisy=0
Gp6_re_im_a6 0 x6_re_a6 x6_im_a6 0 5.043445659
Cx6_im_a6 x6_im_a6 0 4.347339998e-12
Gp6_im_re_a6 0 x6_im_a6 x6_re_a6 0 -5.043445659
Rp6_im_im_a6 0 x6_im_a6 1 noisy=0
Cx7_re_a6 x7_re_a6 0 8.303908788e-12
Gx7_re_a6 0 x7_re_a6 p6 0 7.148048604e-08
Fx7_re_a6 0 x7_re_a6 V6 3.574024302e-06
Rp7_re_re_a6 0 x7_re_a6 1 noisy=0
Gp7_re_im_a6 0 x7_re_a6 x7_im_a6 0 7.230551368
Cx7_im_a6 x7_im_a6 0 8.303908788e-12
Gp7_im_re_a6 0 x7_im_a6 x7_re_a6 0 -7.230551368
Rp7_im_im_a6 0 x7_im_a6 1 noisy=0
Cx8_re_a6 x8_re_a6 0 1.359672759e-11
Gx8_re_a6 0 x8_re_a6 p6 0 4.964340357e-08
Fx8_re_a6 0 x8_re_a6 V6 2.482170179e-06
Rp8_re_re_a6 0 x8_re_a6 1 noisy=0
Gp8_re_im_a6 0 x8_re_a6 x8_im_a6 0 15.68097665
Cx8_im_a6 x8_im_a6 0 1.359672759e-11
Gp8_im_re_a6 0 x8_im_a6 x8_re_a6 0 -15.68097665
Rp8_im_im_a6 0 x8_im_a6 1 noisy=0
Cx9_re_a6 x9_re_a6 0 6.291227666e-12
Gx9_re_a6 0 x9_re_a6 p6 0 8.5213989e-08
Fx9_re_a6 0 x9_re_a6 V6 4.26069945e-06
Rp9_re_re_a6 0 x9_re_a6 1 noisy=0
Gp9_re_im_a6 0 x9_re_a6 x9_im_a6 0 6.899132195
Cx9_im_a6 x9_im_a6 0 6.291227666e-12
Gp9_im_re_a6 0 x9_im_a6 x9_re_a6 0 -6.899132195
Rp9_im_im_a6 0 x9_im_a6 1 noisy=0
Cx10_re_a6 x10_re_a6 0 3.245362601e-11
Gx10_re_a6 0 x10_re_a6 p6 0 2.771747688e-08
Fx10_re_a6 0 x10_re_a6 V6 1.385873844e-06
Rp10_re_re_a6 0 x10_re_a6 1 noisy=0
Gp10_re_im_a6 0 x10_re_a6 x10_im_a6 0 30.09488123
Cx10_im_a6 x10_im_a6 0 3.245362601e-11
Gp10_im_re_a6 0 x10_im_a6 x10_re_a6 0 -30.09488123
Rp10_im_im_a6 0 x10_im_a6 1 noisy=0
Cx11_re_a6 x11_re_a6 0 2.341034518e-11
Gx11_re_a6 0 x11_re_a6 p6 0 3.073740745e-08
Fx11_re_a6 0 x11_re_a6 V6 1.536870373e-06
Rp11_re_re_a6 0 x11_re_a6 1 noisy=0
Gp11_re_im_a6 0 x11_re_a6 x11_im_a6 0 25.09850718
Cx11_im_a6 x11_im_a6 0 2.341034518e-11
Gp11_im_re_a6 0 x11_im_a6 x11_re_a6 0 -25.09850718
Rp11_im_im_a6 0 x11_im_a6 1 noisy=0
Cx12_re_a6 x12_re_a6 0 2.361018525e-11
Gx12_re_a6 0 x12_re_a6 p6 0 3.359042396e-08
Fx12_re_a6 0 x12_re_a6 V6 1.679521198e-06
Rp12_re_re_a6 0 x12_re_a6 1 noisy=0
Gp12_re_im_a6 0 x12_re_a6 x12_im_a6 0 23.41457436
Cx12_im_a6 x12_im_a6 0 2.361018525e-11
Gp12_im_re_a6 0 x12_im_a6 x12_re_a6 0 -23.41457436
Rp12_im_im_a6 0 x12_im_a6 1 noisy=0
V7 p7 s7 0
R7 s7 0 50 noisy=0
Gd7_1 0 s7 p1 0 -1.02458219e-05
Fd7_1 0 s7 V1 -0.0005122910949
Gr1_re_7_1 0 s7 x1_re_a1 0 268.2036921
Gr1_im_7_1 0 s7 x1_im_a1 0 -1659.122213
Gr2_7_1 0 s7 x2_a1 0 0.005448520085
Gr3_re_7_1 0 s7 x3_re_a1 0 -1208.795133
Gr3_im_7_1 0 s7 x3_im_a1 0 -946.8905289
Gr4_re_7_1 0 s7 x4_re_a1 0 3975.812391
Gr4_im_7_1 0 s7 x4_im_a1 0 1534.017519
Gr5_re_7_1 0 s7 x5_re_a1 0 1010.216052
Gr5_im_7_1 0 s7 x5_im_a1 0 4904.729612
Gr6_re_7_1 0 s7 x6_re_a1 0 -2001.38413
Gr6_im_7_1 0 s7 x6_im_a1 0 -8317.23206
Gr7_re_7_1 0 s7 x7_re_a1 0 8413.133556
Gr7_im_7_1 0 s7 x7_im_a1 0 9850.915068
Gr8_re_7_1 0 s7 x8_re_a1 0 -12648.557
Gr8_im_7_1 0 s7 x8_im_a1 0 -7652.764717
Gr9_re_7_1 0 s7 x9_re_a1 0 -1463.643567
Gr9_im_7_1 0 s7 x9_im_a1 0 12182.62112
Gr10_re_7_1 0 s7 x10_re_a1 0 -22614.20197
Gr10_im_7_1 0 s7 x10_im_a1 0 49528.14237
Gr11_re_7_1 0 s7 x11_re_a1 0 17950.85481
Gr11_im_7_1 0 s7 x11_im_a1 0 16883.70919
Gr12_re_7_1 0 s7 x12_re_a1 0 -12380.20146
Gr12_im_7_1 0 s7 x12_im_a1 0 -42049.98276
Gd7_2 0 s7 p2 0 0.003379576858
Fd7_2 0 s7 V2 0.1689788429
Gr1_re_7_2 0 s7 x1_re_a2 0 233140.5502
Gr1_im_7_2 0 s7 x1_im_a2 0 84394.64536
Gr2_7_2 0 s7 x2_a2 0 -1.088204627
Gr3_re_7_2 0 s7 x3_re_a2 0 25460.60665
Gr3_im_7_2 0 s7 x3_im_a2 0 -83978.04659
Gr4_re_7_2 0 s7 x4_re_a2 0 -389496.2931
Gr4_im_7_2 0 s7 x4_im_a2 0 93677.20045
Gr5_re_7_2 0 s7 x5_re_a2 0 16929.91908
Gr5_im_7_2 0 s7 x5_im_a2 0 -867220.4501
Gr6_re_7_2 0 s7 x6_re_a2 0 407945.3143
Gr6_im_7_2 0 s7 x6_im_a2 0 -282474.6896
Gr7_re_7_2 0 s7 x7_re_a2 0 -53578.32812
Gr7_im_7_2 0 s7 x7_im_a2 0 69597.92613
Gr8_re_7_2 0 s7 x8_re_a2 0 -27973.14648
Gr8_im_7_2 0 s7 x8_im_a2 0 -76817.82033
Gr9_re_7_2 0 s7 x9_re_a2 0 72787.81875
Gr9_im_7_2 0 s7 x9_im_a2 0 54889.54726
Gr10_re_7_2 0 s7 x10_re_a2 0 -25342.26639
Gr10_im_7_2 0 s7 x10_im_a2 0 -37515.43228
Gr11_re_7_2 0 s7 x11_re_a2 0 36821.2654
Gr11_im_7_2 0 s7 x11_im_a2 0 -12892.9909
Gr12_re_7_2 0 s7 x12_re_a2 0 -55357.72323
Gr12_im_7_2 0 s7 x12_im_a2 0 32489.06108
Gd7_3 0 s7 p3 0 2.023576629e-05
Fd7_3 0 s7 V3 0.001011788315
Gr1_re_7_3 0 s7 x1_re_a3 0 179696.3391
Gr1_im_7_3 0 s7 x1_im_a3 0 194833.0434
Gr2_7_3 0 s7 x2_a3 0 0.3913044978
Gr3_re_7_3 0 s7 x3_re_a3 0 -12663.54835
Gr3_im_7_3 0 s7 x3_im_a3 0 76127.8446
Gr4_re_7_3 0 s7 x4_re_a3 0 21102.2183
Gr4_im_7_3 0 s7 x4_im_a3 0 -64582.38506
Gr5_re_7_3 0 s7 x5_re_a3 0 -307225.3636
Gr5_im_7_3 0 s7 x5_im_a3 0 333435.5705
Gr6_re_7_3 0 s7 x6_re_a3 0 203080.6316
Gr6_im_7_3 0 s7 x6_im_a3 0 -364598.2855
Gr7_re_7_3 0 s7 x7_re_a3 0 32964.89727
Gr7_im_7_3 0 s7 x7_im_a3 0 -145280.9129
Gr8_re_7_3 0 s7 x8_re_a3 0 45790.55438
Gr8_im_7_3 0 s7 x8_im_a3 0 14560.90436
Gr9_re_7_3 0 s7 x9_re_a3 0 -113567.6284
Gr9_im_7_3 0 s7 x9_im_a3 0 -203068.221
Gr10_re_7_3 0 s7 x10_re_a3 0 28406.44214
Gr10_im_7_3 0 s7 x10_im_a3 0 27538.593
Gr11_re_7_3 0 s7 x11_re_a3 0 20664.18651
Gr11_im_7_3 0 s7 x11_im_a3 0 -16113.25345
Gr12_re_7_3 0 s7 x12_re_a3 0 39923.15897
Gr12_im_7_3 0 s7 x12_im_a3 0 -6032.066789
Gd7_4 0 s7 p4 0 0.0006671250525
Fd7_4 0 s7 V4 0.03335625262
Gr1_re_7_4 0 s7 x1_re_a4 0 -157335.8089
Gr1_im_7_4 0 s7 x1_im_a4 0 -225515.1977
Gr2_7_4 0 s7 x2_a4 0 0.1500011416
Gr3_re_7_4 0 s7 x3_re_a4 0 83011.62672
Gr3_im_7_4 0 s7 x3_im_a4 0 -73094.19336
Gr4_re_7_4 0 s7 x4_re_a4 0 -74949.33739
Gr4_im_7_4 0 s7 x4_im_a4 0 -85880.44725
Gr5_re_7_4 0 s7 x5_re_a4 0 -83234.30073
Gr5_im_7_4 0 s7 x5_im_a4 0 110676.7844
Gr6_re_7_4 0 s7 x6_re_a4 0 31201.17539
Gr6_im_7_4 0 s7 x6_im_a4 0 79995.15808
Gr7_re_7_4 0 s7 x7_re_a4 0 -147088.3353
Gr7_im_7_4 0 s7 x7_im_a4 0 -245472.1795
Gr8_re_7_4 0 s7 x8_re_a4 0 27442.83687
Gr8_im_7_4 0 s7 x8_im_a4 0 -63802.09758
Gr9_re_7_4 0 s7 x9_re_a4 0 140618.2514
Gr9_im_7_4 0 s7 x9_im_a4 0 -30450.97935
Gr10_re_7_4 0 s7 x10_re_a4 0 35677.45997
Gr10_im_7_4 0 s7 x10_im_a4 0 -25811.68241
Gr11_re_7_4 0 s7 x11_re_a4 0 -18670.19047
Gr11_im_7_4 0 s7 x11_im_a4 0 -31624.27696
Gr12_re_7_4 0 s7 x12_re_a4 0 1198.315775
Gr12_im_7_4 0 s7 x12_im_a4 0 -33260.68841
Gd7_5 0 s7 p5 0 -0.0003313005548
Fd7_5 0 s7 V5 -0.01656502774
Gr1_re_7_5 0 s7 x1_re_a5 0 383905.0106
Gr1_im_7_5 0 s7 x1_im_a5 0 169696.2307
Gr2_7_5 0 s7 x2_a5 0 0.05066011732
Gr3_re_7_5 0 s7 x3_re_a5 0 82633.47167
Gr3_im_7_5 0 s7 x3_im_a5 0 -74572.36719
Gr4_re_7_5 0 s7 x4_re_a5 0 18411.99443
Gr4_im_7_5 0 s7 x4_im_a5 0 -149001.1146
Gr5_re_7_5 0 s7 x5_re_a5 0 -102947.1199
Gr5_im_7_5 0 s7 x5_im_a5 0 185643.2468
Gr6_re_7_5 0 s7 x6_re_a5 0 217948.7984
Gr6_im_7_5 0 s7 x6_im_a5 0 -200049.3373
Gr7_re_7_5 0 s7 x7_re_a5 0 -143383.5279
Gr7_im_7_5 0 s7 x7_im_a5 0 -185243.3464
Gr8_re_7_5 0 s7 x8_re_a5 0 41986.92009
Gr8_im_7_5 0 s7 x8_im_a5 0 -93675.82115
Gr9_re_7_5 0 s7 x9_re_a5 0 -271848.302
Gr9_im_7_5 0 s7 x9_im_a5 0 29421.74413
Gr10_re_7_5 0 s7 x10_re_a5 0 43616.54323
Gr10_im_7_5 0 s7 x10_im_a5 0 -21554.26825
Gr11_re_7_5 0 s7 x11_re_a5 0 -17952.96482
Gr11_im_7_5 0 s7 x11_im_a5 0 -5971.000252
Gr12_re_7_5 0 s7 x12_re_a5 0 -560.814859
Gr12_im_7_5 0 s7 x12_im_a5 0 -54767.8268
Gd7_6 0 s7 p6 0 -9.1444533e-05
Fd7_6 0 s7 V6 -0.00457222665
Gr1_re_7_6 0 s7 x1_re_a6 0 -420652.6945
Gr1_im_7_6 0 s7 x1_im_a6 0 -195538.6546
Gr2_7_6 0 s7 x2_a6 0 0.277271184
Gr3_re_7_6 0 s7 x3_re_a6 0 1460.929447
Gr3_im_7_6 0 s7 x3_im_a6 0 104332.753
Gr4_re_7_6 0 s7 x4_re_a6 0 100897.3848
Gr4_im_7_6 0 s7 x4_im_a6 0 -156043.0455
Gr5_re_7_6 0 s7 x5_re_a6 0 -117904.3671
Gr5_im_7_6 0 s7 x5_im_a6 0 282282.7757
Gr6_re_7_6 0 s7 x6_re_a6 0 -45454.07722
Gr6_im_7_6 0 s7 x6_im_a6 0 231312.6574
Gr7_re_7_6 0 s7 x7_re_a6 0 46723.94513
Gr7_im_7_6 0 s7 x7_im_a6 0 -176162.8425
Gr8_re_7_6 0 s7 x8_re_a6 0 54171.39564
Gr8_im_7_6 0 s7 x8_im_a6 0 25157.89841
Gr9_re_7_6 0 s7 x9_re_a6 0 237211.1985
Gr9_im_7_6 0 s7 x9_im_a6 0 -31728.36039
Gr10_re_7_6 0 s7 x10_re_a6 0 19015.03002
Gr10_im_7_6 0 s7 x10_im_a6 0 26466.65688
Gr11_re_7_6 0 s7 x11_re_a6 0 24166.93564
Gr11_im_7_6 0 s7 x11_im_a6 0 -29288.91579
Gr12_re_7_6 0 s7 x12_re_a6 0 39043.51633
Gr12_im_7_6 0 s7 x12_im_a6 0 12366.36049
Gd7_7 0 s7 p7 0 0.008520143696
Fd7_7 0 s7 V7 0.4260071848
Gr1_re_7_7 0 s7 x1_re_a7 0 -229055.2031
Gr1_im_7_7 0 s7 x1_im_a7 0 -141930.6039
Gr2_7_7 0 s7 x2_a7 0 -1.182663564
Gr3_re_7_7 0 s7 x3_re_a7 0 30225.40728
Gr3_im_7_7 0 s7 x3_im_a7 0 -16594.05202
Gr4_re_7_7 0 s7 x4_re_a7 0 -289291.2504
Gr4_im_7_7 0 s7 x4_im_a7 0 75268.80917
Gr5_re_7_7 0 s7 x5_re_a7 0 -8983.612246
Gr5_im_7_7 0 s7 x5_im_a7 0 -495607.8442
Gr6_re_7_7 0 s7 x6_re_a7 0 349003.3109
Gr6_im_7_7 0 s7 x6_im_a7 0 180666.9932
Gr7_re_7_7 0 s7 x7_re_a7 0 -43436.7305
Gr7_im_7_7 0 s7 x7_im_a7 0 132493.2433
Gr8_re_7_7 0 s7 x8_re_a7 0 93722.02348
Gr8_im_7_7 0 s7 x8_im_a7 0 -22803.39195
Gr9_re_7_7 0 s7 x9_re_a7 0 -17533.21398
Gr9_im_7_7 0 s7 x9_im_a7 0 -473527.0813
Gr10_re_7_7 0 s7 x10_re_a7 0 4884.615032
Gr10_im_7_7 0 s7 x10_im_a7 0 -23694.69724
Gr11_re_7_7 0 s7 x11_re_a7 0 -46922.45487
Gr11_im_7_7 0 s7 x11_im_a7 0 56238.43824
Gr12_re_7_7 0 s7 x12_re_a7 0 -20462.09283
Gr12_im_7_7 0 s7 x12_im_a7 0 -43577.83777
Cx1_re_a7 x1_re_a7 0 3.89287585e-12
Gx1_re_a7 0 x1_re_a7 p7 0 3.329744531e-08
Fx1_re_a7 0 x1_re_a7 V7 1.664872266e-06
Rp1_re_re_a7 0 x1_re_a7 1 noisy=0
Gp1_re_im_a7 0 x1_re_a7 x1_im_a7 0 6.237829681
Cx1_im_a7 x1_im_a7 0 3.89287585e-12
Gp1_im_re_a7 0 x1_im_a7 x1_re_a7 0 -6.237829681
Rp1_im_im_a7 0 x1_im_a7 1 noisy=0
Cx2_a7 x2_a7 0 1.818528442e-12
Gx2_a7 0 x2_a7 p7 0 0.02431304751
Fx2_a7 0 x2_a7 V7 1.215652375
Rp2_a7 0 x2_a7 1 noisy=0
Cx3_re_a7 x3_re_a7 0 1.3261597e-11
Gx3_re_a7 0 x3_re_a7 p7 0 1.936361294e-08
Fx3_re_a7 0 x3_re_a7 V7 9.681806471e-07
Rp3_re_re_a7 0 x3_re_a7 1 noisy=0
Gp3_re_im_a7 0 x3_re_a7 x3_im_a7 0 17.80378221
Cx3_im_a7 x3_im_a7 0 1.3261597e-11
Gp3_im_re_a7 0 x3_im_a7 x3_re_a7 0 -17.80378221
Rp3_im_im_a7 0 x3_im_a7 1 noisy=0
Cx4_re_a7 x4_re_a7 0 3.619491499e-12
Gx4_re_a7 0 x4_re_a7 p7 0 8.675043614e-08
Fx4_re_a7 0 x4_re_a7 V7 4.337521807e-06
Rp4_re_re_a7 0 x4_re_a7 1 noisy=0
Gp4_re_im_a7 0 x4_re_a7 x4_im_a7 0 1.759573164
Cx4_im_a7 x4_im_a7 0 3.619491499e-12
Gp4_im_re_a7 0 x4_im_a7 x4_re_a7 0 -1.759573164
Rp4_im_im_a7 0 x4_im_a7 1 noisy=0
Cx5_re_a7 x5_re_a7 0 2.551196837e-12
Gx5_re_a7 0 x5_re_a7 p7 0 1.006172397e-07
Fx5_re_a7 0 x5_re_a7 V7 5.030861987e-06
Rp5_re_re_a7 0 x5_re_a7 1 noisy=0
Gp5_re_im_a7 0 x5_re_a7 x5_im_a7 0 1.86425479
Cx5_im_a7 x5_im_a7 0 2.551196837e-12
Gp5_im_re_a7 0 x5_im_a7 x5_re_a7 0 -1.86425479
Rp5_im_im_a7 0 x5_im_a7 1 noisy=0
Cx6_re_a7 x6_re_a7 0 4.347339998e-12
Gx6_re_a7 0 x6_re_a7 p7 0 5.798370328e-08
Fx6_re_a7 0 x6_re_a7 V7 2.899185164e-06
Rp6_re_re_a7 0 x6_re_a7 1 noisy=0
Gp6_re_im_a7 0 x6_re_a7 x6_im_a7 0 5.043445659
Cx6_im_a7 x6_im_a7 0 4.347339998e-12
Gp6_im_re_a7 0 x6_im_a7 x6_re_a7 0 -5.043445659
Rp6_im_im_a7 0 x6_im_a7 1 noisy=0
Cx7_re_a7 x7_re_a7 0 8.303908788e-12
Gx7_re_a7 0 x7_re_a7 p7 0 4.656965249e-08
Fx7_re_a7 0 x7_re_a7 V7 2.328482625e-06
Rp7_re_re_a7 0 x7_re_a7 1 noisy=0
Gp7_re_im_a7 0 x7_re_a7 x7_im_a7 0 7.230551368
Cx7_im_a7 x7_im_a7 0 8.303908788e-12
Gp7_im_re_a7 0 x7_im_a7 x7_re_a7 0 -7.230551368
Rp7_im_im_a7 0 x7_im_a7 1 noisy=0
Cx8_re_a7 x8_re_a7 0 1.359672759e-11
Gx8_re_a7 0 x8_re_a7 p7 0 2.128382166e-08
Fx8_re_a7 0 x8_re_a7 V7 1.064191083e-06
Rp8_re_re_a7 0 x8_re_a7 1 noisy=0
Gp8_re_im_a7 0 x8_re_a7 x8_im_a7 0 15.68097665
Cx8_im_a7 x8_im_a7 0 1.359672759e-11
Gp8_im_re_a7 0 x8_im_a7 x8_re_a7 0 -15.68097665
Rp8_im_im_a7 0 x8_im_a7 1 noisy=0
Cx9_re_a7 x9_re_a7 0 6.291227666e-12
Gx9_re_a7 0 x9_re_a7 p7 0 5.947902069e-08
Fx9_re_a7 0 x9_re_a7 V7 2.973951034e-06
Rp9_re_re_a7 0 x9_re_a7 1 noisy=0
Gp9_re_im_a7 0 x9_re_a7 x9_im_a7 0 6.899132195
Cx9_im_a7 x9_im_a7 0 6.291227666e-12
Gp9_im_re_a7 0 x9_im_a7 x9_re_a7 0 -6.899132195
Rp9_im_im_a7 0 x9_im_a7 1 noisy=0
Cx10_re_a7 x10_re_a7 0 3.245362601e-11
Gx10_re_a7 0 x10_re_a7 p7 0 1.515391466e-08
Fx10_re_a7 0 x10_re_a7 V7 7.576957332e-07
Rp10_re_re_a7 0 x10_re_a7 1 noisy=0
Gp10_re_im_a7 0 x10_re_a7 x10_im_a7 0 30.09488123
Cx10_im_a7 x10_im_a7 0 3.245362601e-11
Gp10_im_re_a7 0 x10_im_a7 x10_re_a7 0 -30.09488123
Rp10_im_im_a7 0 x10_im_a7 1 noisy=0
Cx11_re_a7 x11_re_a7 0 2.341034518e-11
Gx11_re_a7 0 x11_re_a7 p7 0 1.136536028e-08
Fx11_re_a7 0 x11_re_a7 V7 5.68268014e-07
Rp11_re_re_a7 0 x11_re_a7 1 noisy=0
Gp11_re_im_a7 0 x11_re_a7 x11_im_a7 0 25.09850718
Cx11_im_a7 x11_im_a7 0 2.341034518e-11
Gp11_im_re_a7 0 x11_im_a7 x11_re_a7 0 -25.09850718
Rp11_im_im_a7 0 x11_im_a7 1 noisy=0
Cx12_re_a7 x12_re_a7 0 2.361018525e-11
Gx12_re_a7 0 x12_re_a7 p7 0 1.55337241e-08
Fx12_re_a7 0 x12_re_a7 V7 7.76686205e-07
Rp12_re_re_a7 0 x12_re_a7 1 noisy=0
Gp12_re_im_a7 0 x12_re_a7 x12_im_a7 0 23.41457436
Cx12_im_a7 x12_im_a7 0 2.361018525e-11
Gp12_im_re_a7 0 x12_im_a7 x12_re_a7 0 -23.41457436
Rp12_im_im_a7 0 x12_im_a7 1 noisy=0
Rnz_e1 nz_e1 0 0.25
Rnz_e2 nz_e2 0 0.25
Rnz_e3 nz_e3 0 0.25
Rnz_e4 nz_e4 0 0.25
Rnz_e5 nz_e5 0 0.25
Rnz_e6 nz_e6 0 0.25
Rnz_e7 nz_e7 0 0.25
Cnz_x1 nz_x1 0 6.162073372e-13
Gnz_a1_1 0 nz_x1 nz_x1 0 -0.1582910324
Gnz_a1_2 0 nz_x1 nz_x2 0 0.9873925
Gnz_k1_1 0 nz_x1 nz_e1 0 0.1448618333
Gnz_k1_2 0 nz_x1 nz_e2 0 3.925633041e-06
Gnz_k1_3 0 nz_x1 nz_e3 0 0.0004978236449
Gnz_k1_4 0 nz_x1 nz_e4 0 0.000409082521
Gnz_k1_5 0 nz_x1 nz_e5 0 0.0002724744315
Gnz_k1_6 0 nz_x1 nz_e6 0 6.392431846e-05
Gnz_k1_7 0 nz_x1 nz_e7 0 -0.0001389351713
Cnz_x2 nz_x2 0 6.162073372e-13
Gnz_a2_1 0 nz_x2 nz_x1 0 -0.9873925
Gnz_a2_2 0 nz_x2 nz_x2 0 -0.1582910324
Gnz_k2_1 0 nz_x2 nz_e1 0 -0.1286153601
Gnz_k2_2 0 nz_x2 nz_e2 0 6.088065374e-05
Gnz_k2_3 0 nz_x2 nz_e3 0 -0.0005382859192
Gnz_k2_4 0 nz_x2 nz_e4 0 0.000510593606
Gnz_k2_5 0 nz_x2 nz_e5 0 0.0004886649699
Gnz_k2_6 0 nz_x2 nz_e6 0 -0.001137781051
Gnz_k2_7 0 nz_x2 nz_e7 0 0.0002003083697
Cnz_x3 nz_x3 0 6.162073372e-13
Gnz_a3_3 0 nz_x3 nz_x3 0 -0.3388494362
Gnz_k3_1 0 nz_x3 nz_e1 0 0.2458831769
Gnz_k3_2 0 nz_x3 nz_e2 0 0.000140017064
Gnz_k3_3 0 nz_x3 nz_e3 0 0.001222563853
Gnz_k3_4 0 nz_x3 nz_e4 0 -0.001870635934
Gnz_k3_5 0 nz_x3 nz_e5 0 -0.001792589509
Gnz_k3_6 0 nz_x3 nz_e6 0 0.001112230849
Gnz_k3_7 0 nz_x3 nz_e7 0 -2.747328075e-05
Cnz_x4 nz_x4 0 6.162073372e-13
Gnz_a4_4 0 nz_x4 nz_x4 0 -0.04646554537
Gnz_a4_5 0 nz_x4 nz_x5 0 0.8272624502
Gnz_k4_1 0 nz_x4 nz_e1 0 0.02754373547
Gnz_k4_2 0 nz_x4 nz_e2 0 5.296672145e-06
Gnz_k4_3 0 nz_x4 nz_e3 0 0.0002141872579
Gnz_k4_4 0 nz_x4 nz_e4 0 1.307862744e-05
Gnz_k4_5 0 nz_x4 nz_e5 0 -3.957208265e-05
Gnz_k4_6 0 nz_x4 nz_e6 0 0.0002802370125
Gnz_k4_7 0 nz_x4 nz_e7 0 -3.689611017e-05
Cnz_x5 nz_x5 0 6.162073372e-13
Gnz_a5_4 0 nz_x5 nz_x4 0 -0.8272624502
Gnz_a5_5 0 nz_x5 nz_x5 0 -0.04646554537
Gnz_k5_1 0 nz_x5 nz_e1 0 0.01006562044
Gnz_k5_2 0 nz_x5 nz_e2 0 1.711289419e-05
Gnz_k5_3 0 nz_x5 nz_e3 0 0.0001853041263
Gnz_k5_4 0 nz_x5 nz_e4 0 -4.312505287e-05
Gnz_k5_5 0 nz_x5 nz_e5 0 -8.28934284e-05
Gnz_k5_6 0 nz_x5 nz_e6 0 3.157807418e-05
Gnz_k5_7 0 nz_x5 nz_e7 0 -3.289015353e-05
Cnz_x6 nz_x6 0 6.162073372e-13
Gnz_a6_6 0 nz_x6 nz_x6 0 -0.1702469359
Gnz_a6_7 0 nz_x6 nz_x7 0 0.2995619397
Gnz_k6_1 0 nz_x6 nz_e1 0 0.1496328755
Gnz_k6_2 0 nz_x6 nz_e2 0 -0.0001754692893
Gnz_k6_3 0 nz_x6 nz_e3 0 0.0005170035858
Gnz_k6_4 0 nz_x6 nz_e4 0 -0.0002414560358
Gnz_k6_5 0 nz_x6 nz_e5 0 -0.0001124427357
Gnz_k6_6 0 nz_x6 nz_e6 0 0.000433105273
Gnz_k6_7 0 nz_x6 nz_e7 0 -0.0001703154433
Cnz_x7 nz_x7 0 6.162073372e-13
Gnz_a7_6 0 nz_x7 nz_x6 0 -0.2995619397
Gnz_a7_7 0 nz_x7 nz_x7 0 -0.1702469359
Gnz_k7_1 0 nz_x7 nz_e1 0 0.08166605651
Gnz_k7_2 0 nz_x7 nz_e2 0 -1.956996912e-05
Gnz_k7_3 0 nz_x7 nz_e3 0 -0.0002612922904
Gnz_k7_4 0 nz_x7 nz_e4 0 -0.000374282814
Gnz_k7_5 0 nz_x7 nz_e5 0 0.0002518648516
Gnz_k7_6 0 nz_x7 nz_e6 0 0.0003122517406
Gnz_k7_7 0 nz_x7 nz_e7 0 2.319951222e-05
Cnz_x8 nz_x8 0 6.162073372e-13
Gnz_a8_8 0 nz_x8 nz_x8 0 -0.2415365715
Gnz_a8_9 0 nz_x8 nz_x9 0 0.4502857102
Gnz_k8_1 0 nz_x8 nz_e1 0 0.6257669562
Gnz_k8_2 0 nz_x8 nz_e2 0 -0.0003546035207
Gnz_k8_3 0 nz_x8 nz_e3 0 -0.000177760409
Gnz_k8_4 0 nz_x8 nz_e4 0 -0.001693549266
Gnz_k8_5 0 nz_x8 nz_e5 0 0.0003213821638
Gnz_k8_6 0 nz_x8 nz_e6 0 0.001975207734
Gnz_k8_7 0 nz_x8 nz_e7 0 -0.0001940445739
Cnz_x9 nz_x9 0 6.162073372e-13
Gnz_a9_8 0 nz_x9 nz_x8 0 -0.4502857102
Gnz_a9_9 0 nz_x9 nz_x9 0 -0.2415365715
Gnz_k9_1 0 nz_x9 nz_e1 0 -0.06806074656
Gnz_k9_2 0 nz_x9 nz_e2 0 0.0004104640781
Gnz_k9_3 0 nz_x9 nz_e3 0 -0.0007696499787
Gnz_k9_4 0 nz_x9 nz_e4 0 0.0007280310667
Gnz_k9_5 0 nz_x9 nz_e5 0 0.0004463418483
Gnz_k9_6 0 nz_x9 nz_e6 0 -0.0001218624143
Gnz_k9_7 0 nz_x9 nz_e7 0 0.0003235874638
Cnz_x10 nz_x10 0 6.162073372e-13
Gnz_a10_10 0 nz_x10 nz_x10 0 -0.1417435345
Gnz_a10_11 0 nz_x10 nz_x11 0 0.7148758139
Gnz_k10_1 0 nz_x10 nz_e1 0 0.5393800925
Gnz_k10_2 0 nz_x10 nz_e2 0 0.0002030839503
Gnz_k10_3 0 nz_x10 nz_e3 0 0.001841331005
Gnz_k10_4 0 nz_x10 nz_e4 0 0.001109942454
Gnz_k10_5 0 nz_x10 nz_e5 0 0.0001330512501
Gnz_k10_6 0 nz_x10 nz_e6 0 0.00371034404
Gnz_k10_7 0 nz_x10 nz_e7 0 -0.0002398452673
Cnz_x11 nz_x11 0 6.162073372e-13
Gnz_a11_10 0 nz_x11 nz_x10 0 -0.7148758139
Gnz_a11_11 0 nz_x11 nz_x11 0 -0.1417435345
Gnz_k11_1 0 nz_x11 nz_e1 0 -0.2203952015
Gnz_k11_2 0 nz_x11 nz_e2 0 0.0003994592013
Gnz_k11_3 0 nz_x11 nz_e3 0 0.002553233268
Gnz_k11_4 0 nz_x11 nz_e4 0 0.0009054556032
Gnz_k11_5 0 nz_x11 nz_e5 0 -0.00102421372
Gnz_k11_6 0 nz_x11 nz_e6 0 -0.0009568326481
Gnz_k11_7 0 nz_x11 nz_e7 0 -0.0002360828047
Cnz_x12 nz_x12 0 6.162073372e-13
Gnz_a12_12 0 nz_x12 nz_x12 0 -0.07420690098
Gnz_a12_13 0 nz_x12 nz_x13 0 0.5365568094
Gnz_k12_1 0 nz_x12 nz_e1 0 0.06427583977
Gnz_k12_2 0 nz_x12 nz_e2 0 0.000112284991
Gnz_k12_3 0 nz_x12 nz_e3 0 -0.0005375454734
Gnz_k12_4 0 nz_x12 nz_e4 0 0.0001500356502
Gnz_k12_5 0 nz_x12 nz_e5 0 0.0003036564651
Gnz_k12_6 0 nz_x12 nz_e6 0 0.0001238383074
Gnz_k12_7 0 nz_x12 nz_e7 0 0.0001449667196
Cnz_x13 nz_x13 0 6.162073372e-13
Gnz_a13_12 0 nz_x13 nz_x12 0 -0.5365568094
Gnz_a13_13 0 nz_x13 nz_x13 0 -0.07420690098
Gnz_k13_1 0 nz_x13 nz_e1 0 -0.0769492361
Gnz_k13_2 0 nz_x13 nz_e2 0 0.0001262012266
Gnz_k13_3 0 nz_x13 nz_e3 0 0.0006275640498
Gnz_k13_4 0 nz_x13 nz_e4 0 0.0008017241954
Gnz_k13_5 0 nz_x13 nz_e5 0 -6.95172537e-05
Gnz_k13_6 0 nz_x13 nz_e6 0 0.0001873670446
Gnz_k13_7 0 nz_x13 nz_e7 0 2.332485149e-05
Cnz_x14 nz_x14 0 6.162073372e-13
Gnz_a14_14 0 nz_x14 nz_x14 0 -0.04532026791
Gnz_a14_15 0 nz_x14 nz_x15 0 0.7106660628
Gnz_k14_1 0 nz_x14 nz_e1 0 0.04481648567
Gnz_k14_2 0 nz_x14 nz_e2 0 9.696330356e-06
Gnz_k14_3 0 nz_x14 nz_e3 0 0.0004600469197
Gnz_k14_4 0 nz_x14 nz_e4 0 -0.0002825772615
Gnz_k14_5 0 nz_x14 nz_e5 0 -0.001022541678
Gnz_k14_6 0 nz_x14 nz_e6 0 0.0005569639908
Gnz_k14_7 0 nz_x14 nz_e7 0 -0.0001913813825
Cnz_x15 nz_x15 0 6.162073372e-13
Gnz_a15_14 0 nz_x15 nz_x14 0 -0.7106660628
Gnz_a15_15 0 nz_x15 nz_x15 0 -0.04532026791
Gnz_k15_1 0 nz_x15 nz_e1 0 -0.05337871676
Gnz_k15_2 0 nz_x15 nz_e2 0 0.0002818943343
Gnz_k15_3 0 nz_x15 nz_e3 0 -0.0009981845442
Gnz_k15_4 0 nz_x15 nz_e4 0 5.466035758e-05
Gnz_k15_5 0 nz_x15 nz_e5 0 -9.551664857e-05
Gnz_k15_6 0 nz_x15 nz_e6 0 -0.002393087484
Gnz_k15_7 0 nz_x15 nz_e7 0 9.358545491e-05
Cnz_x16 nz_x16 0 6.162073372e-13
Gnz_a16_16 0 nz_x16 nz_x16 0 -0.09794707327
Gnz_a16_17 0 nz_x16 nz_x17 0 0.6757498066
Gnz_k16_1 0 nz_x16 nz_e1 0 0.30527743
Gnz_k16_2 0 nz_x16 nz_e2 0 0.0002427649422
Gnz_k16_3 0 nz_x16 nz_e3 0 0.001549945281
Gnz_k16_4 0 nz_x16 nz_e4 0 0.001695815783
Gnz_k16_5 0 nz_x16 nz_e5 0 0.000309399828
Gnz_k16_6 0 nz_x16 nz_e6 0 0.003222656862
Gnz_k16_7 0 nz_x16 nz_e7 0 -5.741155e-05
Cnz_x17 nz_x17 0 6.162073372e-13
Gnz_a17_16 0 nz_x17 nz_x16 0 -0.6757498066
Gnz_a17_17 0 nz_x17 nz_x17 0 -0.09794707327
Gnz_k17_1 0 nz_x17 nz_e1 0 -0.2359221998
Gnz_k17_2 0 nz_x17 nz_e2 0 0.0002036990661
Gnz_k17_3 0 nz_x17 nz_e3 0 0.002876913706
Gnz_k17_4 0 nz_x17 nz_e4 0 0.0006656016255
Gnz_k17_5 0 nz_x17 nz_e5 0 -0.001251047545
Gnz_k17_6 0 nz_x17 nz_e6 0 -0.0002662917963
Gnz_k17_7 0 nz_x17 nz_e7 0 -0.0003705775529
Cnz_x18 nz_x18 0 6.162073372e-13
Gnz_a18_18 0 nz_x18 nz_x18 0 -0.01898731862
Gnz_a18_19 0 nz_x18 nz_x19 0 0.5714210985
Gnz_k18_1 0 nz_x18 nz_e1 0 0.01079867531
Gnz_k18_2 0 nz_x18 nz_e2 0 -0.0004883568792
Gnz_k18_3 0 nz_x18 nz_e3 0 0.003835056358
Gnz_k18_4 0 nz_x18 nz_e4 0 0.00222296522
Gnz_k18_5 0 nz_x18 nz_e5 0 0.001139832871
Gnz_k18_6 0 nz_x18 nz_e6 0 0.004540371779
Gnz_k18_7 0 nz_x18 nz_e7 0 -4.658221495e-05
Cnz_x19 nz_x19 0 6.162073372e-13
Gnz_a19_18 0 nz_x19 nz_x18 0 -0.5714210985
Gnz_a19_19 0 nz_x19 nz_x19 0 -0.01898731862
Gnz_k19_1 0 nz_x19 nz_e1 0 -0.07476688864
Gnz_k19_2 0 nz_x19 nz_e2 0 -0.000740115963
Gnz_k19_3 0 nz_x19 nz_e3 0 0.002225999667
Gnz_k19_4 0 nz_x19 nz_e4 0 -0.001292752545
Gnz_k19_5 0 nz_x19 nz_e5 0 -0.002146944949
Gnz_k19_6 0 nz_x19 nz_e6 0 0.001289623796
Gnz_k19_7 0 nz_x19 nz_e7 0 -0.0009193432966
Cnz_x20 nz_x20 0 6.162073372e-13
Gnz_a20_20 0 nz_x20 nz_x20 0 -0.02632200988
Gnz_a20_21 0 nz_x20 nz_x21 0 0.660643154
Gnz_k20_1 0 nz_x20 nz_e1 0 0.02295991976
Gnz_k20_2 0 nz_x20 nz_e2 0 -0.0002627613618
Gnz_k20_3 0 nz_x20 nz_e3 0 0.004290032938
Gnz_k20_4 0 nz_x20 nz_e4 0 0.002655036724
Gnz_k20_5 0 nz_x20 nz_e5 0 0.001507044564
Gnz_k20_6 0 nz_x20 nz_e6 0 0.005097617424
Gnz_k20_7 0 nz_x20 nz_e7 0 -0.0001696874995
Cnz_x21 nz_x21 0 6.162073372e-13
Gnz_a21_20 0 nz_x21 nz_x20 0 -0.660643154
Gnz_a21_21 0 nz_x21 nz_x21 0 -0.02632200988
Gnz_k21_1 0 nz_x21 nz_e1 0 -0.07544711014
Gnz_k21_2 0 nz_x21 nz_e2 0 -0.0007641005513
Gnz_k21_3 0 nz_x21 nz_e3 0 0.004165825858
Gnz_k21_4 0 nz_x21 nz_e4 0 -0.002085389873
Gnz_k21_5 0 nz_x21 nz_e5 0 -0.002508664015
Gnz_k21_6 0 nz_x21 nz_e6 0 0.002845716163
Gnz_k21_7 0 nz_x21 nz_e7 0 -0.0009689659714
Cnz_x22 nz_x22 0 6.162073372e-13
Gnz_a22_22 0 nz_x22 nz_x22 0 -0.02609921654
Gnz_a22_23 0 nz_x22 nz_x23 0 0.6111020463
Gnz_k22_1 0 nz_x22 nz_e1 0 0.02823582304
Gnz_k22_2 0 nz_x22 nz_e2 0 0.0005193267602
Gnz_k22_3 0 nz_x22 nz_e3 0 -0.003754901185
Gnz_k22_4 0 nz_x22 nz_e4 0 -0.001680806397
Gnz_k22_5 0 nz_x22 nz_e5 0 -0.00204254618
Gnz_k22_6 0 nz_x22 nz_e6 0 -0.004127348666
Gnz_k22_7 0 nz_x22 nz_e7 0 -2.191237453e-05
Cnz_x23 nz_x23 0 6.162073372e-13
Gnz_a23_22 0 nz_x23 nz_x22 0 -0.6111020463
Gnz_a23_23 0 nz_x23 nz_x23 0 -0.02609921654
Gnz_k23_1 0 nz_x23 nz_e1 0 -0.0926529362
Gnz_k23_2 0 nz_x23 nz_e2 0 0.001150135108
Gnz_k23_3 0 nz_x23 nz_e3 0 -0.002935060427
Gnz_k23_4 0 nz_x23 nz_e4 0 0.002128184616
Gnz_k23_5 0 nz_x23 nz_e5 0 0.001619090613
Gnz_k23_6 0 nz_x23 nz_e6 0 -0.003717306521
Gnz_k23_7 0 nz_x23 nz_e7 0 0.0008552769214
Cnz_x24 nz_x24 0 6.162073372e-13
Gnz_a24_24 0 nz_x24 nz_x24 0 -0.1582910324
Gnz_a24_25 0 nz_x24 nz_x25 0 0.9873925
Gnz_k24_1 0 nz_x24 nz_e1 0 -2.038319152e-05
Gnz_k24_2 0 nz_x24 nz_e2 0 0.1496973796
Gnz_k24_3 0 nz_x24 nz_e3 0 0.03001863443
Gnz_k24_4 0 nz_x24 nz_e4 0 -0.089473745
Gnz_k24_5 0 nz_x24 nz_e5 0 0.05270549695
Gnz_k24_6 0 nz_x24 nz_e6 0 0.009677639003
Gnz_k24_7 0 nz_x24 nz_e7 0 0.094732337
Cnz_x25 nz_x25 0 6.162073372e-13
Gnz_a25_24 0 nz_x25 nz_x24 0 -0.9873925
Gnz_a25_25 0 nz_x25 nz_x25 0 -0.1582910324
Gnz_k25_1 0 nz_x25 nz_e1 0 -0.0003215850525
Gnz_k25_2 0 nz_x25 nz_e2 0 -0.1325424794
Gnz_k25_3 0 nz_x25 nz_e3 0 0.03685347845
Gnz_k25_4 0 nz_x25 nz_e4 0 0.001871281262
Gnz_k25_5 0 nz_x25 nz_e5 0 0.04658379942
Gnz_k25_6 0 nz_x25 nz_e6 0 -0.03212066011
Gnz_k25_7 0 nz_x25 nz_e7 0 -0.01238957659
Cnz_x26 nz_x26 0 6.162073372e-13
Gnz_a26_26 0 nz_x26 nz_x26 0 -0.3388494362
Gnz_k26_1 0 nz_x26 nz_e1 0 0.0001639156434
Gnz_k26_2 0 nz_x26 nz_e2 0 0.3622779288
Gnz_k26_3 0 nz_x26 nz_e3 0 -0.03494161431
Gnz_k26_4 0 nz_x26 nz_e4 0 -0.09076877415
Gnz_k26_5 0 nz_x26 nz_e5 0 -0.04414607552
Gnz_k26_6 0 nz_x26 nz_e6 0 -0.03328883786
Gnz_k26_7 0 nz_x26 nz_e7 0 -0.03010299748
Cnz_x27 nz_x27 0 6.162073372e-13
Gnz_a27_27 0 nz_x27 nz_x27 0 -0.04646554537
Gnz_a27_28 0 nz_x27 nz_x28 0 0.8272624502
Gnz_k27_1 0 nz_x27 nz_e1 0 9.977265771e-05
Gnz_k27_2 0 nz_x27 nz_e2 0 0.03083656005
Gnz_k27_3 0 nz_x27 nz_e3 0 -0.02735496206
Gnz_k27_4 0 nz_x27 nz_e4 0 -0.01288556575
Gnz_k27_5 0 nz_x27 nz_e5 0 -0.02750802475
Gnz_k27_6 0 nz_x27 nz_e6 0 0.03170606715
Gnz_k27_7 0 nz_x27 nz_e7 0 0.02818038549
Cnz_x28 nz_x28 0 6.162073372e-13
Gnz_a28_27 0 nz_x28 nz_x27 0 -0.8272624502
Gnz_a28_28 0 nz_x28 nz_x28 0 -0.04646554537
Gnz_k28_1 0 nz_x28 nz_e1 0 -6.485559041e-05
Gnz_k28_2 0 nz_x28 nz_e2 0 -0.01290008068
Gnz_k28_3 0 nz_x28 nz_e3 0 0.024129308
Gnz_k28_4 0 nz_x28 nz_e4 0 -0.03526237199
Gnz_k28_5 0 nz_x28 nz_e5 0 0.04336458931
Gnz_k28_6 0 nz_x28 nz_e6 0 -0.0008269131955
Gnz_k28_7 0 nz_x28 nz_e7 0 0.01041502411
Cnz_x29 nz_x29 0 6.162073372e-13
Gnz_a29_29 0 nz_x29 nz_x29 0 -0.1702469359
Gnz_a29_30 0 nz_x29 nz_x30 0 0.2995619397
Gnz_k29_1 0 nz_x29 nz_e1 0 -0.0006757497302
Gnz_k29_2 0 nz_x29 nz_e2 0 0.1986411875
Gnz_k29_3 0 nz_x29 nz_e3 0 0.06314924203
Gnz_k29_4 0 nz_x29 nz_e4 0 0.0187383733
Gnz_k29_5 0 nz_x29 nz_e5 0 0.06054659528
Gnz_k29_6 0 nz_x29 nz_e6 0 0.05211915118
Gnz_k29_7 0 nz_x29 nz_e7 0 -0.07330121212
Cnz_x30 nz_x30 0 6.162073372e-13
Gnz_a30_29 0 nz_x30 nz_x29 0 -0.2995619397
Gnz_a30_30 0 nz_x30 nz_x30 0 -0.1702469359
Gnz_k30_1 0 nz_x30 nz_e1 0 -0.0004925250116
Gnz_k30_2 0 nz_x30 nz_e2 0 -0.1783072889
Gnz_k30_3 0 nz_x30 nz_e3 0 0.05535102724
Gnz_k30_4 0 nz_x30 nz_e4 0 0.1300076179
Gnz_k30_5 0 nz_x30 nz_e5 0 0.07097399156
Gnz_k30_6 0 nz_x30 nz_e6 0 0.02452560075
Gnz_k30_7 0 nz_x30 nz_e7 0 0.05876801368
Cnz_x31 nz_x31 0 6.162073372e-13
Gnz_a31_31 0 nz_x31 nz_x31 0 -0.2415365715
Gnz_a31_32 0 nz_x31 nz_x32 0 0.4502857102
Gnz_k31_1 0 nz_x31 nz_e1 0 -0.0005798293655
Gnz_k31_2 0 nz_x31 nz_e2 0 0.3076777987
Gnz_k31_3 0 nz_x31 nz_e3 0 0.06365585914
Gnz_k31_4 0 nz_x31 nz_e4 0 0.09321498441
Gnz_k31_5 0 nz_x31 nz_e5 0 0.07705342663
Gnz_k31_6 0 nz_x31 nz_e6 0 0.004438173874
Gnz_k31_7 0 nz_x31 nz_e7 0 -0.008074158035
Cnz_x32 nz_x32 0 6.162073372e-13
Gnz_a32_31 0 nz_x32 nz_x31 0 -0.4502857102
Gnz_a32_32 0 nz_x32 nz_x32 0 -0.2415365715
Gnz_k32_1 0 nz_x32 nz_e1 0 0.0005784069586
Gnz_k32_2 0 nz_x32 nz_e2 0 -0.259247068
Gnz_k32_3 0 nz_x32 nz_e3 0 -0.03226844223
Gnz_k32_4 0 nz_x32 nz_e4 0 0.07739098605
Gnz_k32_5 0 nz_x32 nz_e5 0 -0.02533674871
Gnz_k32_6 0 nz_x32 nz_e6 0 -0.01638211204
Gnz_k32_7 0 nz_x32 nz_e7 0 0.1409153991
Cnz_x33 nz_x33 0 6.162073372e-13
Gnz_a33_33 0 nz_x33 nz_x33 0 -0.1417435345
Gnz_a33_34 0 nz_x33 nz_x34 0 0.7148758139
Gnz_k33_1 0 nz_x33 nz_e1 0 0.0007208778521
Gnz_k33_2 0 nz_x33 nz_e2 0 0.1527980006
Gnz_k33_3 0 nz_x33 nz_e3 0 -0.09189155287
Gnz_k33_4 0 nz_x33 nz_e4 0 0.03780602962
Gnz_k33_5 0 nz_x33 nz_e5 0 -0.1304494353
Gnz_k33_6 0 nz_x33 nz_e6 0 0.02767513725
Gnz_k33_7 0 nz_x33 nz_e7 0 0.1138074395
Cnz_x34 nz_x34 0 6.162073372e-13
Gnz_a34_33 0 nz_x34 nz_x33 0 -0.7148758139
Gnz_a34_34 0 nz_x34 nz_x34 0 -0.1417435345
Gnz_k34_1 0 nz_x34 nz_e1 0 3.41870686e-05
Gnz_k34_2 0 nz_x34 nz_e2 0 -0.1317037671
Gnz_k34_3 0 nz_x34 nz_e3 0 -0.03001654782
Gnz_k34_4 0 nz_x34 nz_e4 0 -0.1134912721
Gnz_k34_5 0 nz_x34 nz_e5 0 -0.02166156942
Gnz_k34_6 0 nz_x34 nz_e6 0 0.07606156927
Gnz_k34_7 0 nz_x34 nz_e7 0 0.0868179386
Cnz_x35 nz_x35 0 6.162073372e-13
Gnz_a35_35 0 nz_x35 nz_x35 0 -0.07420690098
Gnz_a35_36 0 nz_x35 nz_x36 0 0.5365568094
Gnz_k35_1 0 nz_x35 nz_e1 0 0.0002545040763
Gnz_k35_2 0 nz_x35 nz_e2 0 0.06456728322
Gnz_k35_3 0 nz_x35 nz_e3 0 0.01472310155
Gnz_k35_4 0 nz_x35 nz_e4 0 0.08115465361
Gnz_k35_5 0 nz_x35 nz_e5 0 0.0408576279
Gnz_k35_6 0 nz_x35 nz_e6 0 -0.06518820805
Gnz_k35_7 0 nz_x35 nz_e7 0 0.02960995483
Cnz_x36 nz_x36 0 6.162073372e-13
Gnz_a36_35 0 nz_x36 nz_x35 0 -0.5365568094
Gnz_a36_36 0 nz_x36 nz_x36 0 -0.07420690098
Gnz_k36_1 0 nz_x36 nz_e1 0 0.0008071996817
Gnz_k36_2 0 nz_x36 nz_e2 0 -0.0984958571
Gnz_k36_3 0 nz_x36 nz_e3 0 -0.0653360459
Gnz_k36_4 0 nz_x36 nz_e4 0 -0.007400280154
Gnz_k36_5 0 nz_x36 nz_e5 0 -0.09152404673
Gnz_k36_6 0 nz_x36 nz_e6 0 -0.0146011918
Gnz_k36_7 0 nz_x36 nz_e7 0 0.0774114956
Cnz_x37 nz_x37 0 6.162073372e-13
Gnz_a37_37 0 nz_x37 nz_x37 0 -0.04532026791
Gnz_a37_38 0 nz_x37 nz_x38 0 0.7106660628
Gnz_k37_1 0 nz_x37 nz_e1 0 0.0002104185283
Gnz_k37_2 0 nz_x37 nz_e2 0 0.01770702291
Gnz_k37_3 0 nz_x37 nz_e3 0 -0.03349635261
Gnz_k37_4 0 nz_x37 nz_e4 0 0.01320431777
Gnz_k37_5 0 nz_x37 nz_e5 0 -0.05396486037
Gnz_k37_6 0 nz_x37 nz_e6 0 0.009273975154
Gnz_k37_7 0 nz_x37 nz_e7 0 0.02163696613
Cnz_x38 nz_x38 0 6.162073372e-13
Gnz_a38_37 0 nz_x38 nz_x37 0 -0.7106660628
Gnz_a38_38 0 nz_x38 nz_x38 0 -0.04532026791
Gnz_k38_1 0 nz_x38 nz_e1 0 9.083305281e-06
Gnz_k38_2 0 nz_x38 nz_e2 0 -0.01165590598
Gnz_k38_3 0 nz_x38 nz_e3 0 -0.01340511712
Gnz_k38_4 0 nz_x38 nz_e4 0 -0.03200968545
Gnz_k38_5 0 nz_x38 nz_e5 0 -0.01178049163
Gnz_k38_6 0 nz_x38 nz_e6 0 0.03491731393
Gnz_k38_7 0 nz_x38 nz_e7 0 0.01785767299
Cnz_x39 nz_x39 0 6.162073372e-13
Gnz_a39_39 0 nz_x39 nz_x39 0 -0.09794707327
Gnz_a39_40 0 nz_x39 nz_x40 0 0.6757498066
Gnz_k39_1 0 nz_x39 nz_e1 0 0.000931159406
Gnz_k39_2 0 nz_x39 nz_e2 0 0.1081641357
Gnz_k39_3 0 nz_x39 nz_e3 0 -0.09775825662
Gnz_k39_4 0 nz_x39 nz_e4 0 0.0794036762
Gnz_k39_5 0 nz_x39 nz_e5 0 -0.1529527512
Gnz_k39_6 0 nz_x39 nz_e6 0 -0.01225844419
Gnz_k39_7 0 nz_x39 nz_e7 0 0.1030045856
Cnz_x40 nz_x40 0 6.162073372e-13
Gnz_a40_39 0 nz_x40 nz_x39 0 -0.6757498066
Gnz_a40_40 0 nz_x40 nz_x40 0 -0.09794707327
Gnz_k40_1 0 nz_x40 nz_e1 0 0.0001125473115
Gnz_k40_2 0 nz_x40 nz_e2 0 -0.117639762
Gnz_k40_3 0 nz_x40 nz_e3 0 -0.07874935118
Gnz_k40_4 0 nz_x40 nz_e4 0 -0.1166487077
Gnz_k40_5 0 nz_x40 nz_e5 0 -0.09893793247
Gnz_k40_6 0 nz_x40 nz_e6 0 0.1113312728
Gnz_k40_7 0 nz_x40 nz_e7 0 0.09830415579
Cnz_x41 nz_x41 0 6.162073372e-13
Gnz_a41_41 0 nz_x41 nz_x41 0 -0.01898731862
Gnz_a41_42 0 nz_x41 nz_x42 0 0.5714210985
Gnz_k41_1 0 nz_x41 nz_e1 0 -0.0002176867519
Gnz_k41_2 0 nz_x41 nz_e2 0 0.002925770791
Gnz_k41_3 0 nz_x41 nz_e3 0 0.0007633546372
Gnz_k41_4 0 nz_x41 nz_e4 0 0.01299321868
Gnz_k41_5 0 nz_x41 nz_e5 0 0.003016178579
Gnz_k41_6 0 nz_x41 nz_e6 0 -0.01494820833
Gnz_k41_7 0 nz_x41 nz_e7 0 0.007224973215
Cnz_x42 nz_x42 0 6.162073372e-13
Gnz_a42_41 0 nz_x42 nz_x41 0 -0.5714210985
Gnz_a42_42 0 nz_x42 nz_x42 0 -0.01898731862
Gnz_k42_1 0 nz_x42 nz_e1 0 5.525848376e-05
Gnz_k42_2 0 nz_x42 nz_e2 0 -0.01528464735
Gnz_k42_3 0 nz_x42 nz_e3 0 -0.01193285054
Gnz_k42_4 0 nz_x42 nz_e4 0 -0.00479330655
Gnz_k42_5 0 nz_x42 nz_e5 0 -0.02202144833
Gnz_k42_6 0 nz_x42 nz_e6 0 0.003946726374
Gnz_k42_7 0 nz_x42 nz_e7 0 0.009444347993
Cnz_x43 nz_x43 0 6.162073372e-13
Gnz_a43_43 0 nz_x43 nz_x43 0 -0.02632200988
Gnz_a43_44 0 nz_x43 nz_x44 0 0.660643154
Gnz_k43_1 0 nz_x43 nz_e1 0 -4.603384841e-05
Gnz_k43_2 0 nz_x43 nz_e2 0 0.001996380739
Gnz_k43_3 0 nz_x43 nz_e3 0 -0.009159869436
Gnz_k43_4 0 nz_x43 nz_e4 0 0.008368598763
Gnz_k43_5 0 nz_x43 nz_e5 0 -0.01692267836
Gnz_k43_6 0 nz_x43 nz_e6 0 -0.00468281958
Gnz_k43_7 0 nz_x43 nz_e7 0 0.007142711406
Cnz_x44 nz_x44 0 6.162073372e-13
Gnz_a44_43 0 nz_x44 nz_x43 0 -0.660643154
Gnz_a44_44 0 nz_x44 nz_x44 0 -0.02632200988
Gnz_k44_1 0 nz_x44 nz_e1 0 -0.0001307444181
Gnz_k44_2 0 nz_x44 nz_e2 0 -0.005561910913
Gnz_k44_3 0 nz_x44 nz_e3 0 -0.01091918161
Gnz_k44_4 0 nz_x44 nz_e4 0 -0.01021466362
Gnz_k44_5 0 nz_x44 nz_e5 0 -0.01576101384
Gnz_k44_6 0 nz_x44 nz_e6 0 0.01418873019
Gnz_k44_7 0 nz_x44 nz_e7 0 0.006782387046
Cnz_x45 nz_x45 0 6.162073372e-13
Gnz_a45_45 0 nz_x45 nz_x45 0 -0.02609921654
Gnz_a45_46 0 nz_x45 nz_x46 0 0.6111020463
Gnz_k45_1 0 nz_x45 nz_e1 0 0.0004302798359
Gnz_k45_2 0 nz_x45 nz_e2 0 0.001320837802
Gnz_k45_3 0 nz_x45 nz_e3 0 -0.003972802303
Gnz_k45_4 0 nz_x45 nz_e4 0 0.01330264088
Gnz_k45_5 0 nz_x45 nz_e5 0 -0.007638341084
Gnz_k45_6 0 nz_x45 nz_e6 0 -0.01345491746
Gnz_k45_7 0 nz_x45 nz_e7 0 0.008695706366
Cnz_x46 nz_x46 0 6.162073372e-13
Gnz_a46_45 0 nz_x46 nz_x45 0 -0.6111020463
Gnz_a46_46 0 nz_x46 nz_x46 0 -0.02609921654
Gnz_k46_1 0 nz_x46 nz_e1 0 0.0002777294952
Gnz_k46_2 0 nz_x46 nz_e2 0 -0.01309452587
Gnz_k46_3 0 nz_x46 nz_e3 0 -0.01507237275
Gnz_k46_4 0 nz_x46 nz_e4 0 -0.008879124438
Gnz_k46_5 0 nz_x46 nz_e5 0 -0.02561096951
Gnz_k46_6 0 nz_x46 nz_e6 0 0.01128504125
Gnz_k46_7 0 nz_x46 nz_e7 0 0.009408366506
Cnz_x47 nz_x47 0 6.162073372e-13
Gnz_a47_47 0 nz_x47 nz_x47 0 -0.1582910324
Gnz_a47_48 0 nz_x47 nz_x48 0 0.9873925
Gnz_k47_1 0 nz_x47 nz_e1 0 0.0005307480105
Gnz_k47_2 0 nz_x47 nz_e2 0 0.02454705514
Gnz_k47_3 0 nz_x47 nz_e3 0 0.1377207152
Gnz_k47_4 0 nz_x47 nz_e4 0 0.1996986127
Gnz_k47_5 0 nz_x47 nz_e5 0 0.01594804452
Gnz_k47_6 0 nz_x47 nz_e6 0 -0.0344376979
Gnz_k47_7 0 nz_x47 nz_e7 0 0.01828153978
Cnz_x48 nz_x48 0 6.162073372e-13
Gnz_a48_47 0 nz_x48 nz_x47 0 -0.9873925
Gnz_a48_48 0 nz_x48 nz_x48 0 -0.1582910324
Gnz_k48_1 0 nz_x48 nz_e1 0 0.001312735598
Gnz_k48_2 0 nz_x48 nz_e2 0 0.05522690607
Gnz_k48_3 0 nz_x48 nz_e3 0 -0.1214190767
Gnz_k48_4 0 nz_x48 nz_e4 0 -0.04142753005
Gnz_k48_5 0 nz_x48 nz_e5 0 -0.004430646347
Gnz_k48_6 0 nz_x48 nz_e6 0 0.02315743026
Gnz_k48_7 0 nz_x48 nz_e7 0 0.005600590436
Cnz_x49 nz_x49 0 6.162073372e-13
Gnz_a49_49 0 nz_x49 nz_x49 0 -0.3388494362
Gnz_k49_1 0 nz_x49 nz_e1 0 0.002251723587
Gnz_k49_2 0 nz_x49 nz_e2 0 -0.02153194956
Gnz_k49_3 0 nz_x49 nz_e3 0 0.3806930913
Gnz_k49_4 0 nz_x49 nz_e4 0 -0.2103157011
Gnz_k49_5 0 nz_x49 nz_e5 0 -0.03793141356
Gnz_k49_6 0 nz_x49 nz_e6 0 -0.002027522393
Gnz_k49_7 0 nz_x49 nz_e7 0 -0.01453554587
Cnz_x50 nz_x50 0 6.162073372e-13
Gnz_a50_50 0 nz_x50 nz_x50 0 -0.04646554537
Gnz_a50_51 0 nz_x50 nz_x51 0 0.8272624502
Gnz_k50_1 0 nz_x50 nz_e1 0 -0.0003283853628
Gnz_k50_2 0 nz_x50 nz_e2 0 -0.04728805655
Gnz_k50_3 0 nz_x50 nz_e3 0 0.04893349506
Gnz_k50_4 0 nz_x50 nz_e4 0 0.08152885954
Gnz_k50_5 0 nz_x50 nz_e5 0 0.003589258872
Gnz_k50_6 0 nz_x50 nz_e6 0 0.01597124603
Gnz_k50_7 0 nz_x50 nz_e7 0 0.01347885542
Cnz_x51 nz_x51 0 6.162073372e-13
Gnz_a51_50 0 nz_x51 nz_x50 0 -0.8272624502
Gnz_a51_51 0 nz_x51 nz_x51 0 -0.04646554537
Gnz_k51_1 0 nz_x51 nz_e1 0 0.0005054738702
Gnz_k51_2 0 nz_x51 nz_e2 0 0.03854297192
Gnz_k51_3 0 nz_x51 nz_e3 0 -0.007002280093
Gnz_k51_4 0 nz_x51 nz_e4 0 0.06417235767
Gnz_k51_5 0 nz_x51 nz_e5 0 -0.0006679117894
Gnz_k51_6 0 nz_x51 nz_e6 0 -0.01012319008
Gnz_k51_7 0 nz_x51 nz_e7 0 0.01457449318
Cnz_x52 nz_x52 0 6.162073372e-13
Gnz_a52_52 0 nz_x52 nz_x52 0 -0.1702469359
Gnz_a52_53 0 nz_x52 nz_x53 0 0.2995619397
Gnz_k52_1 0 nz_x52 nz_e1 0 -0.002629964211
Gnz_k52_2 0 nz_x52 nz_e2 0 0.06469609335
Gnz_k52_3 0 nz_x52 nz_e3 0 0.2165201312
Gnz_k52_4 0 nz_x52 nz_e4 0 -0.09667895856
Gnz_k52_5 0 nz_x52 nz_e5 0 0.04295496357
Gnz_k52_6 0 nz_x52 nz_e6 0 -0.01463950691
Gnz_k52_7 0 nz_x52 nz_e7 0 0.01905891465
Cnz_x53 nz_x53 0 6.162073372e-13
Gnz_a53_52 0 nz_x53 nz_x52 0 -0.2995619397
Gnz_a53_53 0 nz_x53 nz_x53 0 -0.1702469359
Gnz_k53_1 0 nz_x53 nz_e1 0 -0.001829703346
Gnz_k53_2 0 nz_x53 nz_e2 0 0.0381735821
Gnz_k53_3 0 nz_x53 nz_e3 0 -0.197716012
Gnz_k53_4 0 nz_x53 nz_e4 0 0.3135811727
Gnz_k53_5 0 nz_x53 nz_e5 0 0.01727450116
Gnz_k53_6 0 nz_x53 nz_e6 0 -0.01083365767
Gnz_k53_7 0 nz_x53 nz_e7 0 0.001761028416
Cnz_x54 nz_x54 0 6.162073372e-13
Gnz_a54_54 0 nz_x54 nz_x54 0 -0.2415365715
Gnz_a54_55 0 nz_x54 nz_x55 0 0.4502857102
Gnz_k54_1 0 nz_x54 nz_e1 0 -0.001775000951
Gnz_k54_2 0 nz_x54 nz_e2 0 0.04305081635
Gnz_k54_3 0 nz_x54 nz_e3 0 0.2458504017
Gnz_k54_4 0 nz_x54 nz_e4 0 0.06377667965
Gnz_k54_5 0 nz_x54 nz_e5 0 0.0151079779
Gnz_k54_6 0 nz_x54 nz_e6 0 -0.02792351587
Gnz_k54_7 0 nz_x54 nz_e7 0 -0.01263711592
Cnz_x55 nz_x55 0 6.162073372e-13
Gnz_a55_54 0 nz_x55 nz_x54 0 -0.4502857102
Gnz_a55_55 0 nz_x55 nz_x55 0 -0.2415365715
Gnz_k55_1 0 nz_x55 nz_e1 0 3.779163122e-05
Gnz_k55_2 0 nz_x55 nz_e2 0 -0.04356632476
Gnz_k55_3 0 nz_x55 nz_e3 0 -0.2277077217
Gnz_k55_4 0 nz_x55 nz_e4 0 0.2792947692
Gnz_k55_5 0 nz_x55 nz_e5 0 0.01120689045
Gnz_k55_6 0 nz_x55 nz_e6 0 0.009026079924
Gnz_k55_7 0 nz_x55 nz_e7 0 -0.01485976778
Cnz_x56 nz_x56 0 6.162073372e-13
Gnz_a56_56 0 nz_x56 nz_x56 0 -0.1417435345
Gnz_a56_57 0 nz_x56 nz_x57 0 0.7148758139
Gnz_k56_1 0 nz_x56 nz_e1 0 -0.0008863394061
Gnz_k56_2 0 nz_x56 nz_e2 0 -0.1392487295
Gnz_k56_3 0 nz_x56 nz_e3 0 0.1502346994
Gnz_k56_4 0 nz_x56 nz_e4 0 0.1685651669
Gnz_k56_5 0 nz_x56 nz_e5 0 0.02502214341
Gnz_k56_6 0 nz_x56 nz_e6 0 0.00613270927
Gnz_k56_7 0 nz_x56 nz_e7 0 -0.02883234473
Cnz_x57 nz_x57 0 6.162073372e-13
Gnz_a57_56 0 nz_x57 nz_x56 0 -0.7148758139
Gnz_a57_57 0 nz_x57 nz_x57 0 -0.1417435345
Gnz_k57_1 0 nz_x57 nz_e1 0 0.0009782093797
Gnz_k57_2 0 nz_x57 nz_e2 0 -0.03851765903
Gnz_k57_3 0 nz_x57 nz_e3 0 -0.1176542604
Gnz_k57_4 0 nz_x57 nz_e4 0 0.2073868557
Gnz_k57_5 0 nz_x57 nz_e5 0 0.009418442619
Gnz_k57_6 0 nz_x57 nz_e6 0 0.0378727827
Gnz_k57_7 0 nz_x57 nz_e7 0 0.06391900631
Cnz_x58 nz_x58 0 6.162073372e-13
Gnz_a58_58 0 nz_x58 nz_x58 0 -0.07420690098
Gnz_a58_59 0 nz_x58 nz_x59 0 0.5365568094
Gnz_k58_1 0 nz_x58 nz_e1 0 9.974039894e-05
Gnz_k58_2 0 nz_x58 nz_e2 0 0.0140115798
Gnz_k58_3 0 nz_x58 nz_e3 0 0.04027918084
Gnz_k58_4 0 nz_x58 nz_e4 0 0.1179658562
Gnz_k58_5 0 nz_x58 nz_e5 0 -0.007648362098
Gnz_k58_6 0 nz_x58 nz_e6 0 -0.02759365881
Gnz_k58_7 0 nz_x58 nz_e7 0 -0.04748573938
Cnz_x59 nz_x59 0 6.162073372e-13
Gnz_a59_58 0 nz_x59 nz_x58 0 -0.5365568094
Gnz_a59_59 0 nz_x59 nz_x59 0 -0.07420690098
Gnz_k59_1 0 nz_x59 nz_e1 0 0.001237896145
Gnz_k59_2 0 nz_x59 nz_e2 0 -0.09253914296
Gnz_k59_3 0 nz_x59 nz_e3 0 -0.1416353322
Gnz_k59_4 0 nz_x59 nz_e4 0 0.07226499609
Gnz_k59_5 0 nz_x59 nz_e5 0 0.02121516938
Gnz_k59_6 0 nz_x59 nz_e6 0 0.0136444633
Gnz_k59_7 0 nz_x59 nz_e7 0 -0.02868897382
Cnz_x60 nz_x60 0 6.162073372e-13
Gnz_a60_60 0 nz_x60 nz_x60 0 -0.04532026791
Gnz_a60_61 0 nz_x60 nz_x61 0 0.7106660628
Gnz_k60_1 0 nz_x60 nz_e1 0 -0.0005298758434
Gnz_k60_2 0 nz_x60 nz_e2 0 -0.08190983772
Gnz_k60_3 0 nz_x60 nz_e3 0 0.03105438668
Gnz_k60_4 0 nz_x60 nz_e4 0 0.007384511183
Gnz_k60_5 0 nz_x60 nz_e5 0 0.008199311977
Gnz_k60_6 0 nz_x60 nz_e6 0 0.0140116477
Gnz_k60_7 0 nz_x60 nz_e7 0 -0.01409186651
Cnz_x61 nz_x61 0 6.162073372e-13
Gnz_a61_60 0 nz_x61 nz_x60 0 -0.7106660628
Gnz_a61_61 0 nz_x61 nz_x61 0 -0.04532026791
Gnz_k61_1 0 nz_x61 nz_e1 0 -0.0006051537379
Gnz_k61_2 0 nz_x61 nz_e2 0 -0.03033969146
Gnz_k61_3 0 nz_x61 nz_e3 0 -0.008234809828
Gnz_k61_4 0 nz_x61 nz_e4 0 0.08823410817
Gnz_k61_5 0 nz_x61 nz_e5 0 -0.002188952575
Gnz_k61_6 0 nz_x61 nz_e6 0 0.02333760114
Gnz_k61_7 0 nz_x61 nz_e7 0 0.04278853687
Cnz_x62 nz_x62 0 6.162073372e-13
Gnz_a62_62 0 nz_x62 nz_x62 0 -0.09794707327
Gnz_a62_63 0 nz_x62 nz_x63 0 0.6757498066
Gnz_k62_1 0 nz_x62 nz_e1 0 -0.0004409482462
Gnz_k62_2 0 nz_x62 nz_e2 0 -0.1324571165
Gnz_k62_3 0 nz_x62 nz_e3 0 0.08101362271
Gnz_k62_4 0 nz_x62 nz_e4 0 0.08845026809
Gnz_k62_5 0 nz_x62 nz_e5 0 0.0269182015
Gnz_k62_6 0 nz_x62 nz_e6 0 0.0004699400939
Gnz_k62_7 0 nz_x62 nz_e7 0 -0.05629105469
Cnz_x63 nz_x63 0 6.162073372e-13
Gnz_a63_62 0 nz_x63 nz_x62 0 -0.6757498066
Gnz_a63_63 0 nz_x63 nz_x63 0 -0.09794707327
Gnz_k63_1 0 nz_x63 nz_e1 0 0.000687721894
Gnz_k63_2 0 nz_x63 nz_e2 0 -0.09436372152
Gnz_k63_3 0 nz_x63 nz_e3 0 -0.08721409503
Gnz_k63_4 0 nz_x63 nz_e4 0 0.1636104027
Gnz_k63_5 0 nz_x63 nz_e5 0 0.01044593111
Gnz_k63_6 0 nz_x63 nz_e6 0 0.05162342431
Gnz_k63_7 0 nz_x63 nz_e7 0 0.06368517987
Cnz_x64 nz_x64 0 6.162073372e-13
Gnz_a64_64 0 nz_x64 nz_x64 0 -0.01898731862
Gnz_a64_65 0 nz_x64 nz_x65 0 0.5714210985
Gnz_k64_1 0 nz_x64 nz_e1 0 0.001808278312
Gnz_k64_2 0 nz_x64 nz_e2 0 6.04782391e-05
Gnz_k64_3 0 nz_x64 nz_e3 0 -0.01150497108
Gnz_k64_4 0 nz_x64 nz_e4 0 0.02338894425
Gnz_k64_5 0 nz_x64 nz_e5 0 0.002485162721
Gnz_k64_6 0 nz_x64 nz_e6 0 -0.009260092798
Gnz_k64_7 0 nz_x64 nz_e7 0 -0.01927951404
Cnz_x65 nz_x65 0 6.162073372e-13
Gnz_a65_64 0 nz_x65 nz_x64 0 -0.5714210985
Gnz_a65_65 0 nz_x65 nz_x65 0 -0.01898731862
Gnz_k65_1 0 nz_x65 nz_e1 0 -0.0006157094329
Gnz_k65_2 0 nz_x65 nz_e2 0 -0.02744432741
Gnz_k65_3 0 nz_x65 nz_e3 0 -0.02812697323
Gnz_k65_4 0 nz_x65 nz_e4 0 -0.003994651892
Gnz_k65_5 0 nz_x65 nz_e5 0 0.01129005148
Gnz_k65_6 0 nz_x65 nz_e6 0 0.005476841791
Gnz_k65_7 0 nz_x65 nz_e7 0 -0.004546793668
Cnz_x66 nz_x66 0 6.162073372e-13
Gnz_a66_66 0 nz_x66 nz_x66 0 -0.02632200988
Gnz_a66_67 0 nz_x66 nz_x67 0 0.660643154
Gnz_k66_1 0 nz_x66 nz_e1 0 0.00163272886
Gnz_k66_2 0 nz_x66 nz_e2 0 -0.03344722165
Gnz_k66_3 0 nz_x66 nz_e3 0 -0.0003127372419
Gnz_k66_4 0 nz_x66 nz_e4 0 -0.009670227226
Gnz_k66_5 0 nz_x66 nz_e5 0 0.01061467854
Gnz_k66_6 0 nz_x66 nz_e6 0 -0.001593579965
Gnz_k66_7 0 nz_x66 nz_e7 0 -0.02139512194
Cnz_x67 nz_x67 0 6.162073372e-13
Gnz_a67_66 0 nz_x67 nz_x66 0 -0.660643154
Gnz_a67_67 0 nz_x67 nz_x67 0 -0.02632200988
Gnz_k67_1 0 nz_x67 nz_e1 0 0.0009241896071
Gnz_k67_2 0 nz_x67 nz_e2 0 -0.0361539779
Gnz_k67_3 0 nz_x67 nz_e3 0 -0.001543426501
Gnz_k67_4 0 nz_x67 nz_e4 0 0.01772039569
Gnz_k67_5 0 nz_x67 nz_e5 0 -0.0001908049741
Gnz_k67_6 0 nz_x67 nz_e6 0 0.01921623195
Gnz_k67_7 0 nz_x67 nz_e7 0 0.02009817486
Cnz_x68 nz_x68 0 6.162073372e-13
Gnz_a68_68 0 nz_x68 nz_x68 0 -0.02609921654
Gnz_a68_69 0 nz_x68 nz_x69 0 0.6111020463
Gnz_k68_1 0 nz_x68 nz_e1 0 -0.002315800537
Gnz_k68_2 0 nz_x68 nz_e2 0 -0.01393058679
Gnz_k68_3 0 nz_x68 nz_e3 0 -0.01428123679
Gnz_k68_4 0 nz_x68 nz_e4 0 0.01168144108
Gnz_k68_5 0 nz_x68 nz_e5 0 0.01060115997
Gnz_k68_6 0 nz_x68 nz_e6 0 -0.01019643789
Gnz_k68_7 0 nz_x68 nz_e7 0 -0.02881724534
Cnz_x69 nz_x69 0 6.162073372e-13
Gnz_a69_68 0 nz_x69 nz_x68 0 -0.6111020463
Gnz_a69_69 0 nz_x69 nz_x69 0 -0.02609921654
Gnz_k69_1 0 nz_x69 nz_e1 0 -0.0007118697406
Gnz_k69_2 0 nz_x69 nz_e2 0 -0.04225774789
Gnz_k69_3 0 nz_x69 nz_e3 0 -0.02029535889
Gnz_k69_4 0 nz_x69 nz_e4 0 -0.003640064678
Gnz_k69_5 0 nz_x69 nz_e5 0 0.009303645633
Gnz_k69_6 0 nz_x69 nz_e6 0 0.01365896025
Gnz_k69_7 0 nz_x69 nz_e7 0 0.006012928031
Cnz_x70 nz_x70 0 6.162073372e-13
Gnz_a70_70 0 nz_x70 nz_x70 0 -0.1582910324
Gnz_a70_71 0 nz_x70 nz_x71 0 0.9873925
Gnz_k70_1 0 nz_x70 nz_e1 0 0.0007113085285
Gnz_k70_2 0 nz_x70 nz_e2 0 -0.06389056965
Gnz_k70_3 0 nz_x70 nz_e3 0 0.1375601588
Gnz_k70_4 0 nz_x70 nz_e4 0 0.1770967065
Gnz_k70_5 0 nz_x70 nz_e5 0 0.02043182356
Gnz_k70_6 0 nz_x70 nz_e6 0 -0.006864602487
Gnz_k70_7 0 nz_x70 nz_e7 0 0.01694498603
Cnz_x71 nz_x71 0 6.162073372e-13
Gnz_a71_70 0 nz_x71 nz_x70 0 -0.9873925
Gnz_a71_71 0 nz_x71 nz_x71 0 -0.1582910324
Gnz_k71_1 0 nz_x71 nz_e1 0 0.0007783426987
Gnz_k71_2 0 nz_x71 nz_e2 0 -0.002376723448
Gnz_k71_3 0 nz_x71 nz_e3 0 -0.02402888308
Gnz_k71_4 0 nz_x71 nz_e4 0 -0.1127855627
Gnz_k71_5 0 nz_x71 nz_e5 0 0.02727926944
Gnz_k71_6 0 nz_x71 nz_e6 0 0.01098176766
Gnz_k71_7 0 nz_x71 nz_e7 0 0.02333552177
Cnz_x72 nz_x72 0 6.162073372e-13
Gnz_a72_72 0 nz_x72 nz_x72 0 -0.3388494362
Gnz_k72_1 0 nz_x72 nz_e1 0 -0.003404493099
Gnz_k72_2 0 nz_x72 nz_e2 0 -0.08190605162
Gnz_k72_3 0 nz_x72 nz_e3 0 -0.1501628909
Gnz_k72_4 0 nz_x72 nz_e4 0 0.407441915
Gnz_k72_5 0 nz_x72 nz_e5 0 0.02016198563
Gnz_k72_6 0 nz_x72 nz_e6 0 -0.003607183533
Gnz_k72_7 0 nz_x72 nz_e7 0 -0.03114045152
Cnz_x73 nz_x73 0 6.162073372e-13
Gnz_a73_73 0 nz_x73 nz_x73 0 -0.04646554537
Gnz_a73_74 0 nz_x73 nz_x74 0 0.8272624502
Gnz_k73_1 0 nz_x73 nz_e1 0 6.934717246e-05
Gnz_k73_2 0 nz_x73 nz_e2 0 -0.01470837706
Gnz_k73_3 0 nz_x73 nz_e3 0 0.08827587489
Gnz_k73_4 0 nz_x73 nz_e4 0 0.08538269075
Gnz_k73_5 0 nz_x73 nz_e5 0 -0.0358501333
Gnz_k73_6 0 nz_x73 nz_e6 0 -0.01789093323
Gnz_k73_7 0 nz_x73 nz_e7 0 -0.0256875106
Cnz_x74 nz_x74 0 6.162073372e-13
Gnz_a74_73 0 nz_x74 nz_x73 0 -0.8272624502
Gnz_a74_74 0 nz_x74 nz_x74 0 -0.04646554537
Gnz_k74_1 0 nz_x74 nz_e1 0 -2.44160216e-05
Gnz_k74_2 0 nz_x74 nz_e2 0 -0.06140055587
Gnz_k74_3 0 nz_x74 nz_e3 0 0.07008711729
Gnz_k74_4 0 nz_x74 nz_e4 0 0.04627845608
Gnz_k74_5 0 nz_x74 nz_e5 0 0.03357111865
Gnz_k74_6 0 nz_x74 nz_e6 0 -0.01362429891
Gnz_k74_7 0 nz_x74 nz_e7 0 0.03149421618
Cnz_x75 nz_x75 0 6.162073372e-13
Gnz_a75_75 0 nz_x75 nz_x75 0 -0.1702469359
Gnz_a75_76 0 nz_x75 nz_x76 0 0.2995619397
Gnz_k75_1 0 nz_x75 nz_e1 0 0.001503972982
Gnz_k75_2 0 nz_x75 nz_e2 0 0.008237089061
Gnz_k75_3 0 nz_x75 nz_e3 0 -0.07747440388
Gnz_k75_4 0 nz_x75 nz_e4 0 0.1901056579
Gnz_k75_5 0 nz_x75 nz_e5 0 -0.01217896262
Gnz_k75_6 0 nz_x75 nz_e6 0 0.02954114587
Gnz_k75_7 0 nz_x75 nz_e7 0 0.01010227774
Cnz_x76 nz_x76 0 6.162073372e-13
Gnz_a76_75 0 nz_x76 nz_x75 0 -0.2995619397
Gnz_a76_76 0 nz_x76 nz_x76 0 -0.1702469359
Gnz_k76_1 0 nz_x76 nz_e1 0 0.001399279836
Gnz_k76_2 0 nz_x76 nz_e2 0 0.1123147834
Gnz_k76_3 0 nz_x76 nz_e3 0 0.2251750759
Gnz_k76_4 0 nz_x76 nz_e4 0 -0.2824062423
Gnz_k76_5 0 nz_x76 nz_e5 0 -0.01683316054
Gnz_k76_6 0 nz_x76 nz_e6 0 -0.02500862737
Gnz_k76_7 0 nz_x76 nz_e7 0 0.04162868252
Cnz_x77 nz_x77 0 6.162073372e-13
Gnz_a77_77 0 nz_x77 nz_x77 0 -0.2415365715
Gnz_a77_78 0 nz_x77 nz_x78 0 0.4502857102
Gnz_k77_1 0 nz_x77 nz_e1 0 9.500483978e-05
Gnz_k77_2 0 nz_x77 nz_e2 0 0.07188089428
Gnz_k77_3 0 nz_x77 nz_e3 0 0.05674056633
Gnz_k77_4 0 nz_x77 nz_e4 0 0.1955213563
Gnz_k77_5 0 nz_x77 nz_e5 0 -0.02208476742
Gnz_k77_6 0 nz_x77 nz_e6 0 -0.009523685789
Gnz_k77_7 0 nz_x77 nz_e7 0 0.02757976612
Cnz_x78 nz_x78 0 6.162073372e-13
Gnz_a78_77 0 nz_x78 nz_x77 0 -0.4502857102
Gnz_a78_78 0 nz_x78 nz_x78 0 -0.2415365715
Gnz_k78_1 0 nz_x78 nz_e1 0 0.001086917897
Gnz_k78_2 0 nz_x78 nz_e2 0 0.07774480381
Gnz_k78_3 0 nz_x78 nz_e3 0 0.2542886962
Gnz_k78_4 0 nz_x78 nz_e4 0 -0.317005523
Gnz_k78_5 0 nz_x78 nz_e5 0 -0.01112522915
Gnz_k78_6 0 nz_x78 nz_e6 0 -0.02144695555
Gnz_k78_7 0 nz_x78 nz_e7 0 0.01546504049
Cnz_x79 nz_x79 0 6.162073372e-13
Gnz_a79_79 0 nz_x79 nz_x79 0 -0.1417435345
Gnz_a79_80 0 nz_x79 nz_x80 0 0.7148758139
Gnz_k79_1 0 nz_x79 nz_e1 0 0.0003380042066
Gnz_k79_2 0 nz_x79 nz_e2 0 0.07415598304
Gnz_k79_3 0 nz_x79 nz_e3 0 0.174807496
Gnz_k79_4 0 nz_x79 nz_e4 0 0.1838269118
Gnz_k79_5 0 nz_x79 nz_e5 0 -0.05997610198
Gnz_k79_6 0 nz_x79 nz_e6 0 0.005286101723
Gnz_k79_7 0 nz_x79 nz_e7 0 -0.07204212953
Cnz_x80 nz_x80 0 6.162073372e-13
Gnz_a80_79 0 nz_x80 nz_x79 0 -0.7148758139
Gnz_a80_80 0 nz_x80 nz_x80 0 -0.1417435345
Gnz_k80_1 0 nz_x80 nz_e1 0 0.0007453997951
Gnz_k80_2 0 nz_x80 nz_e2 0 -0.1386987375
Gnz_k80_3 0 nz_x80 nz_e3 0 0.2312947031
Gnz_k80_4 0 nz_x80 nz_e4 0 -0.02336879511
Gnz_k80_5 0 nz_x80 nz_e5 0 0.005122354314
Gnz_k80_6 0 nz_x80 nz_e6 0 -0.01843390392
Gnz_k80_7 0 nz_x80 nz_e7 0 -0.01870025774
Cnz_x81 nz_x81 0 6.162073372e-13
Gnz_a81_81 0 nz_x81 nz_x81 0 -0.07420690098
Gnz_a81_82 0 nz_x81 nz_x82 0 0.5365568094
Gnz_k81_1 0 nz_x81 nz_e1 0 0.0003159306138
Gnz_k81_2 0 nz_x81 nz_e2 0 0.1016453244
Gnz_k81_3 0 nz_x81 nz_e3 0 0.1090314262
Gnz_k81_4 0 nz_x81 nz_e4 0 -0.06162747496
Gnz_k81_5 0 nz_x81 nz_e5 0 -0.01426150257
Gnz_k81_6 0 nz_x81 nz_e6 0 -0.04169301399
Gnz_k81_7 0 nz_x81 nz_e7 0 0.04439440116
Cnz_x82 nz_x82 0 6.162073372e-13
Gnz_a82_81 0 nz_x82 nz_x81 0 -0.5365568094
Gnz_a82_82 0 nz_x82 nz_x82 0 -0.07420690098
Gnz_k82_1 0 nz_x82 nz_e1 0 0.0002012843073
Gnz_k82_2 0 nz_x82 nz_e2 0 0.004767474717
Gnz_k82_3 0 nz_x82 nz_e3 0 0.05870097595
Gnz_k82_4 0 nz_x82 nz_e4 0 -0.09863814378
Gnz_k82_5 0 nz_x82 nz_e5 0 0.01496187975
Gnz_k82_6 0 nz_x82 nz_e6 0 0.03054021871
Gnz_k82_7 0 nz_x82 nz_e7 0 -0.03435572228
Cnz_x83 nz_x83 0 6.162073372e-13
Gnz_a83_83 0 nz_x83 nz_x83 0 -0.04532026791
Gnz_a83_84 0 nz_x83 nz_x84 0 0.7106660628
Gnz_k83_1 0 nz_x83 nz_e1 0 -0.0006946149467
Gnz_k83_2 0 nz_x83 nz_e2 0 0.04580173197
Gnz_k83_3 0 nz_x83 nz_e3 0 0.003131941638
Gnz_k83_4 0 nz_x83 nz_e4 0 0.0156416397
Gnz_k83_5 0 nz_x83 nz_e5 0 -0.032229044
Gnz_k83_6 0 nz_x83 nz_e6 0 0.01663342079
Gnz_k83_7 0 nz_x83 nz_e7 0 -0.05775987338
Cnz_x84 nz_x84 0 6.162073372e-13
Gnz_a84_83 0 nz_x84 nz_x83 0 -0.7106660628
Gnz_a84_84 0 nz_x84 nz_x84 0 -0.04532026791
Gnz_k84_1 0 nz_x84 nz_e1 0 0.0003747349623
Gnz_k84_2 0 nz_x84 nz_e2 0 -0.0691504141
Gnz_k84_3 0 nz_x84 nz_e3 0 0.1000059224
Gnz_k84_4 0 nz_x84 nz_e4 0 0.04284313328
Gnz_k84_5 0 nz_x84 nz_e5 0 -0.02720465381
Gnz_k84_6 0 nz_x84 nz_e6 0 -0.02850102965
Gnz_k84_7 0 nz_x84 nz_e7 0 -0.02264747677
Cnz_x85 nz_x85 0 6.162073372e-13
Gnz_a85_85 0 nz_x85 nz_x85 0 -0.09794707327
Gnz_a85_86 0 nz_x85 nz_x86 0 0.6757498066
Gnz_k85_1 0 nz_x85 nz_e1 0 0.0006672046992
Gnz_k85_2 0 nz_x85 nz_e2 0 0.131004804
Gnz_k85_3 0 nz_x85 nz_e3 0 0.0936698749
Gnz_k85_4 0 nz_x85 nz_e4 0 0.06947211879
Gnz_k85_5 0 nz_x85 nz_e5 0 -0.04149590764
Gnz_k85_6 0 nz_x85 nz_e6 0 0.03849530114
Gnz_k85_7 0 nz_x85 nz_e7 0 -0.07528470134
Cnz_x86 nz_x86 0 6.162073372e-13
Gnz_a86_85 0 nz_x86 nz_x85 0 -0.6757498066
Gnz_a86_86 0 nz_x86 nz_x86 0 -0.09794707327
Gnz_k86_1 0 nz_x86 nz_e1 0 0.0004668142753
Gnz_k86_2 0 nz_x86 nz_e2 0 -0.1324199025
Gnz_k86_3 0 nz_x86 nz_e3 0 0.2007112069
Gnz_k86_4 0 nz_x86 nz_e4 0 0.004949247093
Gnz_k86_5 0 nz_x86 nz_e5 0 -0.02924041619
Gnz_k86_6 0 nz_x86 nz_e6 0 -0.008368650222
Gnz_k86_7 0 nz_x86 nz_e7 0 -0.07432238846
Cnz_x87 nz_x87 0 6.162073372e-13
Gnz_a87_87 0 nz_x87 nz_x87 0 -0.01898731862
Gnz_a87_88 0 nz_x87 nz_x88 0 0.5714210985
Gnz_k87_1 0 nz_x87 nz_e1 0 -0.0004098624475
Gnz_k87_2 0 nz_x87 nz_e2 0 0.02622478663
Gnz_k87_3 0 nz_x87 nz_e3 0 0.01822385066
Gnz_k87_4 0 nz_x87 nz_e4 0 -0.02214964807
Gnz_k87_5 0 nz_x87 nz_e5 0 0.005309660903
Gnz_k87_6 0 nz_x87 nz_e6 0 -0.003897361908
Gnz_k87_7 0 nz_x87 nz_e7 0 0.01334494719
Cnz_x88 nz_x88 0 6.162073372e-13
Gnz_a88_87 0 nz_x88 nz_x87 0 -0.5714210985
Gnz_a88_88 0 nz_x88 nz_x88 0 -0.01898731862
Gnz_k88_1 0 nz_x88 nz_e1 0 -0.00235415994
Gnz_k88_2 0 nz_x88 nz_e2 0 -0.005232237894
Gnz_k88_3 0 nz_x88 nz_e3 0 -0.005094421417
Gnz_k88_4 0 nz_x88 nz_e4 0 5.151006927e-05
Gnz_k88_5 0 nz_x88 nz_e5 0 0.00846629064
Gnz_k88_6 0 nz_x88 nz_e6 0 0.02553643647
Gnz_k88_7 0 nz_x88 nz_e7 0 -0.01850764545
Cnz_x89 nz_x89 0 6.162073372e-13
Gnz_a89_89 0 nz_x89 nz_x89 0 -0.02632200988
Gnz_a89_90 0 nz_x89 nz_x90 0 0.660643154
Gnz_k89_1 0 nz_x89 nz_e1 0 0.001779231937
Gnz_k89_2 0 nz_x89 nz_e2 0 0.03572468817
Gnz_k89_3 0 nz_x89 nz_e3 0 -0.01225602535
Gnz_k89_4 0 nz_x89 nz_e4 0 -0.006188145562
Gnz_k89_5 0 nz_x89 nz_e5 0 0.003471646318
Gnz_k89_6 0 nz_x89 nz_e6 0 0.03033035271
Gnz_k89_7 0 nz_x89 nz_e7 0 -0.02205848306
Cnz_x90 nz_x90 0 6.162073372e-13
Gnz_a90_89 0 nz_x90 nz_x89 0 -0.660643154
Gnz_a90_90 0 nz_x90 nz_x90 0 -0.02632200988
Gnz_k90_1 0 nz_x90 nz_e1 0 -0.002459259785
Gnz_k90_2 0 nz_x90 nz_e2 0 -0.02778490424
Gnz_k90_3 0 nz_x90 nz_e3 0 0.02228870717
Gnz_k90_4 0 nz_x90 nz_e4 0 0.0108427454
Gnz_k90_5 0 nz_x90 nz_e5 0 -0.02048989803
Gnz_k90_6 0 nz_x90 nz_e6 0 -0.002139783056
Gnz_k90_7 0 nz_x90 nz_e7 0 -0.03422713519
Cnz_x91 nz_x91 0 6.162073372e-13
Gnz_a91_91 0 nz_x91 nz_x91 0 -0.02609921654
Gnz_a91_92 0 nz_x91 nz_x92 0 0.6111020463
Gnz_k91_1 0 nz_x91 nz_e1 0 -0.001666183983
Gnz_k91_2 0 nz_x91 nz_e2 0 0.03919259915
Gnz_k91_3 0 nz_x91 nz_e3 0 0.00717364127
Gnz_k91_4 0 nz_x91 nz_e4 0 -0.01640072655
Gnz_k91_5 0 nz_x91 nz_e5 0 0.01331902143
Gnz_k91_6 0 nz_x91 nz_e6 0 0.01925188488
Gnz_k91_7 0 nz_x91 nz_e7 0 0.003432830152
Cnz_x92 nz_x92 0 6.162073372e-13
Gnz_a92_91 0 nz_x92 nz_x91 0 -0.6111020463
Gnz_a92_92 0 nz_x92 nz_x92 0 -0.02609921654
Gnz_k92_1 0 nz_x92 nz_e1 0 0.00373283645
Gnz_k92_2 0 nz_x92 nz_e2 0 -0.01606833142
Gnz_k92_3 0 nz_x92 nz_e3 0 -0.001745055722
Gnz_k92_4 0 nz_x92 nz_e4 0 0.006212636503
Gnz_k92_5 0 nz_x92 nz_e5 0 -0.001522619151
Gnz_k92_6 0 nz_x92 nz_e6 0 0.02740355099
Gnz_k92_7 0 nz_x92 nz_e7 0 -0.03752256281
Cnz_x93 nz_x93 0 6.162073372e-13
Gnz_a93_93 0 nz_x93 nz_x93 0 -0.1582910324
Gnz_a93_94 0 nz_x93 nz_x94 0 0.9873925
Gnz_k93_1 0 nz_x93 nz_e1 0 0.0002020353494
Gnz_k93_2 0 nz_x93 nz_e2 0 0.05414862387
Gnz_k93_3 0 nz_x93 nz_e3 0 -0.002066454279
Gnz_k93_4 0 nz_x93 nz_e4 0 0.02490750379
Gnz_k93_5 0 nz_x93 nz_e5 0 0.1681100929
Gnz_k93_6 0 nz_x93 nz_e6 0 0.1516993979
Gnz_k93_7 0 nz_x93 nz_e7 0 -0.02809002952
Cnz_x94 nz_x94 0 6.162073372e-13
Gnz_a94_93 0 nz_x94 nz_x93 0 -0.9873925
Gnz_a94_94 0 nz_x94 nz_x94 0 -0.1582910324
Gnz_k94_1 0 nz_x94 nz_e1 0 0.0006093594903
Gnz_k94_2 0 nz_x94 nz_e2 0 0.04670111565
Gnz_k94_3 0 nz_x94 nz_e3 0 -0.0004588873163
Gnz_k94_4 0 nz_x94 nz_e4 0 0.03969039076
Gnz_k94_5 0 nz_x94 nz_e5 0 -0.1142552366
Gnz_k94_6 0 nz_x94 nz_e6 0 -0.01982540744
Gnz_k94_7 0 nz_x94 nz_e7 0 0.003473700748
Cnz_x95 nz_x95 0 6.162073372e-13
Gnz_a95_95 0 nz_x95 nz_x95 0 -0.3388494362
Gnz_k95_1 0 nz_x95 nz_e1 0 -0.002719803632
Gnz_k95_2 0 nz_x95 nz_e2 0 -0.06356454803
Gnz_k95_3 0 nz_x95 nz_e3 0 0.005966075738
Gnz_k95_4 0 nz_x95 nz_e4 0 0.002781858198
Gnz_k95_5 0 nz_x95 nz_e5 0 0.424932232
Gnz_k95_6 0 nz_x95 nz_e6 0 -0.1522182826
Gnz_k95_7 0 nz_x95 nz_e7 0 -0.0375108138
Cnz_x96 nz_x96 0 6.162073372e-13
Gnz_a96_96 0 nz_x96 nz_x96 0 -0.04646554537
Gnz_a96_97 0 nz_x96 nz_x97 0 0.8272624502
Gnz_k96_1 0 nz_x96 nz_e1 0 -0.0004032834792
Gnz_k96_2 0 nz_x96 nz_e2 0 -0.04918629275
Gnz_k96_3 0 nz_x96 nz_e3 0 -0.0007725187953
Gnz_k96_4 0 nz_x96 nz_e4 0 -0.04169191931
Gnz_k96_5 0 nz_x96 nz_e5 0 0.08953039995
Gnz_k96_6 0 nz_x96 nz_e6 0 0.07028408735
Gnz_k96_7 0 nz_x96 nz_e7 0 -0.02238530373
Cnz_x97 nz_x97 0 6.162073372e-13
Gnz_a97_96 0 nz_x97 nz_x96 0 -0.8272624502
Gnz_a97_97 0 nz_x97 nz_x97 0 -0.04646554537
Gnz_k97_1 0 nz_x97 nz_e1 0 -0.0006697654521
Gnz_k97_2 0 nz_x97 nz_e2 0 0.08224312805
Gnz_k97_3 0 nz_x97 nz_e3 0 -0.01763329732
Gnz_k97_4 0 nz_x97 nz_e4 0 0.04052212052
Gnz_k97_5 0 nz_x97 nz_e5 0 0.02175375422
Gnz_k97_6 0 nz_x97 nz_e6 0 0.06582335979
Gnz_k97_7 0 nz_x97 nz_e7 0 -0.02610337681
Cnz_x98 nz_x98 0 6.162073372e-13
Gnz_a98_98 0 nz_x98 nz_x98 0 -0.1702469359
Gnz_a98_99 0 nz_x98 nz_x99 0 0.2995619397
Gnz_k98_1 0 nz_x98 nz_e1 0 0.002352083719
Gnz_k98_2 0 nz_x98 nz_e2 0 0.03901739993
Gnz_k98_3 0 nz_x98 nz_e3 0 0.04498780272
Gnz_k98_4 0 nz_x98 nz_e4 0 -0.01150073214
Gnz_k98_5 0 nz_x98 nz_e5 0 0.2025799125
Gnz_k98_6 0 nz_x98 nz_e6 0 -0.06181463903
Gnz_k98_7 0 nz_x98 nz_e7 0 -0.006113682101
Cnz_x99 nz_x99 0 6.162073372e-13
Gnz_a99_98 0 nz_x99 nz_x98 0 -0.2995619397
Gnz_a99_99 0 nz_x99 nz_x99 0 -0.1702469359
Gnz_k99_1 0 nz_x99 nz_e1 0 0.001825767958
Gnz_k99_2 0 nz_x99 nz_e2 0 0.08166072525
Gnz_k99_3 0 nz_x99 nz_e3 0 -0.02975876643
Gnz_k99_4 0 nz_x99 nz_e4 0 0.0008719616581
Gnz_k99_5 0 nz_x99 nz_e5 0 -0.274962567
Gnz_k99_6 0 nz_x99 nz_e6 0 0.2154830294
Gnz_k99_7 0 nz_x99 nz_e7 0 0.0530859196
Cnz_x100 nz_x100 0 6.162073372e-13
Gnz_a100_100 0 nz_x100 nz_x100 0 -0.2415365715
Gnz_a100_101 0 nz_x100 nz_x101 0 0.4502857102
Gnz_k100_1 0 nz_x100 nz_e1 0 0.001527677499
Gnz_k100_2 0 nz_x100 nz_e2 0 0.05476653106
Gnz_k100_3 0 nz_x100 nz_e3 0 0.003044645278
Gnz_k100_4 0 nz_x100 nz_e4 0 -0.01818210824
Gnz_k100_5 0 nz_x100 nz_e5 0 0.1936941431
Gnz_k100_6 0 nz_x100 nz_e6 0 0.05841843321
Gnz_k100_7 0 nz_x100 nz_e7 0 0.03485592258
Cnz_x101 nz_x101 0 6.162073372e-13
Gnz_a101_100 0 nz_x101 nz_x100 0 -0.4502857102
Gnz_a101_101 0 nz_x101 nz_x101 0 -0.2415365715
Gnz_k101_1 0 nz_x101 nz_e1 0 -0.0002333535439
Gnz_k101_2 0 nz_x101 nz_e2 0 0.007487933736
Gnz_k101_3 0 nz_x101 nz_e3 0 -0.03701313596
Gnz_k101_4 0 nz_x101 nz_e4 0 0.002276287401
Gnz_k101_5 0 nz_x101 nz_e5 0 -0.3215995553
Gnz_k101_6 0 nz_x101 nz_e6 0 0.2337697026
Gnz_k101_7 0 nz_x101 nz_e7 0 0.04246759937
Cnz_x102 nz_x102 0 6.162073372e-13
Gnz_a102_102 0 nz_x102 nz_x102 0 -0.1417435345
Gnz_a102_103 0 nz_x102 nz_x103 0 0.7148758139
Gnz_k102_1 0 nz_x102 nz_e1 0 0.0002673274403
Gnz_k102_2 0 nz_x102 nz_e2 0 -0.1777144078
Gnz_k102_3 0 nz_x102 nz_e3 0 0.01360161073
Gnz_k102_4 0 nz_x102 nz_e4 0 -0.0761212535
Gnz_k102_5 0 nz_x102 nz_e5 0 0.1886636384
Gnz_k102_6 0 nz_x102 nz_e6 0 0.1904549118
Gnz_k102_7 0 nz_x102 nz_e7 0 0.02899748853
Cnz_x103 nz_x103 0 6.162073372e-13
Gnz_a103_102 0 nz_x103 nz_x102 0 -0.7148758139
Gnz_a103_103 0 nz_x103 nz_x103 0 -0.1417435345
Gnz_k103_1 0 nz_x103 nz_e1 0 -0.001383719504
Gnz_k103_2 0 nz_x103 nz_e2 0 0.00120428188
Gnz_k103_3 0 nz_x103 nz_e3 0 -0.003564134972
Gnz_k103_4 0 nz_x103 nz_e4 0 0.01181107967
Gnz_k103_5 0 nz_x103 nz_e5 0 -0.02172164291
Gnz_k103_6 0 nz_x103 nz_e6 0 0.2118626594
Gnz_k103_7 0 nz_x103 nz_e7 0 -0.09507014251
Cnz_x104 nz_x104 0 6.162073372e-13
Gnz_a104_104 0 nz_x104 nz_x104 0 -0.07420690098
Gnz_a104_105 0 nz_x104 nz_x105 0 0.5365568094
Gnz_k104_1 0 nz_x104 nz_e1 0 -0.0003050362339
Gnz_k104_2 0 nz_x104 nz_e2 0 0.05325718638
Gnz_k104_3 0 nz_x104 nz_e3 0 -0.05012004329
Gnz_k104_4 0 nz_x104 nz_e4 0 -0.006725945479
Gnz_k104_5 0 nz_x104 nz_e5 0 -0.08572268823
Gnz_k104_6 0 nz_x104 nz_e6 0 0.09482508408
Gnz_k104_7 0 nz_x104 nz_e7 0 0.07405656458
Cnz_x105 nz_x105 0 6.162073372e-13
Gnz_a105_104 0 nz_x105 nz_x104 0 -0.5365568094
Gnz_a105_105 0 nz_x105 nz_x105 0 -0.07420690098
Gnz_k105_1 0 nz_x105 nz_e1 0 -0.001884052657
Gnz_k105_2 0 nz_x105 nz_e2 0 -0.1087449406
Gnz_k105_3 0 nz_x105 nz_e3 0 0.008082913663
Gnz_k105_4 0 nz_x105 nz_e4 0 0.01145565852
Gnz_k105_5 0 nz_x105 nz_e5 0 -0.1343592646
Gnz_k105_6 0 nz_x105 nz_e6 0 0.07594130545
Gnz_k105_7 0 nz_x105 nz_e7 0 0.01244549724
Cnz_x106 nz_x106 0 6.162073372e-13
Gnz_a106_106 0 nz_x106 nz_x106 0 -0.04532026791
Gnz_a106_107 0 nz_x106 nz_x107 0 0.7106660628
Gnz_k106_1 0 nz_x106 nz_e1 0 -0.0001513388423
Gnz_k106_2 0 nz_x106 nz_e2 0 -0.1120423702
Gnz_k106_3 0 nz_x106 nz_e3 0 0.01514164636
Gnz_k106_4 0 nz_x106 nz_e4 0 -0.03771066228
Gnz_k106_5 0 nz_x106 nz_e5 0 0.03321418263
Gnz_k106_6 0 nz_x106 nz_e6 0 0.018688808
Gnz_k106_7 0 nz_x106 nz_e7 0 0.01290837243
Cnz_x107 nz_x107 0 6.162073372e-13
Gnz_a107_106 0 nz_x107 nz_x106 0 -0.7106660628
Gnz_a107_107 0 nz_x107 nz_x107 0 -0.04532026791
Gnz_k107_1 0 nz_x107 nz_e1 0 -0.0002362847751
Gnz_k107_2 0 nz_x107 nz_e2 0 -0.01920040149
Gnz_k107_3 0 nz_x107 nz_e3 0 -0.002078283245
Gnz_k107_4 0 nz_x107 nz_e4 0 -0.02481216053
Gnz_k107_5 0 nz_x107 nz_e5 0 0.05929832332
Gnz_k107_6 0 nz_x107 nz_e6 0 0.06568220466
Gnz_k107_7 0 nz_x107 nz_e7 0 -0.05020773009
Cnz_x108 nz_x108 0 6.162073372e-13
Gnz_a108_108 0 nz_x108 nz_x108 0 -0.09794707327
Gnz_a108_109 0 nz_x108 nz_x109 0 0.6757498066
Gnz_k108_1 0 nz_x108 nz_e1 0 0.0007554379752
Gnz_k108_2 0 nz_x108 nz_e2 0 -0.1832962922
Gnz_k108_3 0 nz_x108 nz_e3 0 0.01961623043
Gnz_k108_4 0 nz_x108 nz_e4 0 -0.05118670968
Gnz_k108_5 0 nz_x108 nz_e5 0 0.05305091725
Gnz_k108_6 0 nz_x108 nz_e6 0 0.1174885478
Gnz_k108_7 0 nz_x108 nz_e7 0 0.06382718181
Cnz_x109 nz_x109 0 6.162073372e-13
Gnz_a109_108 0 nz_x109 nz_x108 0 -0.6757498066
Gnz_a109_109 0 nz_x109 nz_x109 0 -0.09794707327
Gnz_k109_1 0 nz_x109 nz_e1 0 -0.001030130353
Gnz_k109_2 0 nz_x109 nz_e2 0 -0.09631089501
Gnz_k109_3 0 nz_x109 nz_e3 0 0.01543298264
Gnz_k109_4 0 nz_x109 nz_e4 0 -0.0303424396
Gnz_k109_5 0 nz_x109 nz_e5 0 0.03350931026
Gnz_k109_6 0 nz_x109 nz_e6 0 0.1654378694
Gnz_k109_7 0 nz_x109 nz_e7 0 -0.09527996169
Cnz_x110 nz_x110 0 6.162073372e-13
Gnz_a110_110 0 nz_x110 nz_x110 0 -0.01898731862
Gnz_a110_111 0 nz_x110 nz_x111 0 0.5714210985
Gnz_k110_1 0 nz_x110 nz_e1 0 -0.000974525985
Gnz_k110_2 0 nz_x110 nz_e2 0 0.005045275401
Gnz_k110_3 0 nz_x110 nz_e3 0 -0.008217332814
Gnz_k110_4 0 nz_x110 nz_e4 0 0.005819391927
Gnz_k110_5 0 nz_x110 nz_e5 0 -0.03069401705
Gnz_k110_6 0 nz_x110 nz_e6 0 0.01316151322
Gnz_k110_7 0 nz_x110 nz_e7 0 0.01909580946
Cnz_x111 nz_x111 0 6.162073372e-13
Gnz_a111_110 0 nz_x111 nz_x110 0 -0.5714210985
Gnz_a111_111 0 nz_x111 nz_x111 0 -0.01898731862
Gnz_k111_1 0 nz_x111 nz_e1 0 -0.001763888435
Gnz_k111_2 0 nz_x111 nz_e2 0 -0.0348245116
Gnz_k111_3 0 nz_x111 nz_e3 0 0.01368768162
Gnz_k111_4 0 nz_x111 nz_e4 0 0.004459660168
Gnz_k111_5 0 nz_x111 nz_e5 0 -0.007347614364
Gnz_k111_6 0 nz_x111 nz_e6 0 0.006611333304
Gnz_k111_7 0 nz_x111 nz_e7 0 -0.001910555096
Cnz_x112 nz_x112 0 6.162073372e-13
Gnz_a112_112 0 nz_x112 nz_x112 0 -0.02632200988
Gnz_a112_113 0 nz_x112 nz_x113 0 0.660643154
Gnz_k112_1 0 nz_x112 nz_e1 0 0.001448788028
Gnz_k112_2 0 nz_x112 nz_e2 0 -0.04746371847
Gnz_k112_3 0 nz_x112 nz_e3 0 0.01282470318
Gnz_k112_4 0 nz_x112 nz_e4 0 -0.0008106923474
Gnz_k112_5 0 nz_x112 nz_e5 0 -0.01329227325
Gnz_k112_6 0 nz_x112 nz_e6 0 0.008293748033
Gnz_k112_7 0 nz_x112 nz_e7 0 0.01870357622
Cnz_x113 nz_x113 0 6.162073372e-13
Gnz_a113_112 0 nz_x113 nz_x112 0 -0.660643154
Gnz_a113_113 0 nz_x113 nz_x113 0 -0.02632200988
Gnz_k113_1 0 nz_x113 nz_e1 0 -0.001929531767
Gnz_k113_2 0 nz_x113 nz_e2 0 -0.04232405082
Gnz_k113_3 0 nz_x113 nz_e3 0 0.00801872202
Gnz_k113_4 0 nz_x113 nz_e4 0 -0.02041897046
Gnz_k113_5 0 nz_x113 nz_e5 0 0.03030048452
Gnz_k113_6 0 nz_x113 nz_e6 0 0.01708955098
Gnz_k113_7 0 nz_x113 nz_e7 0 -0.02441495495
Cnz_x114 nz_x114 0 6.162073372e-13
Gnz_a114_114 0 nz_x114 nz_x114 0 -0.02609921654
Gnz_a114_115 0 nz_x114 nz_x115 0 0.6111020463
Gnz_k114_1 0 nz_x114 nz_e1 0 -0.001333547099
Gnz_k114_2 0 nz_x114 nz_e2 0 -0.01766955251
Gnz_k114_3 0 nz_x114 nz_e3 0 0.001884045686
Gnz_k114_4 0 nz_x114 nz_e4 0 0.01116697367
Gnz_k114_5 0 nz_x114 nz_e5 0 -0.03749595242
Gnz_k114_6 0 nz_x114 nz_e6 0 0.01686889498
Gnz_k114_7 0 nz_x114 nz_e7 0 0.02856018472
Cnz_x115 nz_x115 0 6.162073372e-13
Gnz_a115_114 0 nz_x115 nz_x114 0 -0.6111020463
Gnz_a115_115 0 nz_x115 nz_x115 0 -0.02609921654
Gnz_k115_1 0 nz_x115 nz_e1 0 0.003265971784
Gnz_k115_2 0 nz_x115 nz_e2 0 -0.05778445957
Gnz_k115_3 0 nz_x115 nz_e3 0 0.01982077474
Gnz_k115_4 0 nz_x115 nz_e4 0 -0.006085190355
Gnz_k115_5 0 nz_x115 nz_e5 0 0.01008638557
Gnz_k115_6 0 nz_x115 nz_e6 0 0.0126586765
Gnz_k115_7 0 nz_x115 nz_e7 0 -0.0142814732
Cnz_x116 nz_x116 0 6.162073372e-13
Gnz_a116_116 0 nz_x116 nz_x116 0 -0.1582910324
Gnz_a116_117 0 nz_x116 nz_x117 0 0.9873925
Gnz_k116_1 0 nz_x116 nz_e1 0 -0.0002520379366
Gnz_k116_2 0 nz_x116 nz_e2 0 0.0276300489
Gnz_k116_3 0 nz_x116 nz_e3 0 -0.02188554177
Gnz_k116_4 0 nz_x116 nz_e4 0 0.01867884018
Gnz_k116_5 0 nz_x116 nz_e5 0 0.1910154968
Gnz_k116_6 0 nz_x116 nz_e6 0 0.1362958475
Gnz_k116_7 0 nz_x116 nz_e7 0 0.01695451534
Cnz_x117 nz_x117 0 6.162073372e-13
Gnz_a117_116 0 nz_x117 nz_x116 0 -0.9873925
Gnz_a117_117 0 nz_x117 nz_x117 0 -0.1582910324
Gnz_k117_1 0 nz_x117 nz_e1 0 0.0003997085397
Gnz_k117_2 0 nz_x117 nz_e2 0 -0.01425875244
Gnz_k117_3 0 nz_x117 nz_e3 0 0.008879492772
Gnz_k117_4 0 nz_x117 nz_e4 0 0.009817885537
Gnz_k117_5 0 nz_x117 nz_e5 0 -0.02486344237
Gnz_k117_6 0 nz_x117 nz_e6 0 -0.1123423677
Gnz_k117_7 0 nz_x117 nz_e7 0 0.03125174743
Cnz_x118 nz_x118 0 6.162073372e-13
Gnz_a118_118 0 nz_x118 nz_x118 0 -0.3388494362
Gnz_k118_1 0 nz_x118 nz_e1 0 0.003204626527
Gnz_k118_2 0 nz_x118 nz_e2 0 -0.01831177891
Gnz_k118_3 0 nz_x118 nz_e3 0 -0.01303160651
Gnz_k118_4 0 nz_x118 nz_e4 0 -0.03478722111
Gnz_k118_5 0 nz_x118 nz_e5 0 -0.2378396466
Gnz_k118_6 0 nz_x118 nz_e6 0 0.3767207004
Gnz_k118_7 0 nz_x118 nz_e7 0 -0.01488005522
Cnz_x119 nz_x119 0 6.162073372e-13
Gnz_a119_119 0 nz_x119 nz_x119 0 -0.04646554537
Gnz_a119_120 0 nz_x119 nz_x120 0 0.8272624502
Gnz_k119_1 0 nz_x119 nz_e1 0 -0.0001438895154
Gnz_k119_2 0 nz_x119 nz_e2 0 0.04965690694
Gnz_k119_3 0 nz_x119 nz_e3 0 0.02933088112
Gnz_k119_4 0 nz_x119 nz_e4 0 -0.001008968451
Gnz_k119_5 0 nz_x119 nz_e5 0 0.06887610382
Gnz_k119_6 0 nz_x119 nz_e6 0 0.05240384417
Gnz_k119_7 0 nz_x119 nz_e7 0 -0.02255403016
Cnz_x120 nz_x120 0 6.162073372e-13
Gnz_a120_119 0 nz_x120 nz_x119 0 -0.8272624502
Gnz_a120_120 0 nz_x120 nz_x120 0 -0.04646554537
Gnz_k120_1 0 nz_x120 nz_e1 0 2.642622391e-05
Gnz_k120_2 0 nz_x120 nz_e2 0 0.02245143526
Gnz_k120_3 0 nz_x120 nz_e3 0 -0.01442710858
Gnz_k120_4 0 nz_x120 nz_e4 0 0.01127853602
Gnz_k120_5 0 nz_x120 nz_e5 0 0.06248023754
Gnz_k120_6 0 nz_x120 nz_e6 0 0.009518856365
Gnz_k120_7 0 nz_x120 nz_e7 0 0.03053884978
Cnz_x121 nz_x121 0 6.162073372e-13
Gnz_a121_121 0 nz_x121 nz_x121 0 -0.1702469359
Gnz_a121_122 0 nz_x121 nz_x122 0 0.2995619397
Gnz_k121_1 0 nz_x121 nz_e1 0 -0.002215786966
Gnz_k121_2 0 nz_x121 nz_e2 0 0.04438103625
Gnz_k121_3 0 nz_x121 nz_e3 0 -0.02367284839
Gnz_k121_4 0 nz_x121 nz_e4 0 0.03437926129
Gnz_k121_5 0 nz_x121 nz_e5 0 -0.09977282641
Gnz_k121_6 0 nz_x121 nz_e6 0 0.209485899
Gnz_k121_7 0 nz_x121 nz_e7 0 0.02547185118
Cnz_x122 nz_x122 0 6.162073372e-13
Gnz_a122_121 0 nz_x122 nz_x121 0 -0.2995619397
Gnz_a122_122 0 nz_x122 nz_x122 0 -0.1702469359
Gnz_k122_1 0 nz_x122 nz_e1 0 -0.001875544044
Gnz_k122_2 0 nz_x122 nz_e2 0 -0.02012239418
Gnz_k122_3 0 nz_x122 nz_e3 0 0.00511606208
Gnz_k122_4 0 nz_x122 nz_e4 0 -0.002720503702
Gnz_k122_5 0 nz_x122 nz_e5 0 0.3214035027
Gnz_k122_6 0 nz_x122 nz_e6 0 -0.1951252676
Gnz_k122_7 0 nz_x122 nz_e7 0 0.02841457385
Cnz_x123 nz_x123 0 6.162073372e-13
Gnz_a123_123 0 nz_x123 nz_x123 0 -0.2415365715
Gnz_a123_124 0 nz_x123 nz_x124 0 0.4502857102
Gnz_k123_1 0 nz_x123 nz_e1 0 -0.0009481436629
Gnz_k123_2 0 nz_x123 nz_e2 0 -0.04286485185
Gnz_k123_3 0 nz_x123 nz_e3 0 -0.02893181261
Gnz_k123_4 0 nz_x123 nz_e4 0 -0.01050482809
Gnz_k123_5 0 nz_x123 nz_e5 0 0.04597515667
Gnz_k123_6 0 nz_x123 nz_e6 0 0.2565435423
Gnz_k123_7 0 nz_x123 nz_e7 0 0.02345880859
Cnz_x124 nz_x124 0 6.162073372e-13
Gnz_a124_123 0 nz_x124 nz_x123 0 -0.4502857102
Gnz_a124_124 0 nz_x124 nz_x124 0 -0.2415365715
Gnz_k124_1 0 nz_x124 nz_e1 0 -0.000987108719
Gnz_k124_2 0 nz_x124 nz_e2 0 -0.03781416974
Gnz_k124_3 0 nz_x124 nz_e3 0 0.03288233053
Gnz_k124_4 0 nz_x124 nz_e4 0 0.005394495895
Gnz_k124_5 0 nz_x124 nz_e5 0 0.3110163316
Gnz_k124_6 0 nz_x124 nz_e6 0 -0.2313555154
Gnz_k124_7 0 nz_x124 nz_e7 0 -0.02077434792
Cnz_x125 nz_x125 0 6.162073372e-13
Gnz_a125_125 0 nz_x125 nz_x125 0 -0.1417435345
Gnz_a125_126 0 nz_x125 nz_x126 0 0.7148758139
Gnz_k125_1 0 nz_x125 nz_e1 0 -0.0007154645105
Gnz_k125_2 0 nz_x125 nz_e2 0 -0.01473322131
Gnz_k125_3 0 nz_x125 nz_e3 0 0.04414565234
Gnz_k125_4 0 nz_x125 nz_e4 0 0.002698154586
Gnz_k125_5 0 nz_x125 nz_e5 0 0.1878959864
Gnz_k125_6 0 nz_x125 nz_e6 0 0.1309365158
Gnz_k125_7 0 nz_x125 nz_e7 0 -0.09286693592
Cnz_x126 nz_x126 0 6.162073372e-13
Gnz_a126_125 0 nz_x126 nz_x125 0 -0.7148758139
Gnz_a126_126 0 nz_x126 nz_x126 0 -0.1417435345
Gnz_k126_1 0 nz_x126 nz_e1 0 -0.0001995238442
Gnz_k126_2 0 nz_x126 nz_e2 0 0.1502498968
Gnz_k126_3 0 nz_x126 nz_e3 0 0.05794710139
Gnz_k126_4 0 nz_x126 nz_e4 0 0.03288595003
Gnz_k126_5 0 nz_x126 nz_e5 0 0.2112919614
Gnz_k126_6 0 nz_x126 nz_e6 0 -0.1212577803
Gnz_k126_7 0 nz_x126 nz_e7 0 -0.006772486263
Cnz_x127 nz_x127 0 6.162073372e-13
Gnz_a127_127 0 nz_x127 nz_x127 0 -0.07420690098
Gnz_a127_128 0 nz_x127 nz_x128 0 0.5365568094
Gnz_k127_1 0 nz_x127 nz_e1 0 9.394209252e-05
Gnz_k127_2 0 nz_x127 nz_e2 0 -0.1313582124
Gnz_k127_3 0 nz_x127 nz_e3 0 -0.02890966289
Gnz_k127_4 0 nz_x127 nz_e4 0 -0.03400979643
Gnz_k127_5 0 nz_x127 nz_e5 0 0.09158346394
Gnz_k127_6 0 nz_x127 nz_e6 0 0.06230418941
Gnz_k127_7 0 nz_x127 nz_e7 0 0.0118581767
Cnz_x128 nz_x128 0 6.162073372e-13
Gnz_a128_127 0 nz_x128 nz_x127 0 -0.5365568094
Gnz_a128_128 0 nz_x128 nz_x128 0 -0.07420690098
Gnz_k128_1 0 nz_x128 nz_e1 0 -0.0001222911348
Gnz_k128_2 0 nz_x128 nz_e2 0 -0.02367256637
Gnz_k128_3 0 nz_x128 nz_e3 0 0.03159580711
Gnz_k128_4 0 nz_x128 nz_e4 0 0.02944461011
Gnz_k128_5 0 nz_x128 nz_e5 0 0.1115427223
Gnz_k128_6 0 nz_x128 nz_e6 0 -0.1325544858
Gnz_k128_7 0 nz_x128 nz_e7 0 -0.06646372197
Cnz_x129 nz_x129 0 6.162073372e-13
Gnz_a129_129 0 nz_x129 nz_x129 0 -0.04532026791
Gnz_a129_130 0 nz_x129 nz_x130 0 0.7106660628
Gnz_k129_1 0 nz_x129 nz_e1 0 -0.0005161604877
Gnz_k129_2 0 nz_x129 nz_e2 0 -0.002156301077
Gnz_k129_3 0 nz_x129 nz_e3 0 0.03530603486
Gnz_k129_4 0 nz_x129 nz_e4 0 0.0005614247271
Gnz_k129_5 0 nz_x129 nz_e5 0 0.03624332211
Gnz_k129_6 0 nz_x129 nz_e6 0 0.003216904918
Gnz_k129_7 0 nz_x129 nz_e7 0 -0.06288254111
Cnz_x130 nz_x130 0 6.162073372e-13
Gnz_a130_129 0 nz_x130 nz_x129 0 -0.7106660628
Gnz_a130_130 0 nz_x130 nz_x130 0 -0.04532026791
Gnz_k130_1 0 nz_x130 nz_e1 0 -0.0007101563196
Gnz_k130_2 0 nz_x130 nz_e2 0 0.1049139828
Gnz_k130_3 0 nz_x130 nz_e3 0 0.03599094523
Gnz_k130_4 0 nz_x130 nz_e4 0 0.001507713395
Gnz_k130_5 0 nz_x130 nz_e5 0 0.07512053114
Gnz_k130_6 0 nz_x130 nz_e6 0 -0.02108811526
Gnz_k130_7 0 nz_x130 nz_e7 0 -0.006274300838
Cnz_x131 nz_x131 0 6.162073372e-13
Gnz_a131_131 0 nz_x131 nz_x131 0 -0.09794707327
Gnz_a131_132 0 nz_x131 nz_x132 0 0.6757498066
Gnz_k131_1 0 nz_x131 nz_e1 0 -0.0004433546654
Gnz_k131_2 0 nz_x131 nz_e2 0 -0.07812721151
Gnz_k131_3 0 nz_x131 nz_e3 0 0.03469317272
Gnz_k131_4 0 nz_x131 nz_e4 0 0.00792107066
Gnz_k131_5 0 nz_x131 nz_e5 0 0.1398711004
Gnz_k131_6 0 nz_x131 nz_e6 0 0.06755523331
Gnz_k131_7 0 nz_x131 nz_e7 0 -0.1049245547
Cnz_x132 nz_x132 0 6.162073372e-13
Gnz_a132_131 0 nz_x132 nz_x131 0 -0.6757498066
Gnz_a132_132 0 nz_x132 nz_x132 0 -0.09794707327
Gnz_k132_1 0 nz_x132 nz_e1 0 -6.889018356e-05
Gnz_k132_2 0 nz_x132 nz_e2 0 0.181079493
Gnz_k132_3 0 nz_x132 nz_e3 0 0.0870007383
Gnz_k132_4 0 nz_x132 nz_e4 0 0.03065362029
Gnz_k132_5 0 nz_x132 nz_e5 0 0.1897931433
Gnz_k132_6 0 nz_x132 nz_e6 0 -0.1213898918
Gnz_k132_7 0 nz_x132 nz_e7 0 -0.0486099916
Cnz_x133 nz_x133 0 6.162073372e-13
Gnz_a133_133 0 nz_x133 nz_x133 0 -0.01898731862
Gnz_a133_134 0 nz_x133 nz_x134 0 0.5714210985
Gnz_k133_1 0 nz_x133 nz_e1 0 0.001614257273
Gnz_k133_2 0 nz_x133 nz_e2 0 -0.03894155136
Gnz_k133_3 0 nz_x133 nz_e3 0 -0.009926254608
Gnz_k133_4 0 nz_x133 nz_e4 0 -0.002817935517
Gnz_k133_5 0 nz_x133 nz_e5 0 0.01682536862
Gnz_k133_6 0 nz_x133 nz_e6 0 0.00103088473
Gnz_k133_7 0 nz_x133 nz_e7 0 -0.001316238125
Cnz_x134 nz_x134 0 6.162073372e-13
Gnz_a134_133 0 nz_x134 nz_x133 0 -0.5714210985
Gnz_a134_134 0 nz_x134 nz_x134 0 -0.01898731862
Gnz_k134_1 0 nz_x134 nz_e1 0 -0.0009022909118
Gnz_k134_2 0 nz_x134 nz_e2 0 0.007351918711
Gnz_k134_3 0 nz_x134 nz_e3 0 0.009733757914
Gnz_k134_4 0 nz_x134 nz_e4 0 0.01572534065
Gnz_k134_5 0 nz_x134 nz_e5 0 0.01476877362
Gnz_k134_6 0 nz_x134 nz_e6 0 -0.02567381996
Gnz_k134_7 0 nz_x134 nz_e7 0 -0.01960907718
Cnz_x135 nz_x135 0 6.162073372e-13
Gnz_a135_135 0 nz_x135 nz_x135 0 -0.02632200988
Gnz_a135_136 0 nz_x135 nz_x136 0 0.660643154
Gnz_k135_1 0 nz_x135 nz_e1 0 0.001795264692
Gnz_k135_2 0 nz_x135 nz_e2 0 -0.0281860166
Gnz_k135_3 0 nz_x135 nz_e3 0 0.005411427625
Gnz_k135_4 0 nz_x135 nz_e4 0 0.009739069428
Gnz_k135_5 0 nz_x135 nz_e5 0 0.01578222618
Gnz_k135_6 0 nz_x135 nz_e6 0 -0.003728922174
Gnz_k135_7 0 nz_x135 nz_e7 0 -0.0278382847
Cnz_x136 nz_x136 0 6.162073372e-13
Gnz_a136_135 0 nz_x136 nz_x135 0 -0.660643154
Gnz_a136_136 0 nz_x136 nz_x136 0 -0.02632200988
Gnz_k136_1 0 nz_x136 nz_e1 0 0.0007061550658
Gnz_k136_2 0 nz_x136 nz_e2 0 0.05110883598
Gnz_k136_3 0 nz_x136 nz_e3 0 0.0281559691
Gnz_k136_4 0 nz_x136 nz_e4 0 0.002408119503
Gnz_k136_5 0 nz_x136 nz_e5 0 0.02351061841
Gnz_k136_6 0 nz_x136 nz_e6 0 -0.02063915968
Gnz_k136_7 0 nz_x136 nz_e7 0 -0.01940087944
Cnz_x137 nz_x137 0 6.162073372e-13
Gnz_a137_137 0 nz_x137 nz_x137 0 -0.02609921654
Gnz_a137_138 0 nz_x137 nz_x138 0 0.6111020463
Gnz_k137_1 0 nz_x137 nz_e1 0 -0.002955870023
Gnz_k137_2 0 nz_x137 nz_e2 0 -0.05085274555
Gnz_k137_3 0 nz_x137 nz_e3 0 -0.008786509231
Gnz_k137_4 0 nz_x137 nz_e4 0 0.007905296363
Gnz_k137_5 0 nz_x137 nz_e5 0 0.02313151667
Gnz_k137_6 0 nz_x137 nz_e6 0 -0.0009104070683
Gnz_k137_7 0 nz_x137 nz_e7 0 -0.01450828032
Cnz_x138 nz_x138 0 6.162073372e-13
Gnz_a138_137 0 nz_x138 nz_x137 0 -0.6111020463
Gnz_a138_138 0 nz_x138 nz_x138 0 -0.02609921654
Gnz_k138_1 0 nz_x138 nz_e1 0 -0.0006082326406
Gnz_k138_2 0 nz_x138 nz_e2 0 0.03310562484
Gnz_k138_3 0 nz_x138 nz_e3 0 0.02364729085
Gnz_k138_4 0 nz_x138 nz_e4 0 0.0166388107
Gnz_k138_5 0 nz_x138 nz_e5 0 0.02256566702
Gnz_k138_6 0 nz_x138 nz_e6 0 -0.03257186217
Gnz_k138_7 0 nz_x138 nz_e7 0 -0.02941686283
Cnz_x139 nz_x139 0 6.162073372e-13
Gnz_a139_139 0 nz_x139 nz_x139 0 -0.1582910324
Gnz_a139_140 0 nz_x139 nz_x140 0 0.9873925
Gnz_k139_1 0 nz_x139 nz_e1 0 -0.0001050812149
Gnz_k139_2 0 nz_x139 nz_e2 0 0.09761904761
Gnz_k139_3 0 nz_x139 nz_e3 0 0.004891224442
Gnz_k139_4 0 nz_x139 nz_e4 0 0.0139717065
Gnz_k139_5 0 nz_x139 nz_e5 0 -0.04278552204
Gnz_k139_6 0 nz_x139 nz_e6 0 0.0167747766
Gnz_k139_7 0 nz_x139 nz_e7 0 0.003744035466
Cnz_x140 nz_x140 0 6.162073372e-13
Gnz_a140_139 0 nz_x140 nz_x139 0 -0.9873925
Gnz_a140_140 0 nz_x140 nz_x140 0 -0.1582910324
Gnz_k140_1 0 nz_x140 nz_e1 0 0.0001073571663
Gnz_k140_2 0 nz_x140 nz_e2 0 -0.04367896554
Gnz_k140_3 0 nz_x140 nz_e3 0 -0.01618010814
Gnz_k140_4 0 nz_x140 nz_e4 0 0.03049177886
Gnz_k140_5 0 nz_x140 nz_e5 0 0.00137575342
Gnz_k140_6 0 nz_x140 nz_e6 0 0.02139196416
Gnz_k140_7 0 nz_x140 nz_e7 0 -0.07005520431
Cnz_x141 nz_x141 0 6.162073372e-13
Gnz_a141_141 0 nz_x141 nz_x141 0 -0.3388494362
Gnz_k141_1 0 nz_x141 nz_e1 0 0.0002378744136
Gnz_k141_2 0 nz_x141 nz_e2 0 -0.1701460777
Gnz_k141_3 0 nz_x141 nz_e3 0 0.001160231671
Gnz_k141_4 0 nz_x141 nz_e4 0 0.001958023462
Gnz_k141_5 0 nz_x141 nz_e5 0 -0.04234941691
Gnz_k141_6 0 nz_x141 nz_e6 0 -0.007215663539
Gnz_k141_7 0 nz_x141 nz_e7 0 0.01462904347
Cnz_x142 nz_x142 0 6.162073372e-13
Gnz_a142_142 0 nz_x142 nz_x142 0 -0.04646554537
Gnz_a142_143 0 nz_x142 nz_x143 0 0.8272624502
Gnz_k142_1 0 nz_x142 nz_e1 0 -6.819792862e-05
Gnz_k142_2 0 nz_x142 nz_e2 0 0.04368657056
Gnz_k142_3 0 nz_x142 nz_e3 0 0.01324239499
Gnz_k142_4 0 nz_x142 nz_e4 0 -0.01523237615
Gnz_k142_5 0 nz_x142 nz_e5 0 -0.01816426667
Gnz_k142_6 0 nz_x142 nz_e6 0 -0.01180200104
Gnz_k142_7 0 nz_x142 nz_e7 0 0.001845429307
Cnz_x143 nz_x143 0 6.162073372e-13
Gnz_a143_142 0 nz_x143 nz_x142 0 -0.8272624502
Gnz_a143_143 0 nz_x143 nz_x143 0 -0.04646554537
Gnz_k143_1 0 nz_x143 nz_e1 0 -7.176937584e-05
Gnz_k143_2 0 nz_x143 nz_e2 0 0.004868336861
Gnz_k143_3 0 nz_x143 nz_e3 0 -0.001950303339
Gnz_k143_4 0 nz_x143 nz_e4 0 0.02134766246
Gnz_k143_5 0 nz_x143 nz_e5 0 -0.0208345674
Gnz_k143_6 0 nz_x143 nz_e6 0 0.01888172909
Gnz_k143_7 0 nz_x143 nz_e7 0 -0.003029891257
Cnz_x144 nz_x144 0 6.162073372e-13
Gnz_a144_144 0 nz_x144 nz_x144 0 -0.1702469359
Gnz_a144_145 0 nz_x144 nz_x145 0 0.2995619397
Gnz_k144_1 0 nz_x144 nz_e1 0 -0.0001479906528
Gnz_k144_2 0 nz_x144 nz_e2 0 -0.125227692
Gnz_k144_3 0 nz_x144 nz_e3 0 0.01143658048
Gnz_k144_4 0 nz_x144 nz_e4 0 0.02363621697
Gnz_k144_5 0 nz_x144 nz_e5 0 -0.005499106553
Gnz_k144_6 0 nz_x144 nz_e6 0 0.02370307209
Gnz_k144_7 0 nz_x144 nz_e7 0 -0.00578131086
Cnz_x145 nz_x145 0 6.162073372e-13
Gnz_a145_144 0 nz_x145 nz_x144 0 -0.2995619397
Gnz_a145_145 0 nz_x145 nz_x145 0 -0.1702469359
Gnz_k145_1 0 nz_x145 nz_e1 0 -0.0001999162473
Gnz_k145_2 0 nz_x145 nz_e2 0 0.1412181618
Gnz_k145_3 0 nz_x145 nz_e3 0 -0.008236143561
Gnz_k145_4 0 nz_x145 nz_e4 0 0.00584517954
Gnz_k145_5 0 nz_x145 nz_e5 0 0.07041314905
Gnz_k145_6 0 nz_x145 nz_e6 0 0.02086590693
Gnz_k145_7 0 nz_x145 nz_e7 0 -0.08689538323
Cnz_x146 nz_x146 0 6.162073372e-13
Gnz_a146_146 0 nz_x146 nz_x146 0 -0.2415365715
Gnz_a146_147 0 nz_x146 nz_x147 0 0.4502857102
Gnz_k146_1 0 nz_x146 nz_e1 0 -0.0001722003514
Gnz_k146_2 0 nz_x146 nz_e2 0 -0.02662571486
Gnz_k146_3 0 nz_x146 nz_e3 0 -0.01554756644
Gnz_k146_4 0 nz_x146 nz_e4 0 0.02764870964
Gnz_k146_5 0 nz_x146 nz_e5 0 0.09004127143
Gnz_k146_6 0 nz_x146 nz_e6 0 0.03544001087
Gnz_k146_7 0 nz_x146 nz_e7 0 -0.08145035935
Cnz_x147 nz_x147 0 6.162073372e-13
Gnz_a147_146 0 nz_x147 nz_x146 0 -0.4502857102
Gnz_a147_147 0 nz_x147 nz_x147 0 -0.2415365715
Gnz_k147_1 0 nz_x147 nz_e1 0 0.0001025520935
Gnz_k147_2 0 nz_x147 nz_e2 0 0.3261652529
Gnz_k147_3 0 nz_x147 nz_e3 0 -0.01734248369
Gnz_k147_4 0 nz_x147 nz_e4 0 -0.045776858
Gnz_k147_5 0 nz_x147 nz_e5 0 0.06595437217
Gnz_k147_6 0 nz_x147 nz_e6 0 -0.03617409825
Gnz_k147_7 0 nz_x147 nz_e7 0 -0.154406929
Cnz_x148 nz_x148 0 6.162073372e-13
Gnz_a148_148 0 nz_x148 nz_x148 0 -0.1417435345
Gnz_a148_149 0 nz_x148 nz_x149 0 0.7148758139
Gnz_k148_1 0 nz_x148 nz_e1 0 0.0001020913203
Gnz_k148_2 0 nz_x148 nz_e2 0 0.1552827146
Gnz_k148_3 0 nz_x148 nz_e3 0 0.01298045375
Gnz_k148_4 0 nz_x148 nz_e4 0 -0.07174278472
Gnz_k148_5 0 nz_x148 nz_e5 0 0.02447935922
Gnz_k148_6 0 nz_x148 nz_e6 0 -0.06019511868
Gnz_k148_7 0 nz_x148 nz_e7 0 -0.03747226697
Cnz_x149 nz_x149 0 6.162073372e-13
Gnz_a149_148 0 nz_x149 nz_x148 0 -0.7148758139
Gnz_a149_149 0 nz_x149 nz_x149 0 -0.1417435345
Gnz_k149_1 0 nz_x149 nz_e1 0 -0.0001623051509
Gnz_k149_2 0 nz_x149 nz_e2 0 0.09798508004
Gnz_k149_3 0 nz_x149 nz_e3 0 0.03099370557
Gnz_k149_4 0 nz_x149 nz_e4 0 -0.01195550311
Gnz_k149_5 0 nz_x149 nz_e5 0 -0.08989796889
Gnz_k149_6 0 nz_x149 nz_e6 0 -0.005827524929
Gnz_k149_7 0 nz_x149 nz_e7 0 -0.03951850676
Cnz_x150 nz_x150 0 6.162073372e-13
Gnz_a150_150 0 nz_x150 nz_x150 0 -0.07420690098
Gnz_a150_151 0 nz_x150 nz_x151 0 0.5365568094
Gnz_k150_1 0 nz_x150 nz_e1 0 3.044399482e-05
Gnz_k150_2 0 nz_x150 nz_e2 0 0.04145707273
Gnz_k150_3 0 nz_x150 nz_e3 0 -0.02792558855
Gnz_k150_4 0 nz_x150 nz_e4 0 0.01321279449
Gnz_k150_5 0 nz_x150 nz_e5 0 0.06458645177
Gnz_k150_6 0 nz_x150 nz_e6 0 0.006444601561
Gnz_k150_7 0 nz_x150 nz_e7 0 -0.02646556909
Cnz_x151 nz_x151 0 6.162073372e-13
Gnz_a151_150 0 nz_x151 nz_x150 0 -0.5365568094
Gnz_a151_151 0 nz_x151 nz_x151 0 -0.07420690098
Gnz_k151_1 0 nz_x151 nz_e1 0 0.0002151778211
Gnz_k151_2 0 nz_x151 nz_e2 0 0.1008944632
Gnz_k151_3 0 nz_x151 nz_e3 0 -0.001978380573
Gnz_k151_4 0 nz_x151 nz_e4 0 -0.03842388713
Gnz_k151_5 0 nz_x151 nz_e5 0 0.00612360066
Gnz_k151_6 0 nz_x151 nz_e6 0 -0.04042559739
Gnz_k151_7 0 nz_x151 nz_e7 0 -0.02762839637
Cnz_x152 nz_x152 0 6.162073372e-13
Gnz_a152_152 0 nz_x152 nz_x152 0 -0.04532026791
Gnz_a152_153 0 nz_x152 nz_x153 0 0.7106660628
Gnz_k152_1 0 nz_x152 nz_e1 0 2.064046739e-05
Gnz_k152_2 0 nz_x152 nz_e2 0 0.03487367957
Gnz_k152_3 0 nz_x152 nz_e3 0 0.006231378635
Gnz_k152_4 0 nz_x152 nz_e4 0 -0.02863464602
Gnz_k152_5 0 nz_x152 nz_e5 0 0.005994100304
Gnz_k152_6 0 nz_x152 nz_e6 0 -0.02405168869
Gnz_k152_7 0 nz_x152 nz_e7 0 -0.007702645479
Cnz_x153 nz_x153 0 6.162073372e-13
Gnz_a153_152 0 nz_x153 nz_x152 0 -0.7106660628
Gnz_a153_153 0 nz_x153 nz_x153 0 -0.04532026791
Gnz_k153_1 0 nz_x153 nz_e1 0 -3.265664397e-05
Gnz_k153_2 0 nz_x153 nz_e2 0 0.02094497596
Gnz_k153_3 0 nz_x153 nz_e3 0 0.01454033389
Gnz_k153_4 0 nz_x153 nz_e4 0 -0.004833106379
Gnz_k153_5 0 nz_x153 nz_e5 0 -0.03134846302
Gnz_k153_6 0 nz_x153 nz_e6 0 -0.001986894834
Gnz_k153_7 0 nz_x153 nz_e7 0 -0.000777076169
Cnz_x154 nz_x154 0 6.162073372e-13
Gnz_a154_154 0 nz_x154 nz_x154 0 -0.09794707327
Gnz_a154_155 0 nz_x154 nz_x155 0 0.6757498066
Gnz_k154_1 0 nz_x154 nz_e1 0 0.0002196803048
Gnz_k154_2 0 nz_x154 nz_e2 0 0.1271108166
Gnz_k154_3 0 nz_x154 nz_e3 0 -0.0008534370435
Gnz_k154_4 0 nz_x154 nz_e4 0 -0.06977120281
Gnz_k154_5 0 nz_x154 nz_e5 0 0.05103774064
Gnz_k154_6 0 nz_x154 nz_e6 0 -0.06144859585
Gnz_k154_7 0 nz_x154 nz_e7 0 -0.03890376869
Cnz_x155 nz_x155 0 6.162073372e-13
Gnz_a155_154 0 nz_x155 nz_x154 0 -0.6757498066
Gnz_a155_155 0 nz_x155 nz_x155 0 -0.09794707327
Gnz_k155_1 0 nz_x155 nz_e1 0 -0.000193610405
Gnz_k155_2 0 nz_x155 nz_e2 0 0.1020165009
Gnz_k155_3 0 nz_x155 nz_e3 0 0.04109047264
Gnz_k155_4 0 nz_x155 nz_e4 0 -0.04056350441
Gnz_k155_5 0 nz_x155 nz_e5 0 -0.08715373202
Gnz_k155_6 0 nz_x155 nz_e6 0 -0.02923958495
Gnz_k155_7 0 nz_x155 nz_e7 0 -0.0244874043
Cnz_x156 nz_x156 0 6.162073372e-13
Gnz_a156_156 0 nz_x156 nz_x156 0 -0.01898731862
Gnz_a156_157 0 nz_x156 nz_x157 0 0.5714210985
Gnz_k156_1 0 nz_x156 nz_e1 0 -0.000173386664
Gnz_k156_2 0 nz_x156 nz_e2 0 0.01175046924
Gnz_k156_3 0 nz_x156 nz_e3 0 -0.007544078754
Gnz_k156_4 0 nz_x156 nz_e4 0 0.002375267601
Gnz_k156_5 0 nz_x156 nz_e5 0 0.01580443091
Gnz_k156_6 0 nz_x156 nz_e6 0 -0.0006571426108
Gnz_k156_7 0 nz_x156 nz_e7 0 -0.005357012291
Cnz_x157 nz_x157 0 6.162073372e-13
Gnz_a157_156 0 nz_x157 nz_x156 0 -0.5714210985
Gnz_a157_157 0 nz_x157 nz_x157 0 -0.01898731862
Gnz_k157_1 0 nz_x157 nz_e1 0 -3.203287625e-05
Gnz_k157_2 0 nz_x157 nz_e2 0 0.01541000976
Gnz_k157_3 0 nz_x157 nz_e3 0 0.002759216128
Gnz_k157_4 0 nz_x157 nz_e4 0 -0.01178156082
Gnz_k157_5 0 nz_x157 nz_e5 0 -0.002706935587
Gnz_k157_6 0 nz_x157 nz_e6 0 -0.01005690388
Gnz_k157_7 0 nz_x157 nz_e7 0 -0.00411458829
Cnz_x158 nz_x158 0 6.162073372e-13
Gnz_a158_158 0 nz_x158 nz_x158 0 -0.02632200988
Gnz_a158_159 0 nz_x158 nz_x159 0 0.660643154
Gnz_k158_1 0 nz_x158 nz_e1 0 -4.411514051e-05
Gnz_k158_2 0 nz_x158 nz_e2 0 0.01338213163
Gnz_k158_3 0 nz_x158 nz_e3 0 -0.001302618828
Gnz_k158_4 0 nz_x158 nz_e4 0 -0.01077287937
Gnz_k158_5 0 nz_x158 nz_e5 0 0.008571187162
Gnz_k158_6 0 nz_x158 nz_e6 0 -0.009482870127
Gnz_k158_7 0 nz_x158 nz_e7 0 -0.005141295857
Cnz_x159 nz_x159 0 6.162073372e-13
Gnz_a159_158 0 nz_x159 nz_x158 0 -0.660643154
Gnz_a159_159 0 nz_x159 nz_x159 0 -0.02632200988
Gnz_k159_1 0 nz_x159 nz_e1 0 -0.0001908018424
Gnz_k159_2 0 nz_x159 nz_e2 0 0.01045549958
Gnz_k159_3 0 nz_x159 nz_e3 0 0.007749071843
Gnz_k159_4 0 nz_x159 nz_e4 0 -0.009163200637
Gnz_k159_5 0 nz_x159 nz_e5 0 -0.01291999651
Gnz_k159_6 0 nz_x159 nz_e6 0 -0.006546627175
Gnz_k159_7 0 nz_x159 nz_e7 0 -0.0007262001919
Cnz_x160 nz_x160 0 6.162073372e-13
Gnz_a160_160 0 nz_x160 nz_x160 0 -0.02609921654
Gnz_a160_161 0 nz_x160 nz_x161 0 0.6111020463
Gnz_k160_1 0 nz_x160 nz_e1 0 0.0003038240442
Gnz_k160_2 0 nz_x160 nz_e2 0 0.01665827181
Gnz_k160_3 0 nz_x160 nz_e3 0 -0.007089864764
Gnz_k160_4 0 nz_x160 nz_e4 0 -0.004863206229
Gnz_k160_5 0 nz_x160 nz_e5 0 0.01789844646
Gnz_k160_6 0 nz_x160 nz_e6 0 -0.006211298304
Gnz_k160_7 0 nz_x160 nz_e7 0 -0.007683438698
Cnz_x161 nz_x161 0 6.162073372e-13
Gnz_a161_160 0 nz_x161 nz_x160 0 -0.6111020463
Gnz_a161_161 0 nz_x161 nz_x161 0 -0.02609921654
Gnz_k161_1 0 nz_x161 nz_e1 0 0.0002788217905
Gnz_k161_2 0 nz_x161 nz_e2 0 0.01699358858
Gnz_k161_3 0 nz_x161 nz_e3 0 0.007450494049
Gnz_k161_4 0 nz_x161 nz_e4 0 -0.01658173495
Gnz_k161_5 0 nz_x161 nz_e5 0 -0.01064078233
Gnz_k161_6 0 nz_x161 nz_e6 0 -0.01275302947
Gnz_k161_7 0 nz_x161 nz_e7 0 -0.003632793187
Gnz_c1_1 0 s1 nz_x1 0 -0.2565172563
Gnz_c1_2 0 s1 nz_x2 0 -0.07263237227
Gnz_c1_3 0 s1 nz_x3 0 0.2458831769
Gnz_c1_4 0 s1 nz_x4 0 0.04624832109
Gnz_c1_5 0 s1 nz_x5 0 0.005994699486
Gnz_c1_6 0 s1 nz_x6 0 -0.04357166471
Gnz_c1_7 0 s1 nz_x7 0 0.280455818
Gnz_c1_8 0 s1 nz_x8 0 -0.1761676275
Gnz_c1_9 0 s1 nz_x9 0 0.2417593221
Gnz_c1_10 0 s1 nz_x10 0 -0.2707929284
Gnz_c1_11 0 s1 nz_x11 0 -0.4389951573
Gnz_c1_12 0 s1 nz_x12 0 0.06689641364
Gnz_c1_13 0 s1 nz_x13 0 0.07393485691
Gnz_c1_14 0 s1 nz_x14 0 -0.03553127219
Gnz_c1_15 0 s1 nz_x15 0 0.06732791558
Gnz_c1_16 0 s1 nz_x16 0 0.1398442021
Gnz_c1_17 0 s1 nz_x17 0 0.5150140065
Gnz_c1_18 0 s1 nz_x18 0 0.04289439265
Gnz_c1_19 0 s1 nz_x19 0 -0.01348665327
Gnz_c1_20 0 s1 nz_x20 0 0.02060432265
Gnz_c1_21 0 s1 nz_x21 0 -0.07386363945
Gnz_c1_22 0 s1 nz_x22 0 0.07411397166
Gnz_c1_23 0 s1 nz_x23 0 -0.03529876827
Gnz_c1_24 0 s1 nz_x24 0 4.51112283e-05
Gnz_c1_25 0 s1 nz_x25 0 -0.0007016851276
Gnz_c1_26 0 s1 nz_x26 0 0.002609444834
Gnz_c1_27 0 s1 nz_x27 0 -0.0001260021418
Gnz_c1_28 0 s1 nz_x28 0 -9.628996108e-05
Gnz_c1_29 0 s1 nz_x29 0 0.001300891471
Gnz_c1_30 0 s1 nz_x30 0 0.0005887186442
Gnz_c1_31 0 s1 nz_x31 0 0.0004071821013
Gnz_c1_32 0 s1 nz_x32 0 0.00291379464
Gnz_c1_33 0 s1 nz_x33 0 -0.002248769507
Gnz_c1_34 0 s1 nz_x34 0 -0.006646886657
Gnz_c1_35 0 s1 nz_x35 0 0.001840677559
Gnz_c1_36 0 s1 nz_x36 0 0.001648058737
Gnz_c1_37 0 s1 nz_x37 0 -0.0068065196
Gnz_c1_38 0 s1 nz_x38 0 -0.00468354946
Gnz_c1_39 0 s1 nz_x39 0 -0.0006785587171
Gnz_c1_40 0 s1 nz_x40 0 0.006774737957
Gnz_c1_41 0 s1 nz_x41 0 -0.009315143023
Gnz_c1_42 0 s1 nz_x42 0 0.02084664015
Gnz_c1_43 0 s1 nz_x43 0 0.008188941056
Gnz_c1_44 0 s1 nz_x44 0 0.01546624188
Gnz_c1_45 0 s1 nz_x45 0 -0.005299585673
Gnz_c1_46 0 s1 nz_x46 0 -0.02599488206
Gnz_c1_47 0 s1 nz_x47 0 -6.360402668e-05
Gnz_c1_48 0 s1 nz_x48 0 0.002410304812
Gnz_c1_49 0 s1 nz_x49 0 -0.005753579915
Gnz_c1_50 0 s1 nz_x50 0 -1.145629954e-05
Gnz_c1_51 0 s1 nz_x51 0 2.406199553e-05
Gnz_c1_52 0 s1 nz_x52 0 -0.003506328605
Gnz_c1_53 0 s1 nz_x53 0 -0.0001499283011
Gnz_c1_54 0 s1 nz_x54 0 -0.002753995475
Gnz_c1_55 0 s1 nz_x55 0 -0.01020676466
Gnz_c1_56 0 s1 nz_x56 0 0.005389274926
Gnz_c1_57 0 s1 nz_x57 0 0.01666433678
Gnz_c1_58 0 s1 nz_x58 0 -0.003100029935
Gnz_c1_59 0 s1 nz_x59 0 -0.002986962126
Gnz_c1_60 0 s1 nz_x60 0 0.009240969943
Gnz_c1_61 0 s1 nz_x61 0 -0.00517709139
Gnz_c1_62 0 s1 nz_x62 0 0.009383289144
Gnz_c1_63 0 s1 nz_x63 0 -0.01694022093
Gnz_c1_64 0 s1 nz_x64 0 0.005911241397
Gnz_c1_65 0 s1 nz_x65 0 -0.02808683214
Gnz_c1_66 0 s1 nz_x66 0 -0.04399746893
Gnz_c1_67 0 s1 nz_x67 0 -0.01957982957
Gnz_c1_68 0 s1 nz_x68 0 0.007506249437
Gnz_c1_69 0 s1 nz_x69 0 0.04246378791
Gnz_c1_70 0 s1 nz_x70 0 0.006241460392
Gnz_c1_71 0 s1 nz_x71 0 -0.001608251692
Gnz_c1_72 0 s1 nz_x72 0 -0.001239223159
Gnz_c1_73 0 s1 nz_x73 0 -0.0004291188889
Gnz_c1_74 0 s1 nz_x74 0 0.0001337114434
Gnz_c1_75 0 s1 nz_x75 0 -0.0007730170783
Gnz_c1_76 0 s1 nz_x76 0 0.004464444451
Gnz_c1_77 0 s1 nz_x77 0 -0.01230716562
Gnz_c1_78 0 s1 nz_x78 0 -2.17058388e-05
Gnz_c1_79 0 s1 nz_x79 0 0.01959373309
Gnz_c1_80 0 s1 nz_x80 0 -0.005910401594
Gnz_c1_81 0 s1 nz_x81 0 -0.004469373422
Gnz_c1_82 0 s1 nz_x82 0 0.00205933065
Gnz_c1_83 0 s1 nz_x83 0 -0.006846687568
Gnz_c1_84 0 s1 nz_x84 0 -0.01027983817
Gnz_c1_85 0 s1 nz_x85 0 -0.01545890318
Gnz_c1_86 0 s1 nz_x86 0 -0.007862966869
Gnz_c1_87 0 s1 nz_x87 0 -0.02594371159
Gnz_c1_88 0 s1 nz_x88 0 -0.01497992826
Gnz_c1_89 0 s1 nz_x89 0 -0.01932922111
Gnz_c1_90 0 s1 nz_x90 0 0.04001668154
Gnz_c1_91 0 s1 nz_x91 0 0.04315524535
Gnz_c1_92 0 s1 nz_x92 0 -0.002145791833
Gnz_c1_93 0 s1 nz_x93 0 0.006539040066
Gnz_c1_94 0 s1 nz_x94 0 -0.001457847155
Gnz_c1_95 0 s1 nz_x95 0 -0.001959377748
Gnz_c1_96 0 s1 nz_x96 0 -0.0004085319114
Gnz_c1_97 0 s1 nz_x97 0 0.0001356844098
Gnz_c1_98 0 s1 nz_x98 0 -0.0002648939042
Gnz_c1_99 0 s1 nz_x99 0 0.004439806913
Gnz_c1_100 0 s1 nz_x100 0 -0.01352224622
Gnz_c1_101 0 s1 nz_x101 0 -0.0006461848297
Gnz_c1_102 0 s1 nz_x102 0 0.01993354458
Gnz_c1_103 0 s1 nz_x103 0 -0.006395588617
Gnz_c1_104 0 s1 nz_x104 0 -0.004601595604
Gnz_c1_105 0 s1 nz_x105 0 0.002203198401
Gnz_c1_106 0 s1 nz_x106 0 -0.008294448232
Gnz_c1_107 0 s1 nz_x107 0 -0.01084040432
Gnz_c1_108 0 s1 nz_x108 0 -0.01766596629
Gnz_c1_109 0 s1 nz_x109 0 -0.008543852709
Gnz_c1_110 0 s1 nz_x110 0 -0.03325655132
Gnz_c1_111 0 s1 nz_x111 0 -0.01699404854
Gnz_c1_112 0 s1 nz_x112 0 -0.02015104138
Gnz_c1_113 0 s1 nz_x113 0 0.04957713274
Gnz_c1_114 0 s1 nz_x114 0 0.05028667206
Gnz_c1_115 0 s1 nz_x115 0 -0.006048974083
Gnz_c1_116 0 s1 nz_x116 0 -0.0005480716023
Gnz_c1_117 0 s1 nz_x117 0 0.003068053946
Gnz_c1_118 0 s1 nz_x118 0 -0.00474243026
Gnz_c1_119 0 s1 nz_x119 0 -4.871928159e-05
Gnz_c1_120 0 s1 nz_x120 0 4.301189395e-05
Gnz_c1_121 0 s1 nz_x121 0 -0.002200114206
Gnz_c1_122 0 s1 nz_x122 0 4.019283738e-05
Gnz_c1_123 0 s1 nz_x123 0 -0.003006336081
Gnz_c1_124 0 s1 nz_x124 0 -0.008220384498
Gnz_c1_125 0 s1 nz_x125 0 0.006260759555
Gnz_c1_126 0 s1 nz_x126 0 0.01576665906
Gnz_c1_127 0 s1 nz_x127 0 -0.003266148043
Gnz_c1_128 0 s1 nz_x128 0 -0.003019059473
Gnz_c1_129 0 s1 nz_x129 0 0.008066839519
Gnz_c1_130 0 s1 nz_x130 0 -0.005961494225
Gnz_c1_131 0 s1 nz_x131 0 0.00721922213
Gnz_c1_132 0 s1 nz_x132 0 -0.01537757905
Gnz_c1_133 0 s1 nz_x133 0 0.006313425792
Gnz_c1_134 0 s1 nz_x134 0 -0.03368110444
Gnz_c1_135 0 s1 nz_x135 0 -0.04976825409
Gnz_c1_136 0 s1 nz_x136 0 -0.01749751855
Gnz_c1_137 0 s1 nz_x137 0 0.01256853378
Gnz_c1_138 0 s1 nz_x138 0 0.04689039065
Gnz_c1_139 0 s1 nz_x139 0 5.652294794e-05
Gnz_c1_140 0 s1 nz_x140 0 -0.0003496539426
Gnz_c1_141 0 s1 nz_x141 0 0.001060172417
Gnz_c1_142 0 s1 nz_x142 0 -8.608962063e-05
Gnz_c1_143 0 s1 nz_x143 0 -6.743694125e-05
Gnz_c1_144 0 s1 nz_x144 0 0.0008403311773
Gnz_c1_145 0 s1 nz_x145 0 0.0003242312819
Gnz_c1_146 0 s1 nz_x146 0 0.0002898365187
Gnz_c1_147 0 s1 nz_x147 0 0.001407193791
Gnz_c1_148 0 s1 nz_x148 0 -0.001266046758
Gnz_c1_149 0 s1 nz_x149 0 -0.005261361138
Gnz_c1_150 0 s1 nz_x150 0 0.001522916628
Gnz_c1_151 0 s1 nz_x151 0 0.001783178914
Gnz_c1_152 0 s1 nz_x152 0 -0.00644848576
Gnz_c1_153 0 s1 nz_x153 0 -0.003901531558
Gnz_c1_154 0 s1 nz_x154 0 -0.000811620509
Gnz_c1_155 0 s1 nz_x155 0 0.006755514376
Gnz_c1_156 0 s1 nz_x156 0 -0.00823776324
Gnz_c1_157 0 s1 nz_x157 0 0.01804180891
Gnz_c1_158 0 s1 nz_x158 0 0.01130213815
Gnz_c1_159 0 s1 nz_x159 0 0.01063024663
Gnz_c1_160 0 s1 nz_x160 0 -0.006624769135
Gnz_c1_161 0 s1 nz_x161 0 -0.02250136468
Gnz_d1_1 0 s1 nz_e1 0 0.2798100933
Gnz_c2_1 0 s2 nz_x1 0 7.633763824e-05
Gnz_c2_2 0 s2 nz_x2 0 -0.00118739807
Gnz_c2_3 0 s2 nz_x3 0 0.001143567798
Gnz_c2_4 0 s2 nz_x4 0 -0.000346276711
Gnz_c2_5 0 s2 nz_x5 0 -0.0002646222559
Gnz_c2_6 0 s2 nz_x6 0 0.004045768396
Gnz_c2_7 0 s2 nz_x7 0 0.001830913138
Gnz_c2_8 0 s2 nz_x8 0 0.0004485994956
Gnz_c2_9 0 s2 nz_x9 0 0.003210177464
Gnz_c2_10 0 s2 nz_x10 0 -0.001127874628
Gnz_c2_11 0 s2 nz_x11 0 -0.003333758657
Gnz_c2_12 0 s2 nz_x12 0 0.004367525589
Gnz_c2_13 0 s2 nz_x13 0 0.003910483219
Gnz_c2_14 0 s2 nz_x14 0 -0.001444414972
Gnz_c2_15 0 s2 nz_x15 0 -0.0009938984031
Gnz_c2_16 0 s2 nz_x16 0 -0.0004008268084
Gnz_c2_17 0 s2 nz_x17 0 0.004001859419
Gnz_c2_18 0 s2 nz_x18 0 -0.00292263265
Gnz_c2_19 0 s2 nz_x19 0 0.006540647952
Gnz_c2_20 0 s2 nz_x20 0 0.001388539764
Gnz_c2_21 0 s2 nz_x21 0 0.00262249926
Gnz_c2_22 0 s2 nz_x22 0 -0.001163851871
Gnz_c2_23 0 s2 nz_x23 0 -0.005708784421
Gnz_c2_24 0 s2 nz_x24 0 -0.05812051395
Gnz_c2_25 0 s2 nz_x25 0 -0.1057646406
Gnz_c2_26 0 s2 nz_x26 0 -0.3622779288
Gnz_c2_27 0 s2 nz_x27 0 0.001817324299
Gnz_c2_28 0 s2 nz_x28 0 0.002337616611
Gnz_c2_29 0 s2 nz_x29 0 -0.2136815404
Gnz_c2_30 0 s2 nz_x30 0 0.1013083129
Gnz_c2_31 0 s2 nz_x31 0 -0.01075085353
Gnz_c2_32 0 s2 nz_x32 0 -0.3804114394
Gnz_c2_33 0 s2 nz_x33 0 0.07632711344
Gnz_c2_34 0 s2 nz_x34 0 0.1052342597
Gnz_c2_35 0 s2 nz_x35 0 0.004363408888
Gnz_c2_36 0 s2 nz_x36 0 0.06394369229
Gnz_c2_37 0 s2 nz_x37 0 0.03205868488
Gnz_c2_38 0 s2 nz_x38 0 0.001825955183
Gnz_c2_39 0 s2 nz_x39 0 0.04875675578
Gnz_c2_40 0 s2 nz_x40 0 -0.1340238404
Gnz_c2_41 0 s2 nz_x41 0 0.003084531347
Gnz_c2_42 0 s2 nz_x42 0 -0.002606098883
Gnz_c2_43 0 s2 nz_x43 0 -0.01515594228
Gnz_c2_44 0 s2 nz_x44 0 0.01231243727
Gnz_c2_45 0 s2 nz_x45 0 0.000470078016
Gnz_c2_46 0 s2 nz_x46 0 -0.01479416876
Gnz_c2_47 0 s2 nz_x47 0 -0.1548153864
Gnz_c2_48 0 s2 nz_x48 0 -0.1219901137
Gnz_c2_49 0 s2 nz_x49 0 0.1379618338
Gnz_c2_50 0 s2 nz_x50 0 -0.00098900736
Gnz_c2_51 0 s2 nz_x51 0 0.02682559379
Gnz_c2_52 0 s2 nz_x52 0 0.08916134543
Gnz_c2_53 0 s2 nz_x53 0 -0.1437827991
Gnz_c2_54 0 s2 nz_x54 0 -0.03954436582
Gnz_c2_55 0 s2 nz_x55 0 0.2967579961
Gnz_c2_56 0 s2 nz_x56 0 -0.09184945988
Gnz_c2_57 0 s2 nz_x57 0 0.06422901431
Gnz_c2_58 0 s2 nz_x58 0 0.003427113091
Gnz_c2_59 0 s2 nz_x59 0 -0.06256318692
Gnz_c2_60 0 s2 nz_x60 0 0.009607393541
Gnz_c2_61 0 s2 nz_x61 0 0.008995014156
Gnz_c2_62 0 s2 nz_x62 0 0.08426488141
Gnz_c2_63 0 s2 nz_x63 0 0.0250951105
Gnz_c2_64 0 s2 nz_x64 0 0.002425387861
Gnz_c2_65 0 s2 nz_x65 0 0.004289991348
Gnz_c2_66 0 s2 nz_x66 0 0.005892238491
Gnz_c2_67 0 s2 nz_x67 0 -0.004266055753
Gnz_c2_68 0 s2 nz_x68 0 0.005406124234
Gnz_c2_69 0 s2 nz_x69 0 0.004424678073
Gnz_c2_70 0 s2 nz_x70 0 0.1439372518
Gnz_c2_71 0 s2 nz_x71 0 0.1109373153
Gnz_c2_72 0 s2 nz_x72 0 0.04257398149
Gnz_c2_73 0 s2 nz_x73 0 0.01865427305
Gnz_c2_74 0 s2 nz_x74 0 -0.01863338605
Gnz_c2_75 0 s2 nz_x75 0 0.007957523889
Gnz_c2_76 0 s2 nz_x76 0 -0.1341821904
Gnz_c2_77 0 s2 nz_x77 0 -0.03206014202
Gnz_c2_78 0 s2 nz_x78 0 0.1391621938
Gnz_c2_79 0 s2 nz_x79 0 0.07244519601
Gnz_c2_80 0 s2 nz_x80 0 -0.08154512981
Gnz_c2_81 0 s2 nz_x81 0 -0.05044791758
Gnz_c2_82 0 s2 nz_x82 0 -0.04768047825
Gnz_c2_83 0 s2 nz_x83 0 0.0110319399
Gnz_c2_84 0 s2 nz_x84 0 -0.0210164342
Gnz_c2_85 0 s2 nz_x85 0 -0.08460659715
Gnz_c2_86 0 s2 nz_x86 0 0.01734501178
Gnz_c2_87 0 s2 nz_x87 0 0.006329642918
Gnz_c2_88 0 s2 nz_x88 0 -0.002985456418
Gnz_c2_89 0 s2 nz_x89 0 -0.0002251132923
Gnz_c2_90 0 s2 nz_x90 0 -0.001070455232
Gnz_c2_91 0 s2 nz_x91 0 -1.702681154e-05
Gnz_c2_92 0 s2 nz_x92 0 -0.007669836475
Gnz_c2_93 0 s2 nz_x93 0 -0.05519599929
Gnz_c2_94 0 s2 nz_x94 0 -0.112644745
Gnz_c2_95 0 s2 nz_x95 0 0.06168351453
Gnz_c2_96 0 s2 nz_x96 0 0.01784672171
Gnz_c2_97 0 s2 nz_x97 0 -0.0185001958
Gnz_c2_98 0 s2 nz_x98 0 -0.06384126004
Gnz_c2_99 0 s2 nz_x99 0 -0.07930901007
Gnz_c2_100 0 s2 nz_x100 0 -0.04624207762
Gnz_c2_101 0 s2 nz_x101 0 0.08893171891
Gnz_c2_102 0 s2 nz_x102 0 0.01038497013
Gnz_c2_103 0 s2 nz_x103 0 0.02344193604
Gnz_c2_104 0 s2 nz_x104 0 -0.0467317876
Gnz_c2_105 0 s2 nz_x105 0 -0.06613086731
Gnz_c2_106 0 s2 nz_x106 0 0.009378808481
Gnz_c2_107 0 s2 nz_x107 0 -0.01285073216
Gnz_c2_108 0 s2 nz_x108 0 0.02445494184
Gnz_c2_109 0 s2 nz_x109 0 -0.008579349088
Gnz_c2_110 0 s2 nz_x110 0 0.007188175081
Gnz_c2_111 0 s2 nz_x111 0 -0.005992328164
Gnz_c2_112 0 s2 nz_x112 0 -0.003341599487
Gnz_c2_113 0 s2 nz_x113 0 -0.004486670007
Gnz_c2_114 0 s2 nz_x114 0 -0.0005150057906
Gnz_c2_115 0 s2 nz_x115 0 -0.007023840098
Gnz_c2_116 0 s2 nz_x116 0 0.06280261275
Gnz_c2_117 0 s2 nz_x117 0 0.1019085747
Gnz_c2_118 0 s2 nz_x118 0 0.1313694074
Gnz_c2_119 0 s2 nz_x119 0 0.000685409294
Gnz_c2_120 0 s2 nz_x120 0 0.01662758842
Gnz_c2_121 0 s2 nz_x121 0 0.01391448036
Gnz_c2_122 0 s2 nz_x122 0 -0.05999084567
Gnz_c2_123 0 s2 nz_x123 0 -0.2008602493
Gnz_c2_124 0 s2 nz_x124 0 0.2122541109
Gnz_c2_125 0 s2 nz_x125 0 0.0918438768
Gnz_c2_126 0 s2 nz_x126 0 -0.1480096423
Gnz_c2_127 0 s2 nz_x127 0 0.01445859615
Gnz_c2_128 0 s2 nz_x128 0 -0.05952444901
Gnz_c2_129 0 s2 nz_x129 0 0.01216992481
Gnz_c2_130 0 s2 nz_x130 0 0.004125918884
Gnz_c2_131 0 s2 nz_x131 0 -0.03609618959
Gnz_c2_132 0 s2 nz_x132 0 -0.04449595509
Gnz_c2_133 0 s2 nz_x133 0 0.006731087938
Gnz_c2_134 0 s2 nz_x134 0 0.003868523057
Gnz_c2_135 0 s2 nz_x135 0 0.003439268815
Gnz_c2_136 0 s2 nz_x136 0 -0.0005295170337
Gnz_c2_137 0 s2 nz_x137 0 0.00557897018
Gnz_c2_138 0 s2 nz_x138 0 -0.003407415803
Gnz_c2_139 0 s2 nz_x139 0 0.06492852256
Gnz_c2_140 0 s2 nz_x140 0 0.02350350306
Gnz_c2_141 0 s2 nz_x141 0 -0.1701460777
Gnz_c2_142 0 s2 nz_x142 0 0.004485832705
Gnz_c2_143 0 s2 nz_x143 0 -0.01479585593
Gnz_c2_144 0 s2 nz_x144 0 -0.1894306923
Gnz_c2_145 0 s2 nz_x145 0 0.04555970685
Gnz_c2_146 0 s2 nz_x146 0 0.005964223946
Gnz_c2_147 0 s2 nz_x147 0 -0.305512209
Gnz_c2_148 0 s2 nz_x148 0 0.117228684
Gnz_c2_149 0 s2 nz_x149 0 -0.08117297825
Gnz_c2_150 0 s2 nz_x150 0 -0.01684442549
Gnz_c2_151 0 s2 nz_x151 0 0.02188080745
Gnz_c2_152 0 s2 nz_x152 0 -0.006189107313
Gnz_c2_153 0 s2 nz_x153 0 -0.01699607636
Gnz_c2_154 0 s2 nz_x154 0 0.02193173724
Gnz_c2_155 0 s2 nz_x155 0 0.01653879932
Gnz_c2_156 0 s2 nz_x156 0 -0.004131946128
Gnz_c2_157 0 s2 nz_x157 0 -0.006116727791
Gnz_c2_158 0 s2 nz_x158 0 0.005979977413
Gnz_c2_159 0 s2 nz_x159 0 -0.002093893122
Gnz_c2_160 0 s2 nz_x160 0 -0.008362979012
Gnz_c2_161 0 s2 nz_x161 0 0.004908173965
Gnz_d2_1 0 s2 nz_e1 0 2.518676515e-05
Gnz_d2_2 0 s2 nz_e2 0 0.2746616515
Gnz_c3_1 0 s3 nz_x1 0 -0.0001103199215
Gnz_c3_2 0 s3 nz_x2 0 0.004180625841
Gnz_c3_3 0 s3 nz_x3 0 -0.002673322242
Gnz_c3_4 0 s3 nz_x4 0 -4.465830097e-05
Gnz_c3_5 0 s3 nz_x5 0 9.379711442e-05
Gnz_c3_6 0 s3 nz_x6 0 -0.01191806998
Gnz_c3_7 0 s3 nz_x7 0 -0.0005096088204
Gnz_c3_8 0 s3 nz_x8 0 -0.002579649473
Gnz_c3_9 0 s3 nz_x9 0 -0.009560609416
Gnz_c3_10 0 s3 nz_x10 0 0.003147276174
Gnz_c3_11 0 s3 nz_x11 0 0.009731785967
Gnz_c3_12 0 s3 nz_x12 0 -0.00917489965
Gnz_c3_13 0 s3 nz_x13 0 -0.0088402623
Gnz_c3_14 0 s3 nz_x14 0 0.003952053601
Gnz_c3_15 0 s3 nz_x15 0 -0.002214068739
Gnz_c3_16 0 s3 nz_x16 0 0.005856424583
Gnz_c3_17 0 s3 nz_x17 0 -0.01057295845
Gnz_c3_18 0 s3 nz_x18 0 0.003632151407
Gnz_c3_19 0 s3 nz_x19 0 -0.01725790236
Gnz_c3_20 0 s3 nz_x20 0 -0.02183465856
Gnz_c3_21 0 s3 nz_x21 0 -0.009716897442
Gnz_c3_22 0 s3 nz_x22 0 0.004015110867
Gnz_c3_23 0 s3 nz_x23 0 0.02271398223
Gnz_c3_24 0 s3 nz_x24 0 -0.1586826289
Gnz_c3_25 0 s3 nz_x25 0 -0.1250373906
Gnz_c3_26 0 s3 nz_x26 0 0.1462710312
Gnz_c3_27 0 s3 nz_x27 0 -0.001402852478
Gnz_c3_28 0 s3 nz_x28 0 0.03805062756
Gnz_c3_29 0 s3 nz_x29 0 0.09744733775
Gnz_c3_30 0 s3 nz_x30 0 -0.157144903
Gnz_c3_31 0 s3 nz_x31 0 -0.03362110542
Gnz_c3_32 0 s3 nz_x32 0 0.2523072925
Gnz_c3_33 0 s3 nz_x33 0 -0.1069461706
Gnz_c3_34 0 s3 nz_x34 0 0.07478592829
Gnz_c3_35 0 s3 nz_x35 0 0.004274704817
Gnz_c3_36 0 s3 nz_x36 0 -0.07803627992
Gnz_c3_37 0 s3 nz_x37 0 0.01936172143
Gnz_c3_38 0 s3 nz_x38 0 0.018127597
Gnz_c3_39 0 s3 nz_x39 0 0.08903376583
Gnz_c3_40 0 s3 nz_x40 0 0.02651534251
Gnz_c3_41 0 s3 nz_x41 0 0.004749870227
Gnz_c3_42 0 s3 nz_x42 0 0.008401502499
Gnz_c3_43 0 s3 nz_x43 0 0.01724520861
Gnz_c3_44 0 s3 nz_x44 0 -0.01248575079
Gnz_c3_45 0 s3 nz_x45 0 0.01316754404
Gnz_c3_46 0 s3 nz_x46 0 0.01077706335
Gnz_c3_47 0 s3 nz_x47 0 0.05878572799
Gnz_c3_48 0 s3 nz_x48 0 -0.07094932535
Gnz_c3_49 0 s3 nz_x49 0 -0.3806930913
Gnz_c3_50 0 s3 nz_x50 0 0.00492202687
Gnz_c3_51 0 s3 nz_x51 0 -0.05042045709
Gnz_c3_52 0 s3 nz_x52 0 0.05938505185
Gnz_c3_53 0 s3 nz_x53 0 -0.1195394011
Gnz_c3_54 0 s3 nz_x54 0 -0.03885581995
Gnz_c3_55 0 s3 nz_x55 0 -0.06762081692
Gnz_c3_56 0 s3 nz_x56 0 0.1114842351
Gnz_c3_57 0 s3 nz_x57 0 -0.1762377754
Gnz_c3_58 0 s3 nz_x58 0 -0.04914959946
Gnz_c3_59 0 s3 nz_x59 0 0.1181203087
Gnz_c3_60 0 s3 nz_x60 0 -0.04120728107
Gnz_c3_61 0 s3 nz_x61 0 -0.001768159768
Gnz_c3_62 0 s3 nz_x62 0 -0.1199489062
Gnz_c3_63 0 s3 nz_x63 0 -0.005317904688
Gnz_c3_64 0 s3 nz_x64 0 -0.02342237121
Gnz_c3_65 0 s3 nz_x65 0 -0.001279080028
Gnz_c3_66 0 s3 nz_x66 0 0.009880045445
Gnz_c3_67 0 s3 nz_x67 0 0.02114548403
Gnz_c3_68 0 s3 nz_x68 0 -0.02566251837
Gnz_c3_69 0 s3 nz_x69 0 0.02064721905
Gnz_c3_70 0 s3 nz_x70 0 -0.1101061744
Gnz_c3_71 0 s3 nz_x71 0 -0.02473633766
Gnz_c3_72 0 s3 nz_x72 0 -0.3247240558
Gnz_c3_73 0 s3 nz_x73 0 -0.03523746741
Gnz_c3_74 0 s3 nz_x74 0 0.05869547202
Gnz_c3_75 0 s3 nz_x75 0 0.01399639452
Gnz_c3_76 0 s3 nz_x76 0 -0.1713513593
Gnz_c3_77 0 s3 nz_x77 0 0.00774181754
Gnz_c3_78 0 s3 nz_x78 0 -0.2474432984
Gnz_c3_79 0 s3 nz_x79 0 0.08237894678
Gnz_c3_80 0 s3 nz_x80 0 -0.04060977657
Gnz_c3_81 0 s3 nz_x81 0 0.0524974111
Gnz_c3_82 0 s3 nz_x82 0 0.06755734125
Gnz_c3_83 0 s3 nz_x83 0 0.03794836963
Gnz_c3_84 0 s3 nz_x84 0 0.0308939353
Gnz_c3_85 0 s3 nz_x85 0 -0.03914240123
Gnz_c3_86 0 s3 nz_x86 0 0.0062527483
Gnz_c3_87 0 s3 nz_x87 0 -0.01801939646
Gnz_c3_88 0 s3 nz_x88 0 0.01250998234
Gnz_c3_89 0 s3 nz_x89 0 0.03055610023
Gnz_c3_90 0 s3 nz_x90 0 0.007002295829
Gnz_c3_91 0 s3 nz_x91 0 -0.003325596155
Gnz_c3_92 0 s3 nz_x92 0 0.03407712669
Gnz_c3_93 0 s3 nz_x93 0 -0.1705135774
Gnz_c3_94 0 s3 nz_x94 0 -0.006654816026
Gnz_c3_95 0 s3 nz_x95 0 0.1533820879
Gnz_c3_96 0 s3 nz_x96 0 -0.04735357497
Gnz_c3_97 0 s3 nz_x97 0 0.05735517873
Gnz_c3_98 0 s3 nz_x98 0 -0.2224136256
Gnz_c3_99 0 s3 nz_x99 0 0.2240966591
Gnz_c3_100 0 s3 nz_x100 0 0.0542030161
Gnz_c3_101 0 s3 nz_x101 0 -0.2695657981
Gnz_c3_102 0 s3 nz_x102 0 -0.03359713169
Gnz_c3_103 0 s3 nz_x103 0 0.2257456473
Gnz_c3_104 0 s3 nz_x104 0 0.1129062875
Gnz_c3_105 0 s3 nz_x105 0 0.04922054437
Gnz_c3_106 0 s3 nz_x106 0 0.06458232228
Gnz_c3_107 0 s3 nz_x107 0 0.07696213618
Gnz_c3_108 0 s3 nz_x108 0 0.05873939691
Gnz_c3_109 0 s3 nz_x109 0 -0.1351572982
Gnz_c3_110 0 s3 nz_x110 0 -0.002889774434
Gnz_c3_111 0 s3 nz_x111 0 0.008203669951
Gnz_c3_112 0 s3 nz_x112 0 0.008465185497
Gnz_c3_113 0 s3 nz_x113 0 0.01860946719
Gnz_c3_114 0 s3 nz_x114 0 0.001017274086
Gnz_c3_115 0 s3 nz_x115 0 0.006693354249
Gnz_c3_116 0 s3 nz_x116 0 0.2105724002
Gnz_c3_117 0 s3 nz_x117 0 0.06697875879
Gnz_c3_118 0 s3 nz_x118 0 0.01822539355
Gnz_c3_119 0 s3 nz_x119 0 -0.01603159373
Gnz_c3_120 0 s3 nz_x120 0 -0.0656336556
Gnz_c3_121 0 s3 nz_x121 0 -0.2810316443
Gnz_c3_122 0 s3 nz_x122 0 0.2395797878
Gnz_c3_123 0 s3 nz_x123 0 -0.03968698332
Gnz_c3_124 0 s3 nz_x124 0 -0.3972375406
Gnz_c3_125 0 s3 nz_x125 0 0.02865667459
Gnz_c3_126 0 s3 nz_x126 0 0.0446217105
Gnz_c3_127 0 s3 nz_x127 0 -0.004745896103
Gnz_c3_128 0 s3 nz_x128 0 0.05277274908
Gnz_c3_129 0 s3 nz_x129 0 -0.03265963497
Gnz_c3_130 0 s3 nz_x130 0 0.05279034884
Gnz_c3_131 0 s3 nz_x131 0 0.07431738278
Gnz_c3_132 0 s3 nz_x132 0 -0.1369853902
Gnz_c3_133 0 s3 nz_x133 0 -0.0126224514
Gnz_c3_134 0 s3 nz_x134 0 -0.01323464363
Gnz_c3_135 0 s3 nz_x135 0 -0.01774885414
Gnz_c3_136 0 s3 nz_x136 0 0.02894524885
Gnz_c3_137 0 s3 nz_x137 0 -0.0266320298
Gnz_c3_138 0 s3 nz_x138 0 -0.003327873522
Gnz_c3_139 0 s3 nz_x139 0 0.05327061826
Gnz_c3_140 0 s3 nz_x140 0 0.05775786381
Gnz_c3_141 0 s3 nz_x141 0 0.06457916947
Gnz_c3_142 0 s3 nz_x142 0 -0.003711345756
Gnz_c3_143 0 s3 nz_x143 0 0.02231102572
Gnz_c3_144 0 s3 nz_x144 0 0.01262479333
Gnz_c3_145 0 s3 nz_x145 0 -0.0386376092
Gnz_c3_146 0 s3 nz_x146 0 -0.09612818474
Gnz_c3_147 0 s3 nz_x147 0 0.104329134
Gnz_c3_148 0 s3 nz_x148 0 0.07229413403
Gnz_c3_149 0 s3 nz_x149 0 -0.1297923742
Gnz_c3_150 0 s3 nz_x150 0 0.01391735656
Gnz_c3_151 0 s3 nz_x151 0 -0.06133573693
Gnz_c3_152 0 s3 nz_x152 0 0.02012736667
Gnz_c3_153 0 s3 nz_x153 0 0.006400286369
Gnz_c3_154 0 s3 nz_x154 0 -0.03684823117
Gnz_c3_155 0 s3 nz_x155 0 -0.06588765525
Gnz_c3_156 0 s3 nz_x156 0 0.00770638963
Gnz_c3_157 0 s3 nz_x157 0 0.007470950656
Gnz_c3_158 0 s3 nz_x158 0 0.008377779708
Gnz_c3_159 0 s3 nz_x159 0 -0.006532717255
Gnz_c3_160 0 s3 nz_x160 0 0.01290565356
Gnz_c3_161 0 s3 nz_x161 0 -0.00194993999
Gnz_d3_1 0 s3 nz_e1 0 -0.0002191465756
Gnz_d3_2 0 s3 nz_e2 0 0.002893775121
Gnz_d3_3 0 s3 nz_e3 0 0.2789112902
Gnz_c4_1 0 s4 nz_x1 0 0.009038585685
Gnz_c4_2 0 s4 nz_x2 0 -0.002328993506
Gnz_c4_3 0 s4 nz_x3 0 -0.0005329770327
Gnz_c4_4 0 s4 nz_x4 0 -0.002284338438
Gnz_c4_5 0 s4 nz_x5 0 0.0007117891977
Gnz_c4_6 0 s4 nz_x6 0 -0.002334367346
Gnz_c4_7 0 s4 nz_x7 0 0.01348178926
Gnz_c4_8 0 s4 nz_x8 0 -0.01323479004
Gnz_c4_9 0 s4 nz_x9 0 -2.334186618e-05
Gnz_c4_10 0 s4 nz_x10 0 0.01562016677
Gnz_c4_11 0 s4 nz_x11 0 -0.004711785047
Gnz_c4_12 0 s4 nz_x12 0 -0.01626018149
Gnz_c4_13 0 s4 nz_x13 0 0.007492121815
Gnz_c4_14 0 s4 nz_x14 0 -0.004063446465
Gnz_c4_15 0 s4 nz_x15 0 -0.006100989957
Gnz_c4_16 0 s4 nz_x16 0 -0.01449015888
Gnz_c4_17 0 s4 nz_x17 0 -0.00737022788
Gnz_c4_18 0 s4 nz_x18 0 -0.02030656907
Gnz_c4_19 0 s4 nz_x19 0 -0.01172503582
Gnz_c4_20 0 s4 nz_x20 0 -0.01358042444
Gnz_c4_21 0 s4 nz_x21 0 0.0281151277
Gnz_c4_22 0 s4 nz_x22 0 0.03175070017
Gnz_c4_23 0 s4 nz_x23 0 -0.001578727975
Gnz_c4_24 0 s4 nz_x24 0 0.1231780714
Gnz_c4_25 0 s4 nz_x25 0 0.09493751181
Gnz_c4_26 0 s4 nz_x26 0 0.04178202104
Gnz_c4_27 0 s4 nz_x27 0 0.03613397909
Gnz_c4_28 0 s4 nz_x28 0 -0.03609352025
Gnz_c4_29 0 s4 nz_x29 0 0.007726772235
Gnz_c4_30 0 s4 nz_x30 0 -0.1302911857
Gnz_c4_31 0 s4 nz_x31 0 -0.03129351529
Gnz_c4_32 0 s4 nz_x32 0 0.1358345274
Gnz_c4_33 0 s4 nz_x33 0 0.1151495346
Gnz_c4_34 0 s4 nz_x34 0 -0.1296136151
Gnz_c4_35 0 s4 nz_x35 0 -0.07735070028
Gnz_c4_36 0 s4 nz_x36 0 -0.07310744544
Gnz_c4_37 0 s4 nz_x37 0 0.03085311639
Gnz_c4_38 0 s4 nz_x38 0 -0.05877683309
Gnz_c4_39 0 s4 nz_x39 0 -0.1342546609
Gnz_c4_40 0 s4 nz_x40 0 0.02752325177
Gnz_c4_41 0 s4 nz_x41 0 0.01579061158
Gnz_c4_42 0 s4 nz_x42 0 -0.007447842367
Gnz_c4_43 0 s4 nz_x43 0 -0.0009327592231
Gnz_c4_44 0 s4 nz_x44 0 -0.004435442182
Gnz_c4_45 0 s4 nz_x45 0 -5.704232986e-05
Gnz_c4_46 0 s4 nz_x46 0 -0.02569508328
Gnz_c4_47 0 s4 nz_x47 0 -0.09192986052
Gnz_c4_48 0 s4 nz_x48 0 -0.02065286605
Gnz_c4_49 0 s4 nz_x49 0 -0.3005801344
Gnz_c4_50 0 s4 nz_x50 0 -0.04812044854
Gnz_c4_51 0 s4 nz_x51 0 0.08015480818
Gnz_c4_52 0 s4 nz_x52 0 0.01243491925
Gnz_c4_53 0 s4 nz_x53 0 -0.1522349427
Gnz_c4_54 0 s4 nz_x54 0 0.008888008632
Gnz_c4_55 0 s4 nz_x55 0 -0.2840777583
Gnz_c4_56 0 s4 nz_x56 0 0.11245537
Gnz_c4_57 0 s4 nz_x57 0 -0.05543634181
Gnz_c4_58 0 s4 nz_x58 0 0.06453290238
Gnz_c4_59 0 s4 nz_x59 0 0.08304545342
Gnz_c4_60 0 s4 nz_x60 0 0.05266255014
Gnz_c4_61 0 s4 nz_x61 0 0.04287281464
Gnz_c4_62 0 s4 nz_x62 0 -0.05878472338
Gnz_c4_63 0 s4 nz_x63 0 0.00939048366
Gnz_c4_64 0 s4 nz_x64 0 -0.02295405599
Gnz_c4_65 0 s4 nz_x65 0 0.0159358742
Gnz_c4_66 0 s4 nz_x66 0 0.04325917208
Gnz_c4_67 0 s4 nz_x67 0 0.009913356679
Gnz_c4_68 0 s4 nz_x68 0 -0.004574195019
Gnz_c4_69 0 s4 nz_x69 0 0.04687142272
Gnz_c4_70 0 s4 nz_x70 0 0.1032830375
Gnz_c4_71 0 s4 nz_x71 0 -0.02842481132
Gnz_c4_72 0 s4 nz_x72 0 -0.407441915
Gnz_c4_73 0 s4 nz_x73 0 0.1054084989
Gnz_c4_74 0 s4 nz_x74 0 -0.02414299563
Gnz_c4_75 0 s4 nz_x75 0 0.02997408729
Gnz_c4_76 0 s4 nz_x76 0 -0.1377454164
Gnz_c4_77 0 s4 nz_x77 0 -0.1871547497
Gnz_c4_78 0 s4 nz_x78 0 -0.05244484595
Gnz_c4_79 0 s4 nz_x79 0 0.156164908
Gnz_c4_80 0 s4 nz_x80 0 -0.2722646947
Gnz_c4_81 0 s4 nz_x81 0 0.1195313187
Gnz_c4_82 0 s4 nz_x82 0 0.002478776966
Gnz_c4_83 0 s4 nz_x83 0 0.06004141053
Gnz_c4_84 0 s4 nz_x84 0 -0.09620575805
Gnz_c4_85 0 s4 nz_x85 0 -0.2036647164
Gnz_c4_86 0 s4 nz_x86 0 0.1169366594
Gnz_c4_87 0 s4 nz_x87 0 0.002566852058
Gnz_c4_88 0 s4 nz_x88 0 0.02581309907
Gnz_c4_89 0 s4 nz_x89 0 0.02685722779
Gnz_c4_90 0 s4 nz_x90 0 -0.03218026924
Gnz_c4_91 0 s4 nz_x91 0 0.03255346817
Gnz_c4_92 0 s4 nz_x92 0 0.01813986666
Gnz_c4_93 0 s4 nz_x93 0 0.09978001412
Gnz_c4_94 0 s4 nz_x94 0 0.01308366298
Gnz_c4_95 0 s4 nz_x95 0 -0.009913111195
Gnz_c4_96 0 s4 nz_x96 0 0.09988811159
Gnz_c4_97 0 s4 nz_x97 0 -0.03751335768
Gnz_c4_98 0 s4 nz_x98 0 -0.2485619063
Gnz_c4_99 0 s4 nz_x99 0 0.1715555517
Gnz_c4_100 0 s4 nz_x100 0 -0.0816270123
Gnz_c4_101 0 s4 nz_x101 0 -0.345315035
Gnz_c4_102 0 s4 nz_x102 0 -0.01049586497
Gnz_c4_103 0 s4 nz_x103 0 -0.04797788546
Gnz_c4_104 0 s4 nz_x104 0 0.156200391
Gnz_c4_105 0 s4 nz_x105 0 -0.06140812328
Gnz_c4_106 0 s4 nz_x106 0 0.05471798732
Gnz_c4_107 0 s4 nz_x107 0 -0.07531483601
Gnz_c4_108 0 s4 nz_x108 0 -0.002757276438
Gnz_c4_109 0 s4 nz_x109 0 0.1450472989
Gnz_c4_110 0 s4 nz_x110 0 0.01162219567
Gnz_c4_111 0 s4 nz_x111 0 0.02167357507
Gnz_c4_112 0 s4 nz_x112 0 0.01493414182
Gnz_c4_113 0 s4 nz_x113 0 -0.04172235658
Gnz_c4_114 0 s4 nz_x114 0 0.03686543528
Gnz_c4_115 0 s4 nz_x115 0 0.00799643533
Gnz_c4_116 0 s4 nz_x116 0 -0.159255845
Gnz_c4_117 0 s4 nz_x117 0 -0.003417741622
Gnz_c4_118 0 s4 nz_x118 0 0.1578179235
Gnz_c4_119 0 s4 nz_x119 0 -0.05158882529
Gnz_c4_120 0 s4 nz_x120 0 0.07452965582
Gnz_c4_121 0 s4 nz_x121 0 -0.1879248662
Gnz_c4_122 0 s4 nz_x122 0 0.1934405158
Gnz_c4_123 0 s4 nz_x123 0 0.06496757067
Gnz_c4_124 0 s4 nz_x124 0 -0.2587750797
Gnz_c4_125 0 s4 nz_x125 0 -0.04785604643
Gnz_c4_126 0 s4 nz_x126 0 0.2827147922
Gnz_c4_127 0 s4 nz_x127 0 0.1366422329
Gnz_c4_128 0 s4 nz_x128 0 0.07248360637
Gnz_c4_129 0 s4 nz_x129 0 0.07767155688
Gnz_c4_130 0 s4 nz_x130 0 0.08493788588
Gnz_c4_131 0 s4 nz_x131 0 0.05306878209
Gnz_c4_132 0 s4 nz_x132 0 -0.1528617359
Gnz_c4_133 0 s4 nz_x133 0 -0.005118363404
Gnz_c4_134 0 s4 nz_x134 0 0.009448296966
Gnz_c4_135 0 s4 nz_x135 0 0.01493296439
Gnz_c4_136 0 s4 nz_x136 0 0.02304379928
Gnz_c4_137 0 s4 nz_x137 0 -0.0004526387073
Gnz_c4_138 0 s4 nz_x138 0 0.01166134422
Gnz_c4_139 0 s4 nz_x139 0 -0.04060215216
Gnz_c4_140 0 s4 nz_x140 0 -0.05819655698
Gnz_c4_141 0 s4 nz_x141 0 0.02463998507
Gnz_c4_142 0 s4 nz_x142 0 0.02964712835
Gnz_c4_143 0 s4 nz_x143 0 -0.02610517368
Gnz_c4_144 0 s4 nz_x144 0 -0.03985498306
Gnz_c4_145 0 s4 nz_x145 0 -0.04566769886
Gnz_c4_146 0 s4 nz_x146 0 -0.02719935492
Gnz_c4_147 0 s4 nz_x147 0 0.03616702627
Gnz_c4_148 0 s4 nz_x148 0 0.01362837014
Gnz_c4_149 0 s4 nz_x149 0 0.03494110751
Gnz_c4_150 0 s4 nz_x150 0 -0.06166973458
Gnz_c4_151 0 s4 nz_x151 0 -0.1029191344
Gnz_c4_152 0 s4 nz_x152 0 0.01343582348
Gnz_c4_153 0 s4 nz_x153 0 -0.03123706651
Gnz_c4_154 0 s4 nz_x154 0 0.058682073
Gnz_c4_155 0 s4 nz_x155 0 -0.01270764339
Gnz_c4_156 0 s4 nz_x156 0 0.01097292234
Gnz_c4_157 0 s4 nz_x157 0 -0.007938614092
Gnz_c4_158 0 s4 nz_x158 0 -0.009031403085
Gnz_c4_159 0 s4 nz_x159 0 -0.0152977332
Gnz_c4_160 0 s4 nz_x160 0 0.0004762482591
Gnz_c4_161 0 s4 nz_x161 0 -0.01321884039
Gnz_d4_1 0 s4 nz_e1 0 -0.0001435698608
Gnz_d4_2 0 s4 nz_e2 0 0.001940225278
Gnz_d4_3 0 s4 nz_e3 0 -0.009341983205
Gnz_d4_4 0 s4 nz_e4 0 0.2754525736
Gnz_c5_1 0 s5 nz_x1 0 0.00989605181
Gnz_c5_2 0 s5 nz_x2 0 -0.002206276584
Gnz_c5_3 0 s5 nz_x3 0 -0.000880460494
Gnz_c5_4 0 s5 nz_x4 0 -0.002195132977
Gnz_c5_5 0 s5 nz_x5 0 0.000729062563
Gnz_c5_6 0 s5 nz_x6 0 -0.0007902140744
Gnz_c5_7 0 s5 nz_x7 0 0.01324454
Gnz_c5_8 0 s5 nz_x8 0 -0.01394609243
Gnz_c5_9 0 s5 nz_x9 0 -0.0006664390824
Gnz_c5_10 0 s5 nz_x10 0 0.01603018463
Gnz_c5_11 0 s5 nz_x11 0 -0.005143213037
Gnz_c5_12 0 s5 nz_x12 0 -0.01706196764
Gnz_c5_13 0 s5 nz_x13 0 0.008169101124
Gnz_c5_14 0 s5 nz_x14 0 -0.004277437444
Gnz_c5_15 0 s5 nz_x15 0 -0.005590384078
Gnz_c5_16 0 s5 nz_x16 0 -0.01473890669
Gnz_c5_17 0 s5 nz_x17 0 -0.007128228694
Gnz_c5_18 0 s5 nz_x18 0 -0.02086375887
Gnz_c5_19 0 s5 nz_x19 0 -0.01066134993
Gnz_c5_20 0 s5 nz_x20 0 -0.01151030172
Gnz_c5_21 0 s5 nz_x21 0 0.02831852436
Gnz_c5_22 0 s5 nz_x22 0 0.03137238553
Gnz_c5_23 0 s5 nz_x23 0 -0.003773778204
Gnz_c5_24 0 s5 nz_x24 0 -0.04936299427
Gnz_c5_25 0 s5 nz_x25 0 -0.1007406691
Gnz_c5_26 0 s5 nz_x26 0 0.06324803184
Gnz_c5_27 0 s5 nz_x27 0 0.03489377396
Gnz_c5_28 0 s5 nz_x28 0 -0.03617144151
Gnz_c5_29 0 s5 nz_x29 0 -0.06123705482
Gnz_c5_30 0 s5 nz_x30 0 -0.07607384619
Gnz_c5_31 0 s5 nz_x31 0 -0.04328834046
Gnz_c5_32 0 s5 nz_x32 0 0.08325115833
Gnz_c5_33 0 s5 nz_x33 0 0.01665111657
Gnz_c5_34 0 s5 nz_x34 0 0.03758647398
Gnz_c5_35 0 s5 nz_x35 0 -0.07302563091
Gnz_c5_36 0 s5 nz_x36 0 -0.1033396871
Gnz_c5_37 0 s5 nz_x37 0 0.02279171216
Gnz_c5_38 0 s5 nz_x38 0 -0.03122893371
Gnz_c5_39 0 s5 nz_x39 0 0.03454022636
Gnz_c5_40 0 s5 nz_x40 0 -0.01211749599
Gnz_c5_41 0 s5 nz_x41 0 0.01437306157
Gnz_c5_42 0 s5 nz_x42 0 -0.01198191483
Gnz_c5_43 0 s5 nz_x43 0 -0.01125675029
Gnz_c5_44 0 s5 nz_x44 0 -0.01511411649
Gnz_c5_45 0 s5 nz_x45 0 -0.001463022376
Gnz_c5_46 0 s5 nz_x46 0 -0.01995324211
Gnz_c5_47 0 s5 nz_x47 0 -0.1487776159
Gnz_c5_48 0 s5 nz_x48 0 -0.005806503376
Gnz_c5_49 0 s5 nz_x49 0 0.1483382618
Gnz_c5_50 0 s5 nz_x50 0 -0.06527243036
Gnz_c5_51 0 s5 nz_x51 0 0.07905869645
Gnz_c5_52 0 s5 nz_x52 0 -0.1952004747
Gnz_c5_53 0 s5 nz_x53 0 0.1966775826
Gnz_c5_54 0 s5 nz_x54 0 0.05968011868
Gnz_c5_55 0 s5 nz_x55 0 -0.296804864
Gnz_c5_56 0 s5 nz_x56 0 -0.04626490551
Gnz_c5_57 0 s5 nz_x57 0 0.3108628777
Gnz_c5_58 0 s5 nz_x58 0 0.1414501318
Gnz_c5_59 0 s5 nz_x59 0 0.06166399271
Gnz_c5_60 0 s5 nz_x60 0 0.0778761647
Gnz_c5_61 0 s5 nz_x61 0 0.09280428112
Gnz_c5_62 0 s5 nz_x62 0 0.0785199292
Gnz_c5_63 0 s5 nz_x63 0 -0.1806716113
Gnz_c5_64 0 s5 nz_x64 0 -0.002950489268
Gnz_c5_65 0 s5 nz_x65 0 0.008376030966
Gnz_c5_66 0 s5 nz_x66 0 0.009743320317
Gnz_c5_67 0 s5 nz_x67 0 0.0214192589
Gnz_c5_68 0 s5 nz_x68 0 0.001186473602
Gnz_c5_69 0 s5 nz_x69 0 0.00780663563
Gnz_c5_70 0 s5 nz_x70 0 0.1042742951
Gnz_c5_71 0 s5 nz_x71 0 0.01367297595
Gnz_c5_72 0 s5 nz_x72 0 -0.0103572082
Gnz_c5_73 0 s5 nz_x73 0 0.1008244438
Gnz_c5_74 0 s5 nz_x74 0 -0.03786500079
Gnz_c5_75 0 s5 nz_x75 0 -0.2455428298
Gnz_c5_76 0 s5 nz_x76 0 0.1694718079
Gnz_c5_77 0 s5 nz_x77 0 -0.07828500606
Gnz_c5_78 0 s5 nz_x78 0 -0.3311770068
Gnz_c5_79 0 s5 nz_x79 0 -0.01058775172
Gnz_c5_80 0 s5 nz_x80 0 -0.04839791109
Gnz_c5_81 0 s5 nz_x81 0 0.1591930246
Gnz_c5_82 0 s5 nz_x82 0 -0.06258463773
Gnz_c5_83 0 s5 nz_x83 0 0.04754580975
Gnz_c5_84 0 s5 nz_x84 0 -0.06544291996
Gnz_c5_85 0 s5 nz_x85 0 -0.002454221244
Gnz_c5_86 0 s5 nz_x86 0 0.1291049956
Gnz_c5_87 0 s5 nz_x87 0 0.009315347951
Gnz_c5_88 0 s5 nz_x88 0 0.01737166529
Gnz_c5_89 0 s5 nz_x89 0 0.0121414483
Gnz_c5_90 0 s5 nz_x90 0 -0.03392025075
Gnz_c5_91 0 s5 nz_x91 0 0.03126038319
Gnz_c5_92 0 s5 nz_x92 0 0.006780650512
Gnz_c5_93 0 s5 nz_x93 0 0.1046289813
Gnz_c5_94 0 s5 nz_x94 0 -0.0116670891
Gnz_c5_95 0 s5 nz_x95 0 -0.424932232
Gnz_c5_96 0 s5 nz_x96 0 0.1137655256
Gnz_c5_97 0 s5 nz_x97 0 -0.02680152992
Gnz_c5_98 0 s5 nz_x98 0 0.006753341723
Gnz_c5_99 0 s5 nz_x99 0 -0.1616127353
Gnz_c5_100 0 s5 nz_x100 0 -0.180391654
Gnz_c5_101 0 s5 nz_x101 0 -0.08302395164
Gnz_c5_102 0 s5 nz_x102 0 0.1551616529
Gnz_c5_103 0 s5 nz_x103 0 -0.2600531984
Gnz_c5_104 0 s5 nz_x104 0 0.1170590146
Gnz_c5_105 0 s5 nz_x105 0 -0.002365619502
Gnz_c5_106 0 s5 nz_x106 0 0.05317154257
Gnz_c5_107 0 s5 nz_x107 0 -0.1139505306
Gnz_c5_108 0 s5 nz_x108 0 -0.2090638591
Gnz_c5_109 0 s5 nz_x109 0 0.1253709187
Gnz_c5_110 0 s5 nz_x110 0 0.003554167991
Gnz_c5_111 0 s5 nz_x111 0 0.03214116047
Gnz_c5_112 0 s5 nz_x112 0 0.02899900353
Gnz_c5_113 0 s5 nz_x113 0 -0.04178817344
Gnz_c5_114 0 s5 nz_x114 0 0.03992021085
Gnz_c5_115 0 s5 nz_x115 0 0.01964689099
Gnz_c5_116 0 s5 nz_x116 0 -0.09596210501
Gnz_c5_117 0 s5 nz_x117 0 -0.04334158817
Gnz_c5_118 0 s5 nz_x118 0 -0.3088997914
Gnz_c5_119 0 s5 nz_x119 0 -0.0391441133
Gnz_c5_120 0 s5 nz_x120 0 0.08341719944
Gnz_c5_121 0 s5 nz_x121 0 -2.144790461e-05
Gnz_c5_122 0 s5 nz_x122 0 -0.1713899951
Gnz_c5_123 0 s5 nz_x123 0 0.04060903794
Gnz_c5_124 0 s5 nz_x124 0 -0.247307653
Gnz_c5_125 0 s5 nz_x125 0 0.1075130304
Gnz_c5_126 0 s5 nz_x126 0 -0.09230626523
Gnz_c5_127 0 s5 nz_x127 0 0.06440017669
Gnz_c5_128 0 s5 nz_x128 0 0.09957305163
Gnz_c5_129 0 s5 nz_x129 0 0.0565889898
Gnz_c5_130 0 s5 nz_x130 0 0.02796963537
Gnz_c5_131 0 s5 nz_x131 0 -0.09462304891
Gnz_c5_132 0 s5 nz_x132 0 0.04054319993
Gnz_c5_133 0 s5 nz_x133 0 -0.02567641943
Gnz_c5_134 0 s5 nz_x134 0 0.02047315624
Gnz_c5_135 0 s5 nz_x135 0 0.04911644506
Gnz_c5_136 0 s5 nz_x136 0 0.005750229236
Gnz_c5_137 0 s5 nz_x137 0 0.0004822856464
Gnz_c5_138 0 s5 nz_x138 0 0.05151292859
Gnz_c5_139 0 s5 nz_x139 0 0.1002913749
Gnz_c5_140 0 s5 nz_x140 0 0.04433145652
Gnz_c5_141 0 s5 nz_x141 0 0.008686711869
Gnz_c5_142 0 s5 nz_x142 0 0.03096871629
Gnz_c5_143 0 s5 nz_x143 0 -0.02794763957
Gnz_c5_144 0 s5 nz_x144 0 0.009821145912
Gnz_c5_145 0 s5 nz_x145 0 -0.0794787166
Gnz_c5_146 0 s5 nz_x146 0 -0.03298644694
Gnz_c5_147 0 s5 nz_x147 0 0.05948404494
Gnz_c5_148 0 s5 nz_x148 0 0.09437091289
Gnz_c5_149 0 s5 nz_x149 0 -0.08662052154
Gnz_c5_150 0 s5 nz_x150 0 -0.0633158782
Gnz_c5_151 0 s5 nz_x151 0 -0.08180050614
Gnz_c5_152 0 s5 nz_x152 0 0.02035798945
Gnz_c5_153 0 s5 nz_x153 0 -0.04542013024
Gnz_c5_154 0 s5 nz_x154 0 -0.1109148052
Gnz_c5_155 0 s5 nz_x155 0 0.01200414715
Gnz_c5_156 0 s5 nz_x156 0 0.01349900311
Gnz_c5_157 0 s5 nz_x157 0 -0.006670889359
Gnz_c5_158 0 s5 nz_x158 0 -0.00886523529
Gnz_c5_159 0 s5 nz_x159 0 -0.002948500299
Gnz_c5_160 0 s5 nz_x160 0 -0.000226122524
Gnz_c5_161 0 s5 nz_x161 0 -0.02208258041
Gnz_d5_1 0 s5 nz_e1 0 -0.0001467698569
Gnz_d5_2 0 s5 nz_e2 0 -0.002481544625
Gnz_d5_3 0 s5 nz_e3 0 0.0008369442643
Gnz_d5_4 0 s5 nz_e4 0 -0.001261517735
Gnz_d5_5 0 s5 nz_e5 0 0.2748995872
Gnz_c6_1 0 s6 nz_x1 0 -0.0008973100327
Gnz_c6_2 0 s6 nz_x2 0 0.005023058256
Gnz_c6_3 0 s6 nz_x3 0 -0.002212305061
Gnz_c6_4 0 s6 nz_x4 0 -0.0002031138722
Gnz_c6_5 0 s6 nz_x5 0 0.0001793193998
Gnz_c6_6 0 s6 nz_x6 0 -0.007509654772
Gnz_c6_7 0 s6 nz_x7 0 0.0001371903025
Gnz_c6_8 0 s6 nz_x8 0 -0.00298391148
Gnz_c6_9 0 s6 nz_x9 0 -0.00815906772
Gnz_c6_10 0 s6 nz_x10 0 0.003707717021
Gnz_c6_11 0 s6 nz_x11 0 0.00933725527
Gnz_c6_12 0 s6 nz_x12 0 -0.009920269053
Gnz_c6_13 0 s6 nz_x13 0 -0.009169787121
Gnz_c6_14 0 s6 nz_x14 0 0.003689626266
Gnz_c6_15 0 s6 nz_x15 0 -0.002726679467
Gnz_c6_16 0 s6 nz_x16 0 0.004838534989
Gnz_c6_17 0 s6 nz_x17 0 -0.01030650574
Gnz_c6_18 0 s6 nz_x18 0 0.003528239229
Gnz_c6_19 0 s6 nz_x19 0 -0.01882258505
Gnz_c6_20 0 s6 nz_x20 0 -0.02345212892
Gnz_c6_21 0 s6 nz_x21 0 -0.008245297497
Gnz_c6_22 0 s6 nz_x22 0 0.00655851587
Gnz_c6_23 0 s6 nz_x23 0 0.02446835699
Gnz_c6_24 0 s6 nz_x24 0 0.0607615534
Gnz_c6_25 0 s6 nz_x25 0 0.09859658748
Gnz_c6_26 0 s6 nz_x26 0 0.1398377744
Gnz_c6_27 0 s6 nz_x27 0 0.001039784509
Gnz_c6_28 0 s6 nz_x28 0 0.02522450309
Gnz_c6_29 0 s6 nz_x29 0 0.01527150322
Gnz_c6_30 0 s6 nz_x30 0 -0.06584150966
Gnz_c6_31 0 s6 nz_x31 0 -0.1809557143
Gnz_c6_32 0 s6 nz_x32 0 0.1912204848
Gnz_c6_33 0 s6 nz_x33 0 0.1084460854
Gnz_c6_34 0 s6 nz_x34 0 -0.1747646862
Gnz_c6_35 0 s6 nz_x35 0 0.01850785004
Gnz_c6_36 0 s6 nz_x36 0 -0.07619478159
Gnz_c6_37 0 s6 nz_x37 0 0.02623010162
Gnz_c6_38 0 s6 nz_x38 0 0.008892682026
Gnz_c6_39 0 s6 nz_x39 0 -0.04095580941
Gnz_c6_40 0 s6 nz_x40 0 -0.05048643298
Gnz_c6_41 0 s6 nz_x41 0 0.01198929108
Gnz_c6_42 0 s6 nz_x42 0 0.00689054272
Gnz_c6_43 0 s6 nz_x43 0 0.009557964494
Gnz_c6_44 0 s6 nz_x44 0 -0.001471564243
Gnz_c6_45 0 s6 nz_x45 0 0.01325620481
Gnz_c6_46 0 s6 nz_x46 0 -0.008096369098
Gnz_c6_47 0 s6 nz_x47 0 0.1987638215
Gnz_c6_48 0 s6 nz_x48 0 0.06322269226
Gnz_c6_49 0 s6 nz_x49 0 0.01829817651
Gnz_c6_50 0 s6 nz_x50 0 -0.01714579284
Gnz_c6_51 0 s6 nz_x51 0 -0.07019520838
Gnz_c6_52 0 s6 nz_x52 0 -0.2822127658
Gnz_c6_53 0 s6 nz_x53 0 0.2405866952
Gnz_c6_54 0 s6 nz_x54 0 -0.04205319721
Gnz_c6_55 0 s6 nz_x55 0 -0.4209216029
Gnz_c6_56 0 s6 nz_x56 0 0.02906034949
Gnz_c6_57 0 s6 nz_x57 0 0.04525027835
Gnz_c6_58 0 s6 nz_x58 0 -0.004870464434
Gnz_c6_59 0 s6 nz_x59 0 0.05415790651
Gnz_c6_60 0 s6 nz_x60 0 -0.03492890878
Gnz_c6_61 0 s6 nz_x61 0 0.05645835542
Gnz_c6_62 0 s6 nz_x62 0 0.07980616323
Gnz_c6_63 0 s6 nz_x63 0 -0.1471025755
Gnz_c6_64 0 s6 nz_x64 0 -0.0114802515
Gnz_c6_65 0 s6 nz_x65 0 -0.01203704674
Gnz_c6_66 0 s6 nz_x66 0 -0.01685316512
Gnz_c6_67 0 s6 nz_x67 0 0.02748453814
Gnz_c6_68 0 s6 nz_x68 0 -0.02598068968
Gnz_c6_69 0 s6 nz_x69 0 -0.003246483649
Gnz_c6_70 0 s6 nz_x70 0 -0.1800471882
Gnz_c6_71 0 s6 nz_x71 0 -0.003863938364
Gnz_c6_72 0 s6 nz_x72 0 0.1711754234
Gnz_c6_73 0 s6 nz_x73 0 -0.04040280644
Gnz_c6_74 0 s6 nz_x74 0 0.05836937053
Gnz_c6_75 0 s6 nz_x75 0 -0.2124119209
Gnz_c6_76 0 s6 nz_x76 0 0.2186462726
Gnz_c6_77 0 s6 nz_x77 0 0.05996336862
Gnz_c6_78 0 s6 nz_x78 0 -0.2388426308
Gnz_c6_79 0 s6 nz_x79 0 -0.03555067852
Gnz_c6_80 0 s6 nz_x80 0 0.2100194947
Gnz_c6_81 0 s6 nz_x81 0 0.1140758698
Gnz_c6_82 0 s6 nz_x82 0 0.06051299271
Gnz_c6_83 0 s6 nz_x83 0 0.05985865283
Gnz_c6_84 0 s6 nz_x84 0 0.06545854914
Gnz_c6_85 0 s6 nz_x85 0 0.03794618604
Gnz_c6_86 0 s6 nz_x86 0 -0.1093019218
Gnz_c6_87 0 s6 nz_x87 0 -0.003654429742
Gnz_c6_88 0 s6 nz_x88 0 0.006745933166
Gnz_c6_89 0 s6 nz_x89 0 0.01001559852
Gnz_c6_90 0 s6 nz_x90 0 0.0154555677
Gnz_c6_91 0 s6 nz_x91 0 -0.0003210354047
Gnz_c6_92 0 s6 nz_x92 0 0.008270844492
Gnz_c6_93 0 s6 nz_x93 0 -0.1038142635
Gnz_c6_94 0 s6 nz_x94 0 -0.04688804041
Gnz_c6_95 0 s6 nz_x95 0 -0.320678595
Gnz_c6_96 0 s6 nz_x96 0 -0.03037178534
Gnz_c6_97 0 s6 nz_x97 0 0.06472312339
Gnz_c6_98 0 s6 nz_x98 0 -2.454069189e-05
Gnz_c6_99 0 s6 nz_x99 0 -0.1961044357
Gnz_c6_100 0 s6 nz_x100 0 0.03908115652
Gnz_c6_101 0 s6 nz_x101 0 -0.2380029074
Gnz_c6_102 0 s6 nz_x102 0 0.07917474369
Gnz_c6_103 0 s6 nz_x103 0 -0.06797617801
Gnz_c6_104 0 s6 nz_x104 0 0.05275382808
Gnz_c6_105 0 s6 nz_x105 0 0.0815659198
Gnz_c6_106 0 s6 nz_x106 0 0.05018971567
Gnz_c6_107 0 s6 nz_x107 0 0.02480673452
Gnz_c6_108 0 s6 nz_x108 0 -0.07601381801
Gnz_c6_109 0 s6 nz_x109 0 0.03256969054
Gnz_c6_110 0 s6 nz_x110 0 -0.02287241709
Gnz_c6_111 0 s6 nz_x111 0 0.01823737807
Gnz_c6_112 0 s6 nz_x112 0 0.04051982681
Gnz_c6_113 0 s6 nz_x113 0 0.004743793905
Gnz_c6_114 0 s6 nz_x114 0 0.0004033951257
Gnz_c6_115 0 s6 nz_x115 0 0.04308663226
Gnz_c6_116 0 s6 nz_x116 0 0.06099932807
Gnz_c6_117 0 s6 nz_x117 0 -0.05118591594
Gnz_c6_118 0 s6 nz_x118 0 -0.3767207004
Gnz_c6_119 0 s6 nz_x119 0 -0.003807972197
Gnz_c6_120 0 s6 nz_x120 0 -0.04434263469
Gnz_c6_121 0 s6 nz_x121 0 0.05049722378
Gnz_c6_122 0 s6 nz_x122 0 -0.149034727
Gnz_c6_123 0 s6 nz_x123 0 0.01194021132
Gnz_c6_124 0 s6 nz_x124 0 -0.00988070226
Gnz_c6_125 0 s6 nz_x125 0 0.1404274294
Gnz_c6_126 0 s6 nz_x126 0 -0.2454900355
Gnz_c6_127 0 s6 nz_x127 0 -0.06318547271
Gnz_c6_128 0 s6 nz_x128 0 0.1274285405
Gnz_c6_129 0 s6 nz_x129 0 -0.03304404351
Gnz_c6_130 0 s6 nz_x130 0 -0.001142723732
Gnz_c6_131 0 s6 nz_x131 0 -0.1736639694
Gnz_c6_132 0 s6 nz_x132 0 0.04191369711
Gnz_c6_133 0 s6 nz_x133 0 -0.0296836578
Gnz_c6_134 0 s6 nz_x134 0 -0.00212132565
Gnz_c6_135 0 s6 nz_x135 0 0.01839260126
Gnz_c6_136 0 s6 nz_x136 0 0.02723876203
Gnz_c6_137 0 s6 nz_x137 0 -0.03268134743
Gnz_c6_138 0 s6 nz_x138 0 0.02764991571
Gnz_c6_139 0 s6 nz_x139 0 -0.1175107718
Gnz_c6_140 0 s6 nz_x140 0 -0.05462439327
Gnz_c6_141 0 s6 nz_x141 0 0.04561104748
Gnz_c6_142 0 s6 nz_x142 0 0.000421680631
Gnz_c6_143 0 s6 nz_x143 0 0.03011445981
Gnz_c6_144 0 s6 nz_x144 0 0.06036373104
Gnz_c6_145 0 s6 nz_x145 0 -0.093355645
Gnz_c6_146 0 s6 nz_x146 0 -0.03942772062
Gnz_c6_147 0 s6 nz_x147 0 0.09439655794
Gnz_c6_148 0 s6 nz_x148 0 -0.01682123098
Gnz_c6_149 0 s6 nz_x149 0 0.08560208187
Gnz_c6_150 0 s6 nz_x150 0 0.02019070762
Gnz_c6_151 0 s6 nz_x151 0 -0.07612483145
Gnz_c6_152 0 s6 nz_x152 0 0.02406942139
Gnz_c6_153 0 s6 nz_x153 0 0.01117815133
Gnz_c6_154 0 s6 nz_x154 0 0.08390751592
Gnz_c6_155 0 s6 nz_x155 0 -0.01122311223
Gnz_c6_156 0 s6 nz_x156 0 0.005462324717
Gnz_c6_157 0 s6 nz_x157 0 0.007602905383
Gnz_c6_158 0 s6 nz_x158 0 0.009974500949
Gnz_c6_159 0 s6 nz_x159 0 -0.01208851311
Gnz_c6_160 0 s6 nz_x160 0 0.0135173506
Gnz_c6_161 0 s6 nz_x161 0 0.004281387696
Gnz_d6_1 0 s6 nz_e1 0 -0.000241522939
Gnz_d6_2 0 s6 nz_e2 0 -0.001937678131
Gnz_d6_3 0 s6 nz_e3 0 0.003205947011
Gnz_d6_4 0 s6 nz_e4 0 0.0006511158967
Gnz_d6_5 0 s6 nz_e5 0 -0.009798136834
Gnz_d6_6 0 s6 nz_e6 0 0.27854271
Gnz_c7_1 0 s7 nz_x1 0 0.0001009247872
Gnz_c7_2 0 s7 nz_x2 0 -0.0006243260669
Gnz_c7_3 0 s7 nz_x3 0 0.0007927067626
Gnz_c7_4 0 s7 nz_x4 0 -0.0002554228593
Gnz_c7_5 0 s7 nz_x5 0 -0.0002000814528
Gnz_c7_6 0 s7 nz_x6 0 0.003109554564
Gnz_c7_7 0 s7 nz_x7 0 0.001199782763
Gnz_c7_8 0 s7 nz_x8 0 0.0004607149944
Gnz_c7_9 0 s7 nz_x9 0 0.002236830895
Gnz_c7_10 0 s7 nz_x10 0 -0.000594719029
Gnz_c7_11 0 s7 nz_x11 0 -0.00247149765
Gnz_c7_12 0 s7 nz_x12 0 0.003209343215
Gnz_c7_13 0 s7 nz_x13 0 0.003757811191
Gnz_c7_14 0 s7 nz_x14 0 -0.001331795507
Gnz_c7_15 0 s7 nz_x15 0 -0.0008057771071
Gnz_c7_16 0 s7 nz_x16 0 -0.0003791928239
Gnz_c7_17 0 s7 nz_x17 0 0.003156207298
Gnz_c7_18 0 s7 nz_x18 0 -0.002788081848
Gnz_c7_19 0 s7 nz_x19 0 0.006106274053
Gnz_c7_20 0 s7 nz_x20 0 0.002101809861
Gnz_c7_21 0 s7 nz_x21 0 0.001976861093
Gnz_c7_22 0 s7 nz_x22 0 -0.001739281143
Gnz_c7_23 0 s7 nz_x23 0 -0.005907556701
Gnz_c7_24 0 s7 nz_x24 0 0.06851008275
Gnz_c7_25 0 s7 nz_x25 0 0.02479999353
Gnz_c7_26 0 s7 nz_x26 0 -0.2902981089
Gnz_c7_27 0 s7 nz_x27 0 0.004842913197
Gnz_c7_28 0 s7 nz_x28 0 -0.01597363313
Gnz_c7_29 0 s7 nz_x29 0 -0.225391794
Gnz_c7_30 0 s7 nz_x30 0 0.05420866036
Gnz_c7_31 0 s7 nz_x31 0 0.008605241893
Gnz_c7_32 0 s7 nz_x32 0 -0.4407960672
Gnz_c7_33 0 s7 nz_x33 0 0.1097943762
Gnz_c7_34 0 s7 nz_x34 0 -0.07602522018
Gnz_c7_35 0 s7 nz_x35 0 -0.01496023784
Gnz_c7_36 0 s7 nz_x36 0 0.01943325901
Gnz_c7_37 0 s7 nz_x37 0 -0.006023389276
Gnz_c7_38 0 s7 nz_x38 0 -0.01654099354
Gnz_c7_39 0 s7 nz_x39 0 0.01734645782
Gnz_c7_40 0 s7 nz_x40 0 0.01308102417
Gnz_c7_41 0 s7 nz_x41 0 -0.004457241438
Gnz_c7_42 0 s7 nz_x42 0 -0.006598278809
Gnz_c7_43 0 s7 nz_x43 0 0.006558458592
Gnz_c7_44 0 s7 nz_x44 0 -0.002296448697
Gnz_c7_45 0 s7 nz_x45 0 -0.009997795642
Gnz_c7_46 0 s7 nz_x46 0 0.005867636425
Gnz_c7_47 0 s7 nz_x47 0 0.05483924195
Gnz_c7_48 0 s7 nz_x48 0 0.05945862037
Gnz_c7_49 0 s7 nz_x49 0 0.1039238807
Gnz_c7_50 0 s7 nz_x50 0 -0.002824766459
Gnz_c7_51 0 s7 nz_x51 0 0.01698128961
Gnz_c7_52 0 s7 nz_x52 0 0.01374417467
Gnz_c7_53 0 s7 nz_x53 0 -0.04206342519
Gnz_c7_54 0 s7 nz_x54 0 -0.1631295013
Gnz_c7_55 0 s7 nz_x55 0 0.1770465098
Gnz_c7_56 0 s7 nz_x56 0 0.05815146152
Gnz_c7_57 0 s7 nz_x57 0 -0.104401503
Gnz_c7_58 0 s7 nz_x58 0 0.009909719325
Gnz_c7_59 0 s7 nz_x59 0 -0.0436735191
Gnz_c7_60 0 s7 nz_x60 0 0.009719893139
Gnz_c7_61 0 s7 nz_x61 0 0.003090821595
Gnz_c7_62 0 s7 nz_x62 0 -0.02758330405
Gnz_c7_63 0 s7 nz_x63 0 -0.04932120675
Gnz_c7_64 0 s7 nz_x64 0 0.004244845884
Gnz_c7_65 0 s7 nz_x65 0 0.004115161011
Gnz_c7_66 0 s7 nz_x66 0 0.003139373863
Gnz_c7_67 0 s7 nz_x67 0 -0.002447980553
Gnz_c7_68 0 s7 nz_x68 0 0.006334385544
Gnz_c7_69 0 s7 nz_x69 0 -0.0009570744814
Gnz_c7_70 0 s7 nz_x70 0 -0.05006195808
Gnz_c7_71 0 s7 nz_x71 0 -0.0717556445
Gnz_c7_72 0 s7 nz_x72 0 0.04283685012
Gnz_c7_73 0 s7 nz_x73 0 0.01652375648
Gnz_c7_74 0 s7 nz_x74 0 -0.01454965647
Gnz_c7_75 0 s7 nz_x75 0 -0.04883714005
Gnz_c7_76 0 s7 nz_x76 0 -0.05595987337
Gnz_c7_77 0 s7 nz_x77 0 -0.04020488603
Gnz_c7_78 0 s7 nz_x78 0 0.05346050204
Gnz_c7_79 0 s7 nz_x79 0 0.00803040652
Gnz_c7_80 0 s7 nz_x80 0 0.02058876408
Gnz_c7_81 0 s7 nz_x81 0 -0.03572180275
Gnz_c7_82 0 s7 nz_x82 0 -0.05961525609
Gnz_c7_83 0 s7 nz_x83 0 0.004675521491
Gnz_c7_84 0 s7 nz_x84 0 -0.01087016185
Gnz_c7_85 0 s7 nz_x85 0 0.02924947493
Gnz_c7_86 0 s7 nz_x86 0 -0.006333993975
Gnz_c7_87 0 s7 nz_x87 0 0.004744758075
Gnz_c7_88 0 s7 nz_x88 0 -0.003432704813
Gnz_c7_89 0 s7 nz_x89 0 -0.002390501663
Gnz_c7_90 0 s7 nz_x90 0 -0.004049122412
Gnz_c7_91 0 s7 nz_x91 0 0.0001699466956
Gnz_c7_92 0 s7 nz_x92 0 -0.004717073921
Gnz_c7_93 0 s7 nz_x93 0 0.1183283099
Gnz_c7_94 0 s7 nz_x94 0 0.05230426178
Gnz_c7_95 0 s7 nz_x95 0 0.01445439026
Gnz_c7_96 0 s7 nz_x96 0 0.01710004777
Gnz_c7_97 0 s7 nz_x97 0 -0.01543189479
Gnz_c7_98 0 s7 nz_x98 0 0.01218251829
Gnz_c7_99 0 s7 nz_x99 0 -0.09858838546
Gnz_c7_100 0 s7 nz_x100 0 -0.0508406485
Gnz_c7_101 0 s7 nz_x101 0 0.09168030208
Gnz_c7_102 0 s7 nz_x102 0 0.05512470176
Gnz_c7_103 0 s7 nz_x103 0 -0.05059748041
Gnz_c7_104 0 s7 nz_x104 0 -0.03598586994
Gnz_c7_105 0 s7 nz_x105 0 -0.04649169306
Gnz_c7_106 0 s7 nz_x106 0 0.008153020221
Gnz_c7_107 0 s7 nz_x107 0 -0.01818997112
Gnz_c7_108 0 s7 nz_x108 0 -0.06211103213
Gnz_c7_109 0 s7 nz_x109 0 0.006722186165
Gnz_c7_110 0 s7 nz_x110 0 0.007282534773
Gnz_c7_111 0 s7 nz_x111 0 -0.00359885714
Gnz_c7_112 0 s7 nz_x112 0 -0.002886249476
Gnz_c7_113 0 s7 nz_x113 0 -0.0009599415205
Gnz_c7_114 0 s7 nz_x114 0 -9.515863775e-05
Gnz_c7_115 0 s7 nz_x115 0 -0.0092929631
Gnz_c7_116 0 s7 nz_x116 0 -0.1281579328
Gnz_c7_117 0 s7 nz_x117 0 -0.05957368177
Gnz_c7_118 0 s7 nz_x118 0 0.07310751948
Gnz_c7_119 0 s7 nz_x119 0 0.0003000916499
Gnz_c7_120 0 s7 nz_x120 0 0.02143114307
Gnz_c7_121 0 s7 nz_x121 0 0.0654408653
Gnz_c7_122 0 s7 nz_x122 0 -0.1012076968
Gnz_c7_123 0 s7 nz_x123 0 -0.06314406061
Gnz_c7_124 0 s7 nz_x124 0 0.1511774427
Gnz_c7_125 0 s7 nz_x125 0 -0.01334259513
Gnz_c7_126 0 s7 nz_x126 0 0.06789954446
Gnz_c7_127 0 s7 nz_x127 0 0.01400889855
Gnz_c7_128 0 s7 nz_x128 0 -0.05281761595
Gnz_c7_129 0 s7 nz_x129 0 0.01086842194
Gnz_c7_130 0 s7 nz_x130 0 0.005047436046
Gnz_c7_131 0 s7 nz_x131 0 0.05849038502
Gnz_c7_132 0 s7 nz_x132 0 -0.007823424976
Gnz_c7_133 0 s7 nz_x133 0 0.003308116404
Gnz_c7_134 0 s7 nz_x134 0 0.004604504002
Gnz_c7_135 0 s7 nz_x135 0 0.003936353765
Gnz_c7_136 0 s7 nz_x136 0 -0.004770631067
Gnz_c7_137 0 s7 nz_x137 0 0.006800951242
Gnz_c7_138 0 s7 nz_x138 0 0.002154084024
Gnz_c7_139 0 s7 nz_x139 0 -0.05020752013
Gnz_c7_140 0 s7 nz_x140 0 -0.03111033305
Gnz_c7_141 0 s7 nz_x141 0 -0.1655288722
Gnz_c7_142 0 s7 nz_x142 0 0.005021499919
Gnz_c7_143 0 s7 nz_x143 0 -0.002756853866
Gnz_c7_144 0 s7 nz_x144 0 -0.1290073118
Gnz_c7_145 0 s7 nz_x145 0 0.03356557353
Gnz_c7_146 0 s7 nz_x146 0 -0.002961228724
Gnz_c7_147 0 s7 nz_x147 0 -0.1633650411
Gnz_c7_148 0 s7 nz_x148 0 0.0905057955
Gnz_c7_149 0 s7 nz_x149 0 0.04685173299
Gnz_c7_150 0 s7 nz_x150 0 -0.01222882312
Gnz_c7_151 0 s7 nz_x151 0 0.03730106797
Gnz_c7_152 0 s7 nz_x152 0 0.01785358125
Gnz_c7_153 0 s7 nz_x153 0 -0.004343933216
Gnz_c7_154 0 s7 nz_x154 0 -0.00432892561
Gnz_c7_155 0 s7 nz_x155 0 -0.1169131633
Gnz_c7_156 0 s7 nz_x156 0 0.0007671529928
Gnz_c7_157 0 s7 nz_x157 0 -0.003721369602
Gnz_c7_158 0 s7 nz_x158 0 -0.007160878236
Gnz_c7_159 0 s7 nz_x159 0 0.008582598876
Gnz_c7_160 0 s7 nz_x160 0 -0.003276067237
Gnz_c7_161 0 s7 nz_x161 0 -0.006976995354
Gnz_d7_1 0 s7 nz_e1 0 2.228772246e-05
Gnz_d7_2 0 s7 nz_e2 0 -0.02817891157
Gnz_d7_3 0 s7 nz_e3 0 -0.0006698112045
Gnz_d7_4 0 s7 nz_e4 0 -0.003373655926
Gnz_d7_5 0 s7 nz_e5 0 0.0003084265047
Gnz_d7_6 0 s7 nz_e6 0 0.0015851446
Gnz_d7_7 0 s7 nz_e7 0 0.249551386
.ENDS sparx_core_le
