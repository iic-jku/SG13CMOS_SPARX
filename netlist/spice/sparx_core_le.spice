* sparx_core_le - lumped-element equivalent (Ngspice / SPICE3)
* generated by snp2le
* EQUIVALENT CIRCUIT FOR VECTOR FITTED S-MATRIX
* Created using scikit-rf vectorFitting.py
*
*
.SUBCKT sparx_core_le p1 p2 p3 p4 p5 p6 p7
V1 p1 s1 0
R1 s1 0 50
Gd1_1 0 s1 p1 0 -0.0004918278905
Fd1_1 0 s1 V1 -0.02459139453
Gr1_1_1 0 s1 x1_a1 0 1.017072175
Gr2_re_1_1 0 s1 x2_re_a1 0 -397356.9399
Gr2_im_1_1 0 s1 x2_im_a1 0 -355165.8629
Gr3_re_1_1 0 s1 x3_re_a1 0 -476450.7457
Gr3_im_1_1 0 s1 x3_im_a1 0 -51091.923
Gr4_re_1_1 0 s1 x4_re_a1 0 -312962.1777
Gr4_im_1_1 0 s1 x4_im_a1 0 789543.0153
Gr5_re_1_1 0 s1 x5_re_a1 0 -757484.6065
Gr5_im_1_1 0 s1 x5_im_a1 0 -663617.5099
Gr6_re_1_1 0 s1 x6_re_a1 0 187898.8267
Gr6_im_1_1 0 s1 x6_im_a1 0 64203.16024
Gr7_re_1_1 0 s1 x7_re_a1 0 195389.153
Gr7_im_1_1 0 s1 x7_im_a1 0 -355160.0506
Gr8_re_1_1 0 s1 x8_re_a1 0 1457809.819
Gr8_im_1_1 0 s1 x8_im_a1 0 518145.3397
Gr9_re_1_1 0 s1 x9_re_a1 0 -159971.3312
Gr9_im_1_1 0 s1 x9_im_a1 0 817017.8162
Gr10_re_1_1 0 s1 x10_re_a1 0 227745.1248
Gr10_im_1_1 0 s1 x10_im_a1 0 -306803.8564
Gr11_re_1_1 0 s1 x11_re_a1 0 -149351.1822
Gr11_im_1_1 0 s1 x11_im_a1 0 -653193.8475
Gr12_re_1_1 0 s1 x12_re_a1 0 274929.5934
Gr12_im_1_1 0 s1 x12_im_a1 0 -586548.7347
Gd1_2 0 s1 p2 0 -7.452166041e-05
Fd1_2 0 s1 V2 -0.00372608302
Gr1_1_2 0 s1 x1_a2 0 -0.006833277865
Gr2_re_1_2 0 s1 x2_re_a2 0 -16504.02933
Gr2_im_1_2 0 s1 x2_im_a2 0 -17690.06563
Gr3_re_1_2 0 s1 x3_re_a2 0 -1855.286384
Gr3_im_1_2 0 s1 x3_im_a2 0 -945.0309647
Gr4_re_1_2 0 s1 x4_re_a2 0 -7039.112085
Gr4_im_1_2 0 s1 x4_im_a2 0 26717.24064
Gr5_re_1_2 0 s1 x5_re_a2 0 9252.721434
Gr5_im_1_2 0 s1 x5_im_a2 0 -8493.740406
Gr6_re_1_2 0 s1 x6_re_a2 0 -1566.38419
Gr6_im_1_2 0 s1 x6_im_a2 0 -6080.011752
Gr7_re_1_2 0 s1 x7_re_a2 0 14887.88089
Gr7_im_1_2 0 s1 x7_im_a2 0 5439.748731
Gr8_re_1_2 0 s1 x8_re_a2 0 1912.997602
Gr8_im_1_2 0 s1 x8_im_a2 0 12592.18077
Gr9_re_1_2 0 s1 x9_re_a2 0 -25060.97869
Gr9_im_1_2 0 s1 x9_im_a2 0 -12970.76416
Gr10_re_1_2 0 s1 x10_re_a2 0 -30015.18952
Gr10_im_1_2 0 s1 x10_im_a2 0 124987.3748
Gr11_re_1_2 0 s1 x11_re_a2 0 29399.95401
Gr11_im_1_2 0 s1 x11_im_a2 0 61569.78487
Gr12_re_1_2 0 s1 x12_re_a2 0 -30905.4534
Gr12_im_1_2 0 s1 x12_im_a2 0 -76199.2428
Gd1_3 0 s1 p3 0 0.0001946750431
Fd1_3 0 s1 V3 0.009733752154
Gr1_1_3 0 s1 x1_a3 0 0.054974452
Gr2_re_1_3 0 s1 x2_re_a3 0 37276.56877
Gr2_im_1_3 0 s1 x2_im_a3 0 27912.48214
Gr3_re_1_3 0 s1 x3_re_a3 0 8644.640312
Gr3_im_1_3 0 s1 x3_im_a3 0 3851.986419
Gr4_re_1_3 0 s1 x4_re_a3 0 17398.21832
Gr4_im_1_3 0 s1 x4_im_a3 0 -53046.20952
Gr5_re_1_3 0 s1 x5_re_a3 0 -31217.60101
Gr5_im_1_3 0 s1 x5_im_a3 0 49029.49567
Gr6_re_1_3 0 s1 x6_re_a3 0 1096.496922
Gr6_im_1_3 0 s1 x6_im_a3 0 2093.042553
Gr7_re_1_3 0 s1 x7_re_a3 0 -26115.95375
Gr7_im_1_3 0 s1 x7_im_a3 0 -7446.93016
Gr8_re_1_3 0 s1 x8_re_a3 0 15178.17362
Gr8_im_1_3 0 s1 x8_im_a3 0 -73645.0507
Gr9_re_1_3 0 s1 x9_re_a3 0 26752.41228
Gr9_im_1_3 0 s1 x9_im_a3 0 -9693.343771
Gr10_re_1_3 0 s1 x10_re_a3 0 -4212.29249
Gr10_im_1_3 0 s1 x10_im_a3 0 -207198.1297
Gr11_re_1_3 0 s1 x11_re_a3 0 -237845.752
Gr11_im_1_3 0 s1 x11_im_a3 0 -32878.57598
Gr12_re_1_3 0 s1 x12_re_a3 0 83094.82969
Gr12_im_1_3 0 s1 x12_im_a3 0 206032.5085
Gd1_4 0 s1 p4 0 -0.0004183883932
Fd1_4 0 s1 V4 -0.02091941966
Gr1_1_4 0 s1 x1_a4 0 0.0578698079
Gr2_re_1_4 0 s1 x2_re_a4 0 951.6653326
Gr2_im_1_4 0 s1 x2_im_a4 0 -59294.61162
Gr3_re_1_4 0 s1 x3_re_a4 0 12188.23933
Gr3_im_1_4 0 s1 x3_im_a4 0 -10418.16701
Gr4_re_1_4 0 s1 x4_re_a4 0 -88699.45251
Gr4_im_1_4 0 s1 x4_im_a4 0 12016.78378
Gr5_re_1_4 0 s1 x5_re_a4 0 73440.89175
Gr5_im_1_4 0 s1 x5_im_a4 0 46225.9823
Gr6_re_1_4 0 s1 x6_re_a4 0 -1060.10025
Gr6_im_1_4 0 s1 x6_im_a4 0 -2206.224552
Gr7_re_1_4 0 s1 x7_re_a4 0 -15908.90283
Gr7_im_1_4 0 s1 x7_im_a4 0 28679.57045
Gr8_re_1_4 0 s1 x8_re_a4 0 -95531.13067
Gr8_im_1_4 0 s1 x8_im_a4 0 -8205.671712
Gr9_re_1_4 0 s1 x9_re_a4 0 -25626.54525
Gr9_im_1_4 0 s1 x9_im_a4 0 -38320.4206
Gr10_re_1_4 0 s1 x10_re_a4 0 -231449.4261
Gr10_im_1_4 0 s1 x10_im_a4 0 -49197.67403
Gr11_re_1_4 0 s1 x11_re_a4 0 -47705.83832
Gr11_im_1_4 0 s1 x11_im_a4 0 300040.7416
Gr12_re_1_4 0 s1 x12_re_a4 0 280786.826
Gr12_im_1_4 0 s1 x12_im_a4 0 -80358.52818
Gd1_5 0 s1 p5 0 0.0001853951559
Fd1_5 0 s1 V5 0.009269757795
Gr1_1_5 0 s1 x1_a5 0 0.0613168684
Gr2_re_1_5 0 s1 x2_re_a5 0 35590.06225
Gr2_im_1_5 0 s1 x2_im_a5 0 26938.38918
Gr3_re_1_5 0 s1 x3_re_a5 0 11396.23964
Gr3_im_1_5 0 s1 x3_im_a5 0 5073.028934
Gr4_re_1_5 0 s1 x4_re_a5 0 10698.70313
Gr4_im_1_5 0 s1 x4_im_a5 0 -54984.47026
Gr5_re_1_5 0 s1 x5_re_a5 0 -25488.86651
Gr5_im_1_5 0 s1 x5_im_a5 0 51672.98079
Gr6_re_1_5 0 s1 x6_re_a5 0 1816.027341
Gr6_im_1_5 0 s1 x6_im_a5 0 3632.419898
Gr7_re_1_5 0 s1 x7_re_a5 0 -25765.63398
Gr7_im_1_5 0 s1 x7_im_a5 0 -5111.506342
Gr8_re_1_5 0 s1 x8_re_a5 0 5000.967047
Gr8_im_1_5 0 s1 x8_im_a5 0 -68265.21386
Gr9_re_1_5 0 s1 x9_re_a5 0 25142.73585
Gr9_im_1_5 0 s1 x9_im_a5 0 -15774.38585
Gr10_re_1_5 0 s1 x10_re_a5 0 -10759.35477
Gr10_im_1_5 0 s1 x10_im_a5 0 -212716.5238
Gr11_re_1_5 0 s1 x11_re_a5 0 -245241.0839
Gr11_im_1_5 0 s1 x11_im_a5 0 -16709.68002
Gr12_re_1_5 0 s1 x12_re_a5 0 102558.8698
Gr12_im_1_5 0 s1 x12_im_a5 0 219126.2741
Gd1_6 0 s1 p6 0 -0.0004381172044
Fd1_6 0 s1 V6 -0.02190586022
Gr1_1_6 0 s1 x1_a6 0 0.06339389691
Gr2_re_1_6 0 s1 x2_re_a6 0 7050.726664
Gr2_im_1_6 0 s1 x2_im_a6 0 -64135.5883
Gr3_re_1_6 0 s1 x3_re_a6 0 16403.6517
Gr3_im_1_6 0 s1 x3_im_a6 0 -9148.15541
Gr4_re_1_6 0 s1 x4_re_a6 0 -94087.75308
Gr4_im_1_6 0 s1 x4_im_a6 0 10708.39232
Gr5_re_1_6 0 s1 x5_re_a6 0 72114.43173
Gr5_im_1_6 0 s1 x5_im_a6 0 46357.35989
Gr6_re_1_6 0 s1 x6_re_a6 0 -982.8935753
Gr6_im_1_6 0 s1 x6_im_a6 0 -2122.121674
Gr7_re_1_6 0 s1 x7_re_a6 0 -17684.40449
Gr7_im_1_6 0 s1 x7_im_a6 0 30852.51318
Gr8_re_1_6 0 s1 x8_re_a6 0 -91231.05915
Gr8_im_1_6 0 s1 x8_im_a6 0 -505.9772631
Gr9_re_1_6 0 s1 x9_re_a6 0 -32450.30157
Gr9_im_1_6 0 s1 x9_im_a6 0 -39197.10317
Gr10_re_1_6 0 s1 x10_re_a6 0 -237935.6738
Gr10_im_1_6 0 s1 x10_im_a6 0 -39212.47944
Gr11_re_1_6 0 s1 x11_re_a6 0 -22238.95586
Gr11_im_1_6 0 s1 x11_im_a6 0 305589.2562
Gr12_re_1_6 0 s1 x12_re_a6 0 287081.121
Gr12_im_1_6 0 s1 x12_im_a6 0 -107239.9008
Gd1_7 0 s1 p7 0 -7.04534631e-05
Fd1_7 0 s1 V7 -0.003522673155
Gr1_1_7 0 s1 x1_a7 0 -0.003806371451
Gr2_re_1_7 0 s1 x2_re_a7 0 -11481.61033
Gr2_im_1_7 0 s1 x2_im_a7 0 -14525.63704
Gr3_re_1_7 0 s1 x3_re_a7 0 -1098.285965
Gr3_im_1_7 0 s1 x3_im_a7 0 354.4162828
Gr4_re_1_7 0 s1 x4_re_a7 0 -8427.251296
Gr4_im_1_7 0 s1 x4_im_a7 0 22135.76924
Gr5_re_1_7 0 s1 x5_re_a7 0 8685.126127
Gr5_im_1_7 0 s1 x5_im_a7 0 -8935.772374
Gr6_re_1_7 0 s1 x6_re_a7 0 -901.6477395
Gr6_im_1_7 0 s1 x6_im_a7 0 -5458.818638
Gr7_re_1_7 0 s1 x7_re_a7 0 13680.18002
Gr7_im_1_7 0 s1 x7_im_a7 0 7573.120626
Gr8_re_1_7 0 s1 x8_re_a7 0 137.9958117
Gr8_im_1_7 0 s1 x8_im_a7 0 17008.6075
Gr9_re_1_7 0 s1 x9_re_a7 0 -27226.70876
Gr9_im_1_7 0 s1 x9_im_a7 0 -17798.28795
Gr10_re_1_7 0 s1 x10_re_a7 0 -32816.39926
Gr10_im_1_7 0 s1 x10_im_a7 0 131345.4432
Gr11_re_1_7 0 s1 x11_re_a7 0 45997.57422
Gr11_im_1_7 0 s1 x11_im_a7 0 58686.12712
Gr12_re_1_7 0 s1 x12_re_a7 0 -32404.92348
Gr12_im_1_7 0 s1 x12_im_a7 0 -89015.59223
Cx1_a1 x1_a1 0 3.599252385e-12
Gx1_a1 0 x1_a1 p1 0 0.0203414435
Fx1_a1 0 x1_a1 V1 1.017072175
Rp1_a1 0 x1_a1 1
Cx2_re_a1 x2_re_a1 0 5.856437181e-12
Gx2_re_a1 0 x2_re_a1 p1 0 3.459787709e-08
Fx2_re_a1 0 x2_re_a1 V1 1.729893854e-06
Rp2_re_re_a1 0 x2_re_a1 1
Gp2_re_im_a1 0 x2_re_a1 x2_im_a1 0 8.993009352
Cx2_im_a1 x2_im_a1 0 5.856437181e-12
Gp2_im_re_a1 0 x2_im_a1 x2_re_a1 0 -8.993009352
Rp2_im_im_a1 0 x2_im_a1 1
Cx3_re_a1 x3_re_a1 0 3.515400992e-12
Gx3_re_a1 0 x3_re_a1 p1 0 4.495928338e-08
Fx3_re_a1 0 x3_re_a1 V1 2.247964169e-06
Rp3_re_re_a1 0 x3_re_a1 1
Gp3_re_im_a1 0 x3_re_a1 x3_im_a1 0 1.725264232
Cx3_im_a1 x3_im_a1 0 3.515400992e-12
Gp3_im_re_a1 0 x3_im_a1 x3_re_a1 0 -1.725264232
Rp3_im_im_a1 0 x3_im_a1 1
Cx4_re_a1 x4_re_a1 0 3.685452367e-12
Gx4_re_a1 0 x4_re_a1 p1 0 5.047534375e-08
Fx4_re_a1 0 x4_re_a1 V1 2.523767188e-06
Rp4_re_re_a1 0 x4_re_a1 1
Gp4_re_im_a1 0 x4_re_a1 x4_im_a1 0 5.132870892
Cx4_im_a1 x4_im_a1 0 3.685452367e-12
Gp4_im_re_a1 0 x4_im_a1 x4_re_a1 0 -5.132870892
Rp4_im_im_a1 0 x4_im_a1 1
Cx5_re_a1 x5_re_a1 0 2.023593684e-12
Gx5_re_a1 0 x5_re_a1 p1 0 1.046439957e-07
Fx5_re_a1 0 x5_re_a1 V1 5.232199787e-06
Rp5_re_re_a1 0 x5_re_a1 1
Gp5_re_im_a1 0 x5_re_a1 x5_im_a1 0 1.938964343
Cx5_im_a1 x5_im_a1 0 2.023593684e-12
Gp5_im_re_a1 0 x5_im_a1 x5_re_a1 0 -1.938964343
Rp5_im_im_a1 0 x5_im_a1 1
Cx6_re_a1 x6_re_a1 0 1.536838407e-11
Gx6_re_a1 0 x6_re_a1 p1 0 1.15257765e-08
Fx6_re_a1 0 x6_re_a1 V1 5.762888248e-07
Rp6_re_re_a1 0 x6_re_a1 1
Gp6_re_im_a1 0 x6_re_a1 x6_im_a1 0 20.71158076
Cx6_im_a1 x6_im_a1 0 1.536838407e-11
Gp6_im_re_a1 0 x6_im_a1 x6_re_a1 0 -20.71158076
Rp6_im_im_a1 0 x6_im_a1 1
Cx7_re_a1 x7_re_a1 0 8.283721394e-12
Gx7_re_a1 0 x7_re_a1 p1 0 4.260172472e-08
Fx7_re_a1 0 x7_re_a1 V1 2.130086236e-06
Rp7_re_re_a1 0 x7_re_a1 1
Gp7_re_im_a1 0 x7_re_a1 x7_im_a1 0 7.243952262
Cx7_im_a1 x7_im_a1 0 8.283721394e-12
Gp7_im_re_a1 0 x7_im_a1 x7_re_a1 0 -7.243952262
Rp7_im_im_a1 0 x7_im_a1 1
Cx8_re_a1 x8_re_a1 0 6.26307816e-12
Gx8_re_a1 0 x8_re_a1 p1 0 1.106169706e-07
Fx8_re_a1 0 x8_re_a1 V1 5.530848529e-06
Rp8_re_re_a1 0 x8_re_a1 1
Gp8_re_im_a1 0 x8_re_a1 x8_im_a1 0 6.959167708
Cx8_im_a1 x8_im_a1 0 6.26307816e-12
Gp8_im_re_a1 0 x8_im_a1 x8_re_a1 0 -6.959167708
Rp8_im_im_a1 0 x8_im_a1 1
Cx9_re_a1 x9_re_a1 0 1.437227943e-11
Gx9_re_a1 0 x9_re_a1 p1 0 4.415359578e-08
Fx9_re_a1 0 x9_re_a1 V1 2.207679789e-06
Rp9_re_re_a1 0 x9_re_a1 1
Gp9_re_im_a1 0 x9_re_a1 x9_im_a1 0 16.64222601
Cx9_im_a1 x9_im_a1 0 1.437227943e-11
Gp9_im_re_a1 0 x9_im_a1 x9_re_a1 0 -16.64222601
Rp9_im_im_a1 0 x9_im_a1 1
Cx10_re_a1 x10_re_a1 0 3.091922882e-11
Gx10_re_a1 0 x10_re_a1 p1 0 4.004701625e-08
Fx10_re_a1 0 x10_re_a1 V1 2.002350812e-06
Rp10_re_re_a1 0 x10_re_a1 1
Gp10_re_im_a1 0 x10_re_a1 x10_im_a1 0 28.86213401
Cx10_im_a1 x10_im_a1 0 3.091922882e-11
Gp10_im_re_a1 0 x10_im_a1 x10_re_a1 0 -28.86213401
Rp10_im_im_a1 0 x10_im_a1 1
Cx11_re_a1 x11_re_a1 0 2.197240297e-11
Gx11_re_a1 0 x11_re_a1 p1 0 4.896291693e-08
Fx11_re_a1 0 x11_re_a1 V1 2.448145847e-06
Rp11_re_re_a1 0 x11_re_a1 1
Gp11_re_im_a1 0 x11_re_a1 x11_im_a1 0 23.68502501
Cx11_im_a1 x11_im_a1 0 2.197240297e-11
Gp11_im_re_a1 0 x11_im_a1 x11_re_a1 0 -23.68502501
Rp11_im_im_a1 0 x11_im_a1 1
Cx12_re_a1 x12_re_a1 0 2.154716074e-11
Gx12_re_a1 0 x12_re_a1 p1 0 5.684440998e-08
Fx12_re_a1 0 x12_re_a1 V1 2.842220499e-06
Rp12_re_re_a1 0 x12_re_a1 1
Gp12_re_im_a1 0 x12_re_a1 x12_im_a1 0 21.52683006
Cx12_im_a1 x12_im_a1 0 2.154716074e-11
Gp12_im_re_a1 0 x12_im_a1 x12_re_a1 0 -21.52683006
Rp12_im_im_a1 0 x12_im_a1 1
V2 p2 s2 0
R2 s2 0 50
Gd2_1 0 s2 p1 0 -7.452166041e-05
Fd2_1 0 s2 V1 -0.003726083021
Gr1_2_1 0 s2 x1_a1 0 -0.004857773792
Gr2_re_2_1 0 s2 x2_re_a1 0 -15169.08655
Gr2_im_2_1 0 s2 x2_im_a1 0 -16259.18928
Gr3_re_2_1 0 s2 x3_re_a1 0 -3338.906209
Gr3_im_2_1 0 s2 x3_im_a1 0 -1700.745387
Gr4_re_2_1 0 s2 x4_re_a1 0 -8008.148171
Gr4_im_2_1 0 s2 x4_im_a1 0 30395.25708
Gr5_re_2_1 0 s2 x5_re_a1 0 9257.610499
Gr5_im_2_1 0 s2 x5_im_a1 0 -8498.228423
Gr6_re_2_1 0 s2 x6_re_a1 0 -2587.47063
Gr6_im_2_1 0 s2 x6_im_a1 0 -10043.41841
Gr7_re_2_1 0 s2 x7_re_a1 0 17895.37918
Gr7_im_2_1 0 s2 x7_im_a1 0 6538.631446
Gr8_re_2_1 0 s2 x8_re_a1 0 1292.029116
Gr8_im_2_1 0 s2 x8_im_a1 0 8504.696622
Gr9_re_2_1 0 s2 x9_re_a1 0 -13582.37555
Gr9_im_2_1 0 s2 x9_im_a1 0 -7029.804871
Gr10_re_2_1 0 s2 x10_re_a1 0 -13819.65424
Gr10_im_2_1 0 s2 x10_im_a1 0 57546.93981
Gr11_re_2_1 0 s2 x11_re_a1 0 12802.227
Gr11_im_2_1 0 s2 x11_im_a1 0 26810.59847
Gr12_re_2_1 0 s2 x12_re_a1 0 -12607.0519
Gr12_im_2_1 0 s2 x12_im_a1 0 -31083.44008
Gd2_2 0 s2 p2 0 -0.001932797783
Fd2_2 0 s2 V2 -0.09663988917
Gr1_2_2 0 s2 x1_a2 0 -0.7230360985
Gr2_re_2_2 0 s2 x2_re_a2 0 23339.32221
Gr2_im_2_2 0 s2 x2_im_a2 0 209465.0619
Gr3_re_2_2 0 s2 x3_re_a2 0 -179031.8127
Gr3_im_2_2 0 s2 x3_im_a2 0 289715.2769
Gr4_re_2_2 0 s2 x4_re_a2 0 807095.9184
Gr4_im_2_2 0 s2 x4_im_a2 0 -377984.3709
Gr5_re_2_2 0 s2 x5_re_a2 0 -540660.1595
Gr5_im_2_2 0 s2 x5_im_a2 0 -325036.4249
Gr6_re_2_2 0 s2 x6_re_a2 0 -123463.2566
Gr6_im_2_2 0 s2 x6_im_a2 0 -152952.7026
Gr7_re_2_2 0 s2 x7_re_a2 0 -182285.9959
Gr7_im_2_2 0 s2 x7_im_a2 0 133585.8188
Gr8_re_2_2 0 s2 x8_re_a2 0 397529.3837
Gr8_im_2_2 0 s2 x8_im_a2 0 -567930.9156
Gr9_re_2_2 0 s2 x9_re_a2 0 36171.64828
Gr9_im_2_2 0 s2 x9_im_a2 0 311780.2399
Gr10_re_2_2 0 s2 x10_re_a2 0 -37771.08892
Gr10_im_2_2 0 s2 x10_im_a2 0 -94056.42083
Gr11_re_2_2 0 s2 x11_re_a2 0 -195760.0647
Gr11_im_2_2 0 s2 x11_im_a2 0 96702.29066
Gr12_re_2_2 0 s2 x12_re_a2 0 -116962.8722
Gr12_im_2_2 0 s2 x12_im_a2 0 -110997.9702
Gd2_3 0 s2 p3 0 0.0004531967918
Fd2_3 0 s2 V3 0.02265983959
Gr1_2_3 0 s2 x1_a3 0 0.2341360609
Gr2_re_2_3 0 s2 x2_re_a3 0 215062.4809
Gr2_im_2_3 0 s2 x2_im_a3 0 -298042.6948
Gr3_re_2_3 0 s2 x3_re_a3 0 75196.23536
Gr3_im_2_3 0 s2 x3_im_a3 0 -255075.0643
Gr4_re_2_3 0 s2 x4_re_a3 0 83414.76031
Gr4_im_2_3 0 s2 x4_im_a3 0 -301871.8653
Gr5_re_2_3 0 s2 x5_re_a3 0 -240361.7308
Gr5_im_2_3 0 s2 x5_im_a3 0 445979.099
Gr6_re_2_3 0 s2 x6_re_a3 0 -19898.2906
Gr6_im_2_3 0 s2 x6_im_a3 0 103132.3122
Gr7_re_2_3 0 s2 x7_re_a3 0 77281.23806
Gr7_im_2_3 0 s2 x7_im_a3 0 -222106.7549
Gr8_re_2_3 0 s2 x8_re_a3 0 123485.024
Gr8_im_2_3 0 s2 x8_im_a3 0 -127117.9216
Gr9_re_2_3 0 s2 x9_re_a3 0 69149.12657
Gr9_im_2_3 0 s2 x9_im_a3 0 102858.7472
Gr10_re_2_3 0 s2 x10_re_a3 0 18574.42398
Gr10_im_2_3 0 s2 x10_im_a3 0 4364.345373
Gr11_re_2_3 0 s2 x11_re_a3 0 357.7990401
Gr11_im_2_3 0 s2 x11_im_a3 0 2628.709962
Gr12_re_2_3 0 s2 x12_re_a3 0 8647.859241
Gr12_im_2_3 0 s2 x12_im_a3 0 -13481.03914
Gd2_4 0 s2 p4 0 -0.001469674238
Fd2_4 0 s2 V4 -0.07348371191
Gr1_2_4 0 s2 x1_a4 0 0.03632923937
Gr2_re_2_4 0 s2 x2_re_a4 0 -184924.12
Gr2_im_2_4 0 s2 x2_im_a4 0 167922.7745
Gr3_re_2_4 0 s2 x3_re_a4 0 -33503.55955
Gr3_im_2_4 0 s2 x3_im_a4 0 -253181.7109
Gr4_re_2_4 0 s2 x4_re_a4 0 -89691.69685
Gr4_im_2_4 0 s2 x4_im_a4 0 197571.1286
Gr5_re_2_4 0 s2 x5_re_a4 0 212179.4835
Gr5_im_2_4 0 s2 x5_im_a4 0 139377.443
Gr6_re_2_4 0 s2 x6_re_a4 0 76206.21518
Gr6_im_2_4 0 s2 x6_im_a4 0 -86807.87776
Gr7_re_2_4 0 s2 x7_re_a4 0 -80640.90575
Gr7_im_2_4 0 s2 x7_im_a4 0 -182464.0349
Gr8_re_2_4 0 s2 x8_re_a4 0 -78851.05995
Gr8_im_2_4 0 s2 x8_im_a4 0 63985.06126
Gr9_re_2_4 0 s2 x9_re_a4 0 58697.64043
Gr9_im_2_4 0 s2 x9_im_a4 0 -86933.91671
Gr10_re_2_4 0 s2 x10_re_a4 0 65975.45835
Gr10_im_2_4 0 s2 x10_im_a4 0 -17245.76444
Gr11_re_2_4 0 s2 x11_re_a4 0 -29847.06209
Gr11_im_2_4 0 s2 x11_im_a4 0 -34222.59914
Gr12_re_2_4 0 s2 x12_re_a4 0 24708.35094
Gr12_im_2_4 0 s2 x12_im_a4 0 -77364.44494
Gd2_5 0 s2 p5 0 -0.001186048763
Fd2_5 0 s2 V5 -0.05930243815
Gr1_2_5 0 s2 x1_a5 0 0.6178800977
Gr2_re_2_5 0 s2 x2_re_a5 0 -8714.362908
Gr2_im_2_5 0 s2 x2_im_a5 0 -168239.8886
Gr3_re_2_5 0 s2 x3_re_a5 0 -11232.52987
Gr3_im_2_5 0 s2 x3_im_a5 0 -234338.5979
Gr4_re_2_5 0 s2 x4_re_a5 0 -551870.7826
Gr4_im_2_5 0 s2 x4_im_a5 0 64598.72542
Gr5_re_2_5 0 s2 x5_re_a5 0 272116.9338
Gr5_im_2_5 0 s2 x5_im_a5 0 481020.9506
Gr6_re_2_5 0 s2 x6_re_a5 0 38774.70074
Gr6_im_2_5 0 s2 x6_im_a5 0 127247.4808
Gr7_re_2_5 0 s2 x7_re_a5 0 165609.7366
Gr7_im_2_5 0 s2 x7_im_a5 0 -97614.40878
Gr8_re_2_5 0 s2 x8_re_a5 0 138981.3329
Gr8_im_2_5 0 s2 x8_im_a5 0 -26753.4578
Gr9_re_2_5 0 s2 x9_re_a5 0 27640.92543
Gr9_im_2_5 0 s2 x9_im_a5 0 -14477.5432
Gr10_re_2_5 0 s2 x10_re_a5 0 63819.6434
Gr10_im_2_5 0 s2 x10_im_a5 0 67208.25663
Gr11_re_2_5 0 s2 x11_re_a5 0 42996.02757
Gr11_im_2_5 0 s2 x11_im_a5 0 -67565.94103
Gr12_re_2_5 0 s2 x12_re_a5 0 105426.3596
Gr12_im_2_5 0 s2 x12_im_a5 0 3437.230546
Gd2_6 0 s2 p6 0 0.000615231747
Fd2_6 0 s2 V6 0.03076158735
Gr1_2_6 0 s2 x1_a6 0 -0.05553364101
Gr2_re_2_6 0 s2 x2_re_a6 0 134651.4757
Gr2_im_2_6 0 s2 x2_im_a6 0 -51304.37539
Gr3_re_2_6 0 s2 x3_re_a6 0 -170785.24
Gr3_im_2_6 0 s2 x3_im_a6 0 -165369.8191
Gr4_re_2_6 0 s2 x4_re_a6 0 185531.6772
Gr4_im_2_6 0 s2 x4_im_a6 0 -172240.8728
Gr5_re_2_6 0 s2 x5_re_a6 0 -94454.41548
Gr5_im_2_6 0 s2 x5_im_a6 0 44023.33219
Gr6_re_2_6 0 s2 x6_re_a6 0 72536.62424
Gr6_im_2_6 0 s2 x6_im_a6 0 -81297.53961
Gr7_re_2_6 0 s2 x7_re_a6 0 -85963.78028
Gr7_im_2_6 0 s2 x7_im_a6 0 -234677.5331
Gr8_re_2_6 0 s2 x8_re_a6 0 137380.7526
Gr8_im_2_6 0 s2 x8_im_a6 0 13324.83218
Gr9_re_2_6 0 s2 x9_re_a6 0 41393.77903
Gr9_im_2_6 0 s2 x9_im_a6 0 -97909.47632
Gr10_re_2_6 0 s2 x10_re_a6 0 55177.81483
Gr10_im_2_6 0 s2 x10_im_a6 0 -18238.64348
Gr11_re_2_6 0 s2 x11_re_a6 0 -15322.35912
Gr11_im_2_6 0 s2 x11_im_a6 0 -50069.98157
Gr12_re_2_6 0 s2 x12_re_a6 0 23277.49018
Gr12_im_2_6 0 s2 x12_im_a6 0 -46795.69313
Gd2_7 0 s2 p7 0 0.003979981604
Fd2_7 0 s2 V7 0.1989990802
Gr1_2_7 0 s2 x1_a7 0 -0.6856754721
Gr2_re_2_7 0 s2 x2_re_a7 0 -30238.85315
Gr2_im_2_7 0 s2 x2_im_a7 0 432875.6793
Gr3_re_2_7 0 s2 x3_re_a7 0 -258947.1989
Gr3_im_2_7 0 s2 x3_im_a7 0 276790.1047
Gr4_re_2_7 0 s2 x4_re_a7 0 523152.627
Gr4_im_2_7 0 s2 x4_im_a7 0 -94916.12944
Gr5_re_2_7 0 s2 x5_re_a7 0 -510510.8487
Gr5_im_2_7 0 s2 x5_im_a7 0 -933684.8034
Gr6_re_2_7 0 s2 x6_re_a7 0 -42992.43102
Gr6_im_2_7 0 s2 x6_im_a7 0 -153870.4266
Gr7_re_2_7 0 s2 x7_re_a7 0 -135686.2374
Gr7_im_2_7 0 s2 x7_im_a7 0 166365.595
Gr8_re_2_7 0 s2 x8_re_a7 0 604649.4732
Gr8_im_2_7 0 s2 x8_im_a7 0 230274.7742
Gr9_re_2_7 0 s2 x9_re_a7 0 -121176.7406
Gr9_im_2_7 0 s2 x9_im_a7 0 57606.37385
Gr10_re_2_7 0 s2 x10_re_a7 0 -27686.96304
Gr10_im_2_7 0 s2 x10_im_a7 0 -20656.4857
Gr11_re_2_7 0 s2 x11_re_a7 0 -37646.21594
Gr11_im_2_7 0 s2 x11_im_a7 0 -45978.67866
Gr12_re_2_7 0 s2 x12_re_a7 0 -9138.44418
Gr12_im_2_7 0 s2 x12_im_a7 0 13059.85612
Cx1_a2 x1_a2 0 3.599252385e-12
Gx1_a2 0 x1_a2 p2 0 0.01446072197
Fx1_a2 0 x1_a2 V2 0.7230360985
Rp1_a2 0 x1_a2 1
Cx2_re_a2 x2_re_a2 0 5.856437181e-12
Gx2_re_a2 0 x2_re_a2 p2 0 3.17993977e-08
Fx2_re_a2 0 x2_re_a2 V2 1.589969885e-06
Rp2_re_re_a2 0 x2_re_a2 1
Gp2_re_im_a2 0 x2_re_a2 x2_im_a2 0 8.993009352
Cx2_im_a2 x2_im_a2 0 5.856437181e-12
Gp2_im_re_a2 0 x2_im_a2 x2_re_a2 0 -8.993009352
Rp2_im_im_a2 0 x2_im_a2 1
Cx3_re_a2 x3_re_a2 0 3.515400992e-12
Gx3_re_a2 0 x3_re_a2 p2 0 8.091194545e-08
Fx3_re_a2 0 x3_re_a2 V2 4.045597272e-06
Rp3_re_re_a2 0 x3_re_a2 1
Gp3_re_im_a2 0 x3_re_a2 x3_im_a2 0 1.725264232
Cx3_im_a2 x3_im_a2 0 3.515400992e-12
Gp3_im_re_a2 0 x3_im_a2 x3_re_a2 0 -1.725264232
Rp3_im_im_a2 0 x3_im_a2 1
Cx4_re_a2 x4_re_a2 0 3.685452367e-12
Gx4_re_a2 0 x4_re_a2 p2 0 5.742400837e-08
Fx4_re_a2 0 x4_re_a2 V2 2.871200419e-06
Rp4_re_re_a2 0 x4_re_a2 1
Gp4_re_im_a2 0 x4_re_a2 x4_im_a2 0 5.132870892
Cx4_im_a2 x4_im_a2 0 3.685452367e-12
Gp4_im_re_a2 0 x4_im_a2 x4_re_a2 0 -5.132870892
Rp4_im_im_a2 0 x4_im_a2 1
Cx5_re_a2 x5_re_a2 0 2.023593684e-12
Gx5_re_a2 0 x5_re_a2 p2 0 1.046992888e-07
Fx5_re_a2 0 x5_re_a2 V2 5.234964439e-06
Rp5_re_re_a2 0 x5_re_a2 1
Gp5_re_im_a2 0 x5_re_a2 x5_im_a2 0 1.938964343
Cx5_im_a2 x5_im_a2 0 2.023593684e-12
Gp5_im_re_a2 0 x5_im_a2 x5_re_a2 0 -1.938964343
Rp5_im_im_a2 0 x5_im_a2 1
Cx6_re_a2 x6_re_a2 0 1.536838407e-11
Gx6_re_a2 0 x6_re_a2 p2 0 1.903914016e-08
Fx6_re_a2 0 x6_re_a2 V2 9.51957008e-07
Rp6_re_re_a2 0 x6_re_a2 1
Gp6_re_im_a2 0 x6_re_a2 x6_im_a2 0 20.71158076
Cx6_im_a2 x6_im_a2 0 1.536838407e-11
Gp6_im_re_a2 0 x6_im_a2 x6_re_a2 0 -20.71158076
Rp6_im_im_a2 0 x6_im_a2 1
Cx7_re_a2 x7_re_a2 0 8.283721394e-12
Gx7_re_a2 0 x7_re_a2 p2 0 5.120769189e-08
Fx7_re_a2 0 x7_re_a2 V2 2.560384595e-06
Rp7_re_re_a2 0 x7_re_a2 1
Gp7_re_im_a2 0 x7_re_a2 x7_im_a2 0 7.243952262
Cx7_im_a2 x7_im_a2 0 8.283721394e-12
Gp7_im_re_a2 0 x7_im_a2 x7_re_a2 0 -7.243952262
Rp7_im_im_a2 0 x7_im_a2 1
Cx8_re_a2 x8_re_a2 0 6.26307816e-12
Gx8_re_a2 0 x8_re_a2 p2 0 7.471015492e-08
Fx8_re_a2 0 x8_re_a2 V2 3.735507746e-06
Rp8_re_re_a2 0 x8_re_a2 1
Gp8_re_im_a2 0 x8_re_a2 x8_im_a2 0 6.959167708
Cx8_im_a2 x8_im_a2 0 6.26307816e-12
Gp8_im_re_a2 0 x8_im_a2 x8_re_a2 0 -6.959167708
Rp8_im_im_a2 0 x8_im_a2 1
Cx9_re_a2 x9_re_a2 0 1.437227943e-11
Gx9_re_a2 0 x9_re_a2 p2 0 2.393005985e-08
Fx9_re_a2 0 x9_re_a2 V2 1.196502992e-06
Rp9_re_re_a2 0 x9_re_a2 1
Gp9_re_im_a2 0 x9_re_a2 x9_im_a2 0 16.64222601
Cx9_im_a2 x9_im_a2 0 1.437227943e-11
Gp9_im_re_a2 0 x9_im_a2 x9_re_a2 0 -16.64222601
Rp9_im_im_a2 0 x9_im_a2 1
Cx10_re_a2 x10_re_a2 0 3.091922882e-11
Gx10_re_a2 0 x10_re_a2 p2 0 1.843852819e-08
Fx10_re_a2 0 x10_re_a2 V2 9.219264094e-07
Rp10_re_re_a2 0 x10_re_a2 1
Gp10_re_im_a2 0 x10_re_a2 x10_im_a2 0 28.86213401
Cx10_im_a2 x10_im_a2 0 3.091922882e-11
Gp10_im_re_a2 0 x10_im_a2 x10_re_a2 0 -28.86213401
Rp10_im_im_a2 0 x10_im_a2 1
Cx11_re_a2 x11_re_a2 0 2.197240297e-11
Gx11_re_a2 0 x11_re_a2 p2 0 2.132093053e-08
Fx11_re_a2 0 x11_re_a2 V2 1.066046527e-06
Rp11_re_re_a2 0 x11_re_a2 1
Gp11_re_im_a2 0 x11_re_a2 x11_im_a2 0 23.68502501
Cx11_im_a2 x11_im_a2 0 2.197240297e-11
Gp11_im_re_a2 0 x11_im_a2 x11_re_a2 0 -23.68502501
Rp11_im_im_a2 0 x11_im_a2 1
Cx12_re_a2 x12_re_a2 0 2.154716074e-11
Gx12_re_a2 0 x12_re_a2 p2 0 2.318815446e-08
Fx12_re_a2 0 x12_re_a2 V2 1.159407723e-06
Rp12_re_re_a2 0 x12_re_a2 1
Gp12_re_im_a2 0 x12_re_a2 x12_im_a2 0 21.52683006
Cx12_im_a2 x12_im_a2 0 2.154716074e-11
Gp12_im_re_a2 0 x12_im_a2 x12_re_a2 0 -21.52683006
Rp12_im_im_a2 0 x12_im_a2 1
V3 p3 s3 0
R3 s3 0 50
Gd3_1 0 s3 p1 0 0.000194675043
Fd3_1 0 s3 V1 0.00973375215
Gr1_3_1 0 s3 x1_a1 0 0.04103337091
Gr2_re_3_1 0 s3 x2_re_a1 0 41084.04229
Gr2_im_3_1 0 s3 x2_im_a1 0 30763.49658
Gr3_re_3_1 0 s3 x3_re_a1 0 18388.78033
Gr3_im_3_1 0 s3 x3_im_a1 0 8193.901595
Gr4_re_3_1 0 s3 x4_re_a1 0 25981.68389
Gr4_im_3_1 0 s3 x4_im_a1 0 -79216.72342
Gr5_re_3_1 0 s3 x5_re_a1 0 -27559.47199
Gr5_im_3_1 0 s3 x5_im_a1 0 43284.14002
Gr6_re_3_1 0 s3 x6_re_a1 0 2889.634753
Gr6_im_3_1 0 s3 x6_im_a1 0 5515.864552
Gr7_re_3_1 0 s3 x7_re_a1 0 -47047.48432
Gr7_im_3_1 0 s3 x7_im_a1 0 -13415.52881
Gr8_re_3_1 0 s3 x8_re_a1 0 13044.00004
Gr8_im_3_1 0 s3 x8_im_a1 0 -63289.96287
Gr9_re_3_1 0 s3 x9_re_a1 0 23918.20063
Gr9_im_3_1 0 s3 x9_im_a1 0 -8666.408797
Gr10_re_3_1 0 s3 x10_re_a1 0 -3148.989347
Gr10_im_3_1 0 s3 x10_im_a1 0 -154895.3935
Gr11_re_3_1 0 s3 x11_re_a1 0 -204466.1779
Gr11_im_3_1 0 s3 x11_im_a1 0 -28264.35498
Gr12_re_3_1 0 s3 x12_re_a1 0 61713.05701
Gr12_im_3_1 0 s3 x12_im_a1 0 153016.6918
Gd3_2 0 s3 p2 0 0.0004531967915
Fd3_2 0 s3 V2 0.02265983958
Gr1_3_2 0 s3 x1_a2 0 0.2458308523
Gr2_re_3_2 0 s3 x2_re_a2 0 257888.7793
Gr2_im_3_2 0 s3 x2_im_a2 0 -357393.193
Gr3_re_3_2 0 s3 x3_re_a2 0 88880.97952
Gr3_im_3_2 0 s3 x3_im_a2 0 -301495.4334
Gr4_re_3_2 0 s3 x4_re_a2 0 109494.223
Gr4_im_3_2 0 s3 x4_im_a2 0 -396251.5171
Gr5_re_3_2 0 s3 x5_re_a2 0 -212083.6909
Gr5_im_3_2 0 s3 x5_im_a2 0 393510.6186
Gr6_re_3_2 0 s3 x6_re_a2 0 -31744.91487
Gr6_im_3_2 0 s3 x6_im_a2 0 164533.0514
Gr7_re_3_2 0 s3 x7_re_a2 0 115823.4687
Gr7_im_3_2 0 s3 x7_im_a2 0 -332877.3635
Gr8_re_3_2 0 s3 x8_re_a2 0 157125.8679
Gr8_im_3_2 0 s3 x8_im_a2 0 -161748.4704
Gr9_re_3_2 0 s3 x9_re_a2 0 114070.8157
Gr9_im_3_2 0 s3 x9_im_a2 0 169679.3839
Gr10_re_3_2 0 s3 x10_re_a2 0 30158.65289
Gr10_im_3_2 0 s3 x10_im_a2 0 7086.237328
Gr11_re_3_2 0 s3 x11_re_a2 0 706.360447
Gr11_im_3_2 0 s3 x11_im_a2 0 5189.552101
Gr12_re_3_2 0 s3 x12_re_a2 0 15744.65865
Gr12_im_3_2 0 s3 x12_im_a2 0 -24544.15058
Gd3_3 0 s3 p3 0 -0.004571093768
Fd3_3 0 s3 V3 -0.2285546884
Gr1_3_3 0 s3 x1_a3 0 -0.7591508104
Gr2_re_3_3 0 s3 x2_re_a3 0 192820.1192
Gr2_im_3_3 0 s3 x2_im_a3 0 645078.3143
Gr3_re_3_3 0 s3 x3_re_a3 0 260004.9669
Gr3_im_3_3 0 s3 x3_im_a3 0 -102069.8405
Gr4_re_3_3 0 s3 x4_re_a3 0 624309.9475
Gr4_im_3_3 0 s3 x4_im_a3 0 -717449.9592
Gr5_re_3_3 0 s3 x5_re_a3 0 -487601.8395
Gr5_im_3_3 0 s3 x5_im_a3 0 584580.867
Gr6_re_3_3 0 s3 x6_re_a3 0 -201909.7559
Gr6_im_3_3 0 s3 x6_im_a3 0 -288422.2819
Gr7_re_3_3 0 s3 x7_re_a3 0 -304347.4503
Gr7_im_3_3 0 s3 x7_im_a3 0 89395.35918
Gr8_re_3_3 0 s3 x8_re_a3 0 60213.60501
Gr8_im_3_3 0 s3 x8_im_a3 0 -1106857.078
Gr9_re_3_3 0 s3 x9_re_a3 0 -14796.72892
Gr9_im_3_3 0 s3 x9_im_a3 0 515564.6146
Gr10_re_3_3 0 s3 x10_re_a3 0 -170823.4536
Gr10_im_3_3 0 s3 x10_im_a3 0 -169181.1361
Gr11_re_3_3 0 s3 x11_re_a3 0 -170860.6389
Gr11_im_3_3 0 s3 x11_im_a3 0 313406.3969
Gr12_re_3_3 0 s3 x12_re_a3 0 -336544.4556
Gr12_im_3_3 0 s3 x12_im_a3 0 -37293.30694
Gd3_4 0 s3 p4 0 0.001584594537
Fd3_4 0 s3 V4 0.07922972684
Gr1_3_4 0 s3 x1_a4 0 -0.6083208378
Gr2_re_3_4 0 s3 x2_re_a4 0 108444.8809
Gr2_im_3_4 0 s3 x2_im_a4 0 -324102.5447
Gr3_re_3_4 0 s3 x3_re_a4 0 187800.2082
Gr3_im_3_4 0 s3 x3_im_a4 0 -179126.4269
Gr4_re_3_4 0 s3 x4_re_a4 0 -189898.1896
Gr4_im_3_4 0 s3 x4_im_a4 0 -174669.7588
Gr5_re_3_4 0 s3 x5_re_a4 0 -180029.3107
Gr5_im_3_4 0 s3 x5_im_a4 0 -156068.4315
Gr6_re_3_4 0 s3 x6_re_a4 0 -149947.1248
Gr6_im_3_4 0 s3 x6_im_a4 0 207859.4651
Gr7_re_3_4 0 s3 x7_re_a4 0 119210.1922
Gr7_im_3_4 0 s3 x7_im_a4 0 222588.8935
Gr8_re_3_4 0 s3 x8_re_a4 0 89073.47155
Gr8_im_3_4 0 s3 x8_im_a4 0 65751.04795
Gr9_re_3_4 0 s3 x9_re_a4 0 171907.5744
Gr9_im_3_4 0 s3 x9_im_a4 0 307052.0236
Gr10_re_3_4 0 s3 x10_re_a4 0 -106048.8387
Gr10_im_3_4 0 s3 x10_im_a4 0 49586.7742
Gr11_re_3_4 0 s3 x11_re_a4 0 134342.7419
Gr11_im_3_4 0 s3 x11_im_a4 0 47076.57319
Gr12_re_3_4 0 s3 x12_re_a4 0 -9572.872462
Gr12_im_3_4 0 s3 x12_im_a4 0 172685.7466
Gd3_5 0 s3 p5 0 -0.0002116452028
Fd3_5 0 s3 V5 -0.01058226014
Gr1_3_5 0 s3 x1_a5 0 0.492983949
Gr2_re_3_5 0 s3 x2_re_a5 0 132236.7664
Gr2_im_3_5 0 s3 x2_im_a5 0 496846.2852
Gr3_re_3_5 0 s3 x3_re_a5 0 -352894.3377
Gr3_im_3_5 0 s3 x3_im_a5 0 312131.4743
Gr4_re_3_5 0 s3 x4_re_a5 0 -86948.53184
Gr4_im_3_5 0 s3 x4_im_a5 0 93331.51059
Gr5_re_3_5 0 s3 x5_re_a5 0 230515.573
Gr5_im_3_5 0 s3 x5_im_a5 0 -698006.63
Gr6_re_3_5 0 s3 x6_re_a5 0 -20884.09721
Gr6_im_3_5 0 s3 x6_im_a5 0 -167743.7015
Gr7_re_3_5 0 s3 x7_re_a5 0 -38748.91661
Gr7_im_3_5 0 s3 x7_im_a5 0 432895.5541
Gr8_re_3_5 0 s3 x8_re_a5 0 -169152.0704
Gr8_im_3_5 0 s3 x8_im_a5 0 285140.7925
Gr9_re_3_5 0 s3 x9_re_a5 0 -177136.404
Gr9_im_3_5 0 s3 x9_im_a5 0 -73339.79198
Gr10_re_3_5 0 s3 x10_re_a5 0 -61952.54981
Gr10_im_3_5 0 s3 x10_im_a5 0 94687.28873
Gr11_re_3_5 0 s3 x11_re_a5 0 120656.4051
Gr11_im_3_5 0 s3 x11_im_a5 0 38481.67794
Gr12_re_3_5 0 s3 x12_re_a5 0 16234.3872
Gr12_im_3_5 0 s3 x12_im_a5 0 177744.9676
Gd3_6 0 s3 p6 0 -0.0001403675507
Fd3_6 0 s3 V6 -0.007018377536
Gr1_3_6 0 s3 x1_a6 0 0.3429874958
Gr2_re_3_6 0 s3 x2_re_a6 0 90576.387
Gr2_im_3_6 0 s3 x2_im_a6 0 -659968.3318
Gr3_re_3_6 0 s3 x3_re_a6 0 -317377.5076
Gr3_im_3_6 0 s3 x3_im_a6 0 228338.2835
Gr4_re_3_6 0 s3 x4_re_a6 0 -767347.1096
Gr4_im_3_6 0 s3 x4_im_a6 0 425324.4257
Gr5_re_3_6 0 s3 x5_re_a6 0 377187.3004
Gr5_im_3_6 0 s3 x5_im_a6 0 -522238.324
Gr6_re_3_6 0 s3 x6_re_a6 0 -25628.69594
Gr6_im_3_6 0 s3 x6_im_a6 0 329832.1263
Gr7_re_3_6 0 s3 x7_re_a6 0 357796.1735
Gr7_im_3_6 0 s3 x7_im_a6 0 472664.4786
Gr8_re_3_6 0 s3 x8_re_a6 0 -468881.1258
Gr8_im_3_6 0 s3 x8_im_a6 0 879917.1257
Gr9_re_3_6 0 s3 x9_re_a6 0 177686.4212
Gr9_im_3_6 0 s3 x9_im_a6 0 -86434.66823
Gr10_re_3_6 0 s3 x10_re_a6 0 -9346.082172
Gr10_im_3_6 0 s3 x10_im_a6 0 204690.2049
Gr11_re_3_6 0 s3 x11_re_a6 0 324264.1889
Gr11_im_3_6 0 s3 x11_im_a6 0 -102122.5095
Gr12_re_3_6 0 s3 x12_re_a6 0 226002.4502
Gr12_im_3_6 0 s3 x12_im_a6 0 268351.2011
Gd3_7 0 s3 p7 0 -0.001134031053
Fd3_7 0 s3 V7 -0.05670155265
Gr1_3_7 0 s3 x1_a7 0 0.6690092736
Gr2_re_3_7 0 s3 x2_re_a7 0 1527.607614
Gr2_im_3_7 0 s3 x2_im_a7 0 -176746.9685
Gr3_re_3_7 0 s3 x3_re_a7 0 -28984.04371
Gr3_im_3_7 0 s3 x3_im_a7 0 -260343.4243
Gr4_re_3_7 0 s3 x4_re_a7 0 -709964.5512
Gr4_im_3_7 0 s3 x4_im_a7 0 82456.92936
Gr5_re_3_7 0 s3 x5_re_a7 0 234997.9154
Gr5_im_3_7 0 s3 x5_im_a7 0 389542.7733
Gr6_re_3_7 0 s3 x6_re_a7 0 27859.22119
Gr6_im_3_7 0 s3 x6_im_a7 0 197634.9541
Gr7_re_3_7 0 s3 x7_re_a7 0 255695.2801
Gr7_im_3_7 0 s3 x7_im_a7 0 -127194.4342
Gr8_re_3_7 0 s3 x8_re_a7 0 177434.2796
Gr8_im_3_7 0 s3 x8_im_a7 0 -3981.429524
Gr9_re_3_7 0 s3 x9_re_a7 0 42264.22977
Gr9_im_3_7 0 s3 x9_im_a7 0 -33766.25609
Gr10_re_3_7 0 s3 x10_re_a7 0 104366.2742
Gr10_im_3_7 0 s3 x10_im_a7 0 113346.4972
Gr11_re_3_7 0 s3 x11_re_a7 0 94792.07996
Gr11_im_3_7 0 s3 x11_im_a7 0 -141643.0051
Gr12_re_3_7 0 s3 x12_re_a7 0 195141.6648
Gr12_im_3_7 0 s3 x12_im_a7 0 12758.56109
Cx1_a3 x1_a3 0 3.599252385e-12
Gx1_a3 0 x1_a3 p3 0 0.01518301621
Fx1_a3 0 x1_a3 V3 0.7591508104
Rp1_a3 0 x1_a3 1
Cx2_re_a3 x2_re_a3 0 5.856437181e-12
Gx2_re_a3 0 x2_re_a3 p3 0 3.813174581e-08
Fx2_re_a3 0 x2_re_a3 V3 1.906587291e-06
Rp2_re_re_a3 0 x2_re_a3 1
Gp2_re_im_a3 0 x2_re_a3 x2_im_a3 0 8.993009352
Cx2_im_a3 x2_im_a3 0 5.856437181e-12
Gp2_im_re_a3 0 x2_im_a3 x2_re_a3 0 -8.993009352
Rp2_im_im_a3 0 x2_im_a3 1
Cx3_re_a3 x3_re_a3 0 3.515400992e-12
Gx3_re_a3 0 x3_re_a3 p3 0 9.563687506e-08
Fx3_re_a3 0 x3_re_a3 V3 4.781843753e-06
Rp3_re_re_a3 0 x3_re_a3 1
Gp3_re_im_a3 0 x3_re_a3 x3_im_a3 0 1.725264232
Cx3_im_a3 x3_im_a3 0 3.515400992e-12
Gp3_im_re_a3 0 x3_im_a3 x3_re_a3 0 -1.725264232
Rp3_im_im_a3 0 x3_im_a3 1
Cx4_re_a3 x4_re_a3 0 3.685452367e-12
Gx4_re_a3 0 x4_re_a3 p3 0 7.537751296e-08
Fx4_re_a3 0 x4_re_a3 V3 3.768875648e-06
Rp4_re_re_a3 0 x4_re_a3 1
Gp4_re_im_a3 0 x4_re_a3 x4_im_a3 0 5.132870892
Cx4_im_a3 x4_im_a3 0 3.685452367e-12
Gp4_im_re_a3 0 x4_im_a3 x4_re_a3 0 -5.132870892
Rp4_im_im_a3 0 x4_im_a3 1
Cx5_re_a3 x5_re_a3 0 2.023593684e-12
Gx5_re_a3 0 x5_re_a3 p3 0 9.238164296e-08
Fx5_re_a3 0 x5_re_a3 V3 4.619082148e-06
Rp5_re_re_a3 0 x5_re_a3 1
Gp5_re_im_a3 0 x5_re_a3 x5_im_a3 0 1.938964343
Cx5_im_a3 x5_im_a3 0 2.023593684e-12
Gp5_im_re_a3 0 x5_im_a3 x5_re_a3 0 -1.938964343
Rp5_im_im_a3 0 x5_im_a3 1
Cx6_re_a3 x6_re_a3 0 1.536838407e-11
Gx6_re_a3 0 x6_re_a3 p3 0 3.037426157e-08
Fx6_re_a3 0 x6_re_a3 V3 1.518713079e-06
Rp6_re_re_a3 0 x6_re_a3 1
Gp6_re_im_a3 0 x6_re_a3 x6_im_a3 0 20.71158076
Cx6_im_a3 x6_im_a3 0 1.536838407e-11
Gp6_im_re_a3 0 x6_im_a3 x6_re_a3 0 -20.71158076
Rp6_im_im_a3 0 x6_im_a3 1
Cx7_re_a3 x7_re_a3 0 8.283721394e-12
Gx7_re_a3 0 x7_re_a3 p3 0 7.674634422e-08
Fx7_re_a3 0 x7_re_a3 V3 3.837317211e-06
Rp7_re_re_a3 0 x7_re_a3 1
Gp7_re_im_a3 0 x7_re_a3 x7_im_a3 0 7.243952262
Cx7_im_a3 x7_im_a3 0 8.283721394e-12
Gp7_im_re_a3 0 x7_im_a3 x7_re_a3 0 -7.243952262
Rp7_im_im_a3 0 x7_im_a3 1
Cx8_re_a3 x8_re_a3 0 6.26307816e-12
Gx8_re_a3 0 x8_re_a3 p3 0 9.506333277e-08
Fx8_re_a3 0 x8_re_a3 V3 4.753166639e-06
Rp8_re_re_a3 0 x8_re_a3 1
Gp8_re_im_a3 0 x8_re_a3 x8_im_a3 0 6.959167708
Cx8_im_a3 x8_im_a3 0 6.26307816e-12
Gp8_im_re_a3 0 x8_im_a3 x8_re_a3 0 -6.959167708
Rp8_im_im_a3 0 x8_im_a3 1
Cx9_re_a3 x9_re_a3 0 1.437227943e-11
Gx9_re_a3 0 x9_re_a3 p3 0 3.9475863e-08
Fx9_re_a3 0 x9_re_a3 V3 1.97379315e-06
Rp9_re_re_a3 0 x9_re_a3 1
Gp9_re_im_a3 0 x9_re_a3 x9_im_a3 0 16.64222601
Cx9_im_a3 x9_im_a3 0 1.437227943e-11
Gp9_im_re_a3 0 x9_im_a3 x9_re_a3 0 -16.64222601
Rp9_im_im_a3 0 x9_im_a3 1
Cx10_re_a3 x10_re_a3 0 3.091922882e-11
Gx10_re_a3 0 x10_re_a3 p3 0 2.993800355e-08
Fx10_re_a3 0 x10_re_a3 V3 1.496900177e-06
Rp10_re_re_a3 0 x10_re_a3 1
Gp10_re_im_a3 0 x10_re_a3 x10_im_a3 0 28.86213401
Cx10_im_a3 x10_im_a3 0 3.091922882e-11
Gp10_im_re_a3 0 x10_im_a3 x10_re_a3 0 -28.86213401
Rp10_im_im_a3 0 x10_im_a3 1
Cx11_re_a3 x11_re_a3 0 2.197240297e-11
Gx11_re_a3 0 x11_re_a3 p3 0 4.209139916e-08
Fx11_re_a3 0 x11_re_a3 V3 2.104569958e-06
Rp11_re_re_a3 0 x11_re_a3 1
Gp11_re_im_a3 0 x11_re_a3 x11_im_a3 0 23.68502501
Cx11_im_a3 x11_im_a3 0 2.197240297e-11
Gp11_im_re_a3 0 x11_im_a3 x11_re_a3 0 -23.68502501
Rp11_im_im_a3 0 x11_im_a3 1
Cx12_re_a3 x12_re_a3 0 2.154716074e-11
Gx12_re_a3 0 x12_re_a3 p3 0 4.221733563e-08
Fx12_re_a3 0 x12_re_a3 V3 2.110866782e-06
Rp12_re_re_a3 0 x12_re_a3 1
Gp12_re_im_a3 0 x12_re_a3 x12_im_a3 0 21.52683006
Cx12_im_a3 x12_im_a3 0 2.154716074e-11
Gp12_im_re_a3 0 x12_im_a3 x12_re_a3 0 -21.52683006
Rp12_im_im_a3 0 x12_im_a3 1
V4 p4 s4 0
R4 s4 0 50
Gd4_1 0 s4 p1 0 -0.0004183883932
Fd4_1 0 s4 V1 -0.02091941966
Gr1_4_1 0 s4 x1_a1 0 0.05273360248
Gr2_re_4_1 0 s4 x2_re_a1 0 1272.52145
Gr2_im_4_1 0 s4 x2_im_a1 0 -79285.92386
Gr3_re_4_1 0 s4 x3_re_a1 0 24544.20426
Gr3_im_4_1 0 s4 x3_im_a1 0 -20979.70119
Gr4_re_4_1 0 s4 x4_re_a1 0 -128428.9027
Gr4_im_4_1 0 s4 x4_im_a1 0 17399.23202
Gr5_re_4_1 0 s4 x5_re_a1 0 89006.72992
Gr5_im_4_1 0 s4 x5_im_a1 0 56023.60516
Gr6_re_4_1 0 s4 x6_re_a1 0 -3524.366598
Gr6_im_4_1 0 s4 x6_im_a1 0 -7334.72529
Gr7_re_4_1 0 s4 x7_re_a1 0 -32994.65675
Gr7_im_4_1 0 s4 x7_im_a1 0 59480.69409
Gr8_re_4_1 0 s4 x8_re_a1 0 -83783.39276
Gr8_im_4_1 0 s4 x8_im_a1 0 -7196.59666
Gr9_re_4_1 0 s4 x9_re_a1 0 -27007.37039
Gr9_im_4_1 0 s4 x9_im_a1 0 -40385.22488
Gr10_re_4_1 0 s4 x10_re_a1 0 -191419.2946
Gr10_im_4_1 0 s4 x10_im_a1 0 -40688.73369
Gr11_re_4_1 0 s4 x11_re_a1 0 -41586.13873
Gr11_im_4_1 0 s4 x11_im_a1 0 261551.5488
Gr12_re_4_1 0 s4 x12_re_a1 0 205861.255
Gr12_im_4_1 0 s4 x12_im_a1 0 -58915.53992
Gd4_2 0 s4 p2 0 -0.001469674238
Fd4_2 0 s4 V2 -0.0734837119
Gr1_4_2 0 s4 x1_a2 0 0.04656756159
Gr2_re_4_2 0 s4 x2_re_a2 0 -269032.6443
Gr2_im_4_2 0 s4 x2_im_a2 0 244298.624
Gr3_re_4_2 0 s4 x3_re_a2 0 -37489.15662
Gr3_im_4_2 0 s4 x3_im_a2 0 -283300.3102
Gr4_re_4_2 0 s4 x4_re_a2 0 -114151.0351
Gr4_im_4_2 0 s4 x4_im_a2 0 251449.6842
Gr5_re_4_2 0 s4 x5_re_a2 0 257015.2391
Gr5_im_4_2 0 s4 x5_im_a2 0 168829.3621
Gr6_re_4_2 0 s4 x6_re_a2 0 153372.464
Gr6_im_4_2 0 s4 x6_im_a2 0 -174709.3473
Gr7_re_4_2 0 s4 x7_re_a2 0 -139139.604
Gr7_im_4_2 0 s4 x7_im_a2 0 -314827.4853
Gr8_re_4_2 0 s4 x8_re_a2 0 -102391.212
Gr8_im_4_2 0 s4 x8_im_a2 0 83087.1263
Gr9_re_4_2 0 s4 x9_re_a2 0 114139.292
Gr9_im_4_2 0 s4 x9_im_a2 0 -169045.5636
Gr10_re_4_2 0 s4 x10_re_a2 0 118510.2548
Gr10_im_4_2 0 s4 x10_im_a2 0 -30978.18479
Gr11_re_4_2 0 s4 x11_re_a2 0 -59750.25773
Gr11_im_4_2 0 s4 x11_im_a2 0 -68509.5609
Gr12_re_4_2 0 s4 x12_re_a2 0 44408.2059
Gr12_im_4_2 0 s4 x12_im_a2 0 -139046.7623
Gd4_3 0 s4 p3 0 0.001584594537
Fd4_3 0 s4 V3 0.07922972686
Gr1_4_3 0 s4 x1_a3 0 -0.7426630327
Gr2_re_4_3 0 s4 x2_re_a3 0 131568.7294
Gr2_im_4_3 0 s4 x2_im_a3 0 -393211.3681
Gr3_re_4_3 0 s4 x3_re_a3 0 177786.2033
Gr3_im_4_3 0 s4 x3_im_a3 0 -169574.931
Gr4_re_4_3 0 s4 x4_re_a3 0 -184119.649
Gr4_im_4_3 0 s4 x4_im_a3 0 -169354.6146
Gr5_re_4_3 0 s4 x5_re_a3 0 -247147.8037
Gr5_im_4_3 0 s4 x5_im_a3 0 -214253.8341
Gr6_re_4_3 0 s4 x6_re_a3 0 -189163.2415
Gr6_im_4_3 0 s4 x6_im_a3 0 262221.568
Gr7_re_4_3 0 s4 x7_re_a3 0 137241.7534
Gr7_im_4_3 0 s4 x7_im_a3 0 256257.3676
Gr8_re_4_3 0 s4 x8_re_a3 0 90901.30718
Gr8_im_4_3 0 s4 x8_im_a3 0 67100.29479
Gr9_re_4_3 0 s4 x9_re_a3 0 202638.3754
Gr9_im_4_3 0 s4 x9_im_a3 0 361941.7206
Gr10_re_4_3 0 s4 x10_re_a3 0 -117322.9161
Gr10_im_4_3 0 s4 x10_im_a3 0 54858.35603
Gr11_re_4_3 0 s4 x11_re_a3 0 136227.6278
Gr11_im_4_3 0 s4 x11_im_a3 0 47737.07761
Gr12_re_4_3 0 s4 x12_re_a3 0 -9450.115222
Gr12_im_4_3 0 s4 x12_im_a3 0 170471.3195
Gd4_4 0 s4 p4 0 -0.003474974094
Fd4_4 0 s4 V4 -0.1737487047
Gr1_4_4 0 s4 x1_a4 0 -0.9268024504
Gr2_re_4_4 0 s4 x2_re_a4 0 -287728.6804
Gr2_im_4_4 0 s4 x2_im_a4 0 497000.1286
Gr3_re_4_4 0 s4 x3_re_a4 0 133315.7191
Gr3_im_4_4 0 s4 x3_im_a4 0 -147366.2005
Gr4_re_4_4 0 s4 x4_re_a4 0 1033556.04
Gr4_im_4_4 0 s4 x4_im_a4 0 -164690.4331
Gr5_re_4_4 0 s4 x5_re_a4 0 -756294.5553
Gr5_im_4_4 0 s4 x5_im_a4 0 19891.18061
Gr6_re_4_4 0 s4 x6_re_a4 0 262659.1588
Gr6_im_4_4 0 s4 x6_im_a4 0 -240561.6795
Gr7_re_4_4 0 s4 x7_re_a4 0 454950.3703
Gr7_im_4_4 0 s4 x7_im_a4 0 -225611.6375
Gr8_re_4_4 0 s4 x8_re_a4 0 639319.7744
Gr8_im_4_4 0 s4 x8_im_a4 0 -614226.0646
Gr9_re_4_4 0 s4 x9_re_a4 0 339039.0248
Gr9_im_4_4 0 s4 x9_im_a4 0 23414.757
Gr10_re_4_4 0 s4 x10_re_a4 0 80483.16361
Gr10_im_4_4 0 s4 x10_im_a4 0 -1142.759393
Gr11_re_4_4 0 s4 x11_re_a4 0 -183595.1661
Gr11_im_4_4 0 s4 x11_im_a4 0 -133016.6463
Gr12_re_4_4 0 s4 x12_re_a4 0 117594.4011
Gr12_im_4_4 0 s4 x12_im_a4 0 -210047.8576
Gd4_5 0 s4 p5 0 -0.0002215899735
Fd4_5 0 s4 V5 -0.01107949868
Gr1_4_5 0 s4 x1_a5 0 0.4538265461
Gr2_re_4_5 0 s4 x2_re_a5 0 98909.23189
Gr2_im_4_5 0 s4 x2_im_a5 0 -787608.4597
Gr3_re_4_5 0 s4 x3_re_a5 0 -289154.4841
Gr3_im_4_5 0 s4 x3_im_a5 0 212162.1246
Gr4_re_4_5 0 s4 x4_re_a5 0 -773714.1956
Gr4_im_4_5 0 s4 x4_im_a5 0 420079.1676
Gr5_re_4_5 0 s4 x5_re_a5 0 545270.3336
Gr5_im_4_5 0 s4 x5_im_a5 0 -707504.3261
Gr6_re_4_5 0 s4 x6_re_a5 0 -19884.86715
Gr6_im_4_5 0 s4 x6_im_a5 0 396829.3201
Gr7_re_4_5 0 s4 x7_re_a5 0 410918.6196
Gr7_im_4_5 0 s4 x7_im_a5 0 542886.8064
Gr8_re_4_5 0 s4 x8_re_a5 0 -515497.4075
Gr8_im_4_5 0 s4 x8_im_a5 0 922483.3663
Gr9_re_4_5 0 s4 x9_re_a5 0 195408.9855
Gr9_im_4_5 0 s4 x9_im_a5 0 -80860.376
Gr10_re_4_5 0 s4 x10_re_a5 0 -11142.92225
Gr10_im_4_5 0 s4 x10_im_a5 0 226790.9751
Gr11_re_4_5 0 s4 x11_re_a5 0 326241.9213
Gr11_im_4_5 0 s4 x11_im_a5 0 -95635.46643
Gr12_re_4_5 0 s4 x12_re_a5 0 217456.9269
Gr12_im_4_5 0 s4 x12_im_a5 0 265324.8837
Gd4_6 0 s4 p6 0 0.00246900862
Fd4_6 0 s4 V6 0.123450431
Gr1_4_6 0 s4 x1_a6 0 -0.2062197938
Gr2_re_4_6 0 s4 x2_re_a6 0 -378931.6592
Gr2_im_4_6 0 s4 x2_im_a6 0 402277.1019
Gr3_re_4_6 0 s4 x3_re_a6 0 -374330.2894
Gr3_im_4_6 0 s4 x3_im_a6 0 262232.7791
Gr4_re_4_6 0 s4 x4_re_a6 0 820412.4717
Gr4_im_4_6 0 s4 x4_im_a6 0 485497.9383
Gr5_re_4_6 0 s4 x5_re_a6 0 -565052.4975
Gr5_im_4_6 0 s4 x5_im_a6 0 -950341.5726
Gr6_re_4_6 0 s4 x6_re_a6 0 402032.4983
Gr6_im_4_6 0 s4 x6_im_a6 0 -215619.0923
Gr7_re_4_6 0 s4 x7_re_a6 0 634496.9772
Gr7_im_4_6 0 s4 x7_im_a6 0 -125226.2217
Gr8_re_4_6 0 s4 x8_re_a6 0 565487.0383
Gr8_im_4_6 0 s4 x8_im_a6 0 744253.5003
Gr9_re_4_6 0 s4 x9_re_a6 0 192956.8026
Gr9_im_4_6 0 s4 x9_im_a6 0 -456329.5273
Gr10_re_4_6 0 s4 x10_re_a6 0 121580.9687
Gr10_im_4_6 0 s4 x10_im_a6 0 141409.2018
Gr11_re_4_6 0 s4 x11_re_a6 0 58262.36231
Gr11_im_4_6 0 s4 x11_im_a6 0 -325638.1375
Gr12_re_4_6 0 s4 x12_re_a6 0 321513.7969
Gr12_im_4_6 0 s4 x12_im_a6 0 -19474.35998
Gd4_7 0 s4 p7 0 0.0007609216407
Fd4_7 0 s4 V7 0.03804608204
Gr1_4_7 0 s4 x1_a7 0 -0.06497634425
Gr2_re_4_7 0 s4 x2_re_a7 0 182746.482
Gr2_im_4_7 0 s4 x2_im_a7 0 -80660.52204
Gr3_re_4_7 0 s4 x3_re_a7 0 -201136.139
Gr3_im_4_7 0 s4 x3_im_a7 0 -165225.5809
Gr4_re_4_7 0 s4 x4_re_a7 0 254721.2225
Gr4_im_4_7 0 s4 x4_im_a7 0 -200414.2846
Gr5_re_4_7 0 s4 x5_re_a7 0 -138034.0976
Gr5_im_4_7 0 s4 x5_im_a7 0 16353.9652
Gr6_re_4_7 0 s4 x6_re_a7 0 164994.5353
Gr6_im_4_7 0 s4 x6_im_a7 0 -118544.2328
Gr7_re_4_7 0 s4 x7_re_a7 0 -134414.085
Gr7_im_4_7 0 s4 x7_im_a7 0 -393783.3498
Gr8_re_4_7 0 s4 x8_re_a7 0 217357.2129
Gr8_im_4_7 0 s4 x8_im_a7 0 37289.59436
Gr9_re_4_7 0 s4 x9_re_a7 0 71872.44565
Gr9_im_4_7 0 s4 x9_im_a7 0 -179672.5625
Gr10_re_4_7 0 s4 x10_re_a7 0 97570.37945
Gr10_im_4_7 0 s4 x10_im_a7 0 -29340.57236
Gr11_re_4_7 0 s4 x11_re_a7 0 -32040.68927
Gr11_im_4_7 0 s4 x11_im_a7 0 -110819.4755
Gr12_re_4_7 0 s4 x12_re_a7 0 49112.66287
Gr12_im_4_7 0 s4 x12_im_a7 0 -80439.88599
Cx1_a4 x1_a4 0 3.599252385e-12
Gx1_a4 0 x1_a4 p4 0 0.01853604901
Fx1_a4 0 x1_a4 V4 0.9268024504
Rp1_a4 0 x1_a4 1
Cx2_re_a4 x2_re_a4 0 5.856437181e-12
Gx2_re_a4 0 x2_re_a4 p4 0 4.626262949e-08
Fx2_re_a4 0 x2_re_a4 V4 2.313131475e-06
Rp2_re_re_a4 0 x2_re_a4 1
Gp2_re_im_a4 0 x2_re_a4 x2_im_a4 0 8.993009352
Cx2_im_a4 x2_im_a4 0 5.856437181e-12
Gp2_im_re_a4 0 x2_im_a4 x2_re_a4 0 -8.993009352
Rp2_im_im_a4 0 x2_im_a4 1
Cx3_re_a4 x3_re_a4 0 3.515400992e-12
Gx3_re_a4 0 x3_re_a4 p4 0 9.053726338e-08
Fx3_re_a4 0 x3_re_a4 V4 4.526863169e-06
Rp3_re_re_a4 0 x3_re_a4 1
Gp3_re_im_a4 0 x3_re_a4 x3_im_a4 0 1.725264232
Cx3_im_a4 x3_im_a4 0 3.515400992e-12
Gp3_im_re_a4 0 x3_im_a4 x3_re_a4 0 -1.725264232
Rp3_im_im_a4 0 x3_im_a4 1
Cx4_re_a4 x4_re_a4 0 3.685452367e-12
Gx4_re_a4 0 x4_re_a4 p4 0 7.308379961e-08
Fx4_re_a4 0 x4_re_a4 V4 3.65418998e-06
Rp4_re_re_a4 0 x4_re_a4 1
Gp4_re_im_a4 0 x4_re_a4 x4_im_a4 0 5.132870892
Cx4_im_a4 x4_im_a4 0 3.685452367e-12
Gp4_im_re_a4 0 x4_im_a4 x4_re_a4 0 -5.132870892
Rp4_im_im_a4 0 x4_im_a4 1
Cx5_re_a4 x5_re_a4 0 2.023593684e-12
Gx5_re_a4 0 x5_re_a4 p4 0 1.268233493e-07
Fx5_re_a4 0 x5_re_a4 V4 6.341167464e-06
Rp5_re_re_a4 0 x5_re_a4 1
Gp5_re_im_a4 0 x5_re_a4 x5_im_a4 0 1.938964343
Cx5_im_a4 x5_im_a4 0 2.023593684e-12
Gp5_im_re_a4 0 x5_im_a4 x5_re_a4 0 -1.938964343
Rp5_im_im_a4 0 x5_im_a4 1
Cx6_re_a4 x6_re_a4 0 1.536838407e-11
Gx6_re_a4 0 x6_re_a4 p4 0 3.831813236e-08
Fx6_re_a4 0 x6_re_a4 V4 1.915906618e-06
Rp6_re_re_a4 0 x6_re_a4 1
Gp6_re_im_a4 0 x6_re_a4 x6_im_a4 0 20.71158076
Cx6_im_a4 x6_im_a4 0 1.536838407e-11
Gp6_im_re_a4 0 x6_im_a4 x6_re_a4 0 -20.71158076
Rp6_im_im_a4 0 x6_im_a4 1
Cx7_re_a4 x7_re_a4 0 8.283721394e-12
Gx7_re_a4 0 x7_re_a4 p4 0 8.835488524e-08
Fx7_re_a4 0 x7_re_a4 V4 4.417744262e-06
Rp7_re_re_a4 0 x7_re_a4 1
Gp7_re_im_a4 0 x7_re_a4 x7_im_a4 0 7.243952262
Cx7_im_a4 x7_im_a4 0 8.283721394e-12
Gp7_im_re_a4 0 x7_im_a4 x7_re_a4 0 -7.243952262
Rp7_im_im_a4 0 x7_im_a4 1
Cx8_re_a4 x8_re_a4 0 6.26307816e-12
Gx8_re_a4 0 x8_re_a4 p4 0 9.701408355e-08
Fx8_re_a4 0 x8_re_a4 V4 4.850704177e-06
Rp8_re_re_a4 0 x8_re_a4 1
Gp8_re_im_a4 0 x8_re_a4 x8_im_a4 0 6.959167708
Cx8_im_a4 x8_im_a4 0 6.26307816e-12
Gp8_im_re_a4 0 x8_im_a4 x8_re_a4 0 -6.959167708
Rp8_im_im_a4 0 x8_im_a4 1
Cx9_re_a4 x9_re_a4 0 1.437227943e-11
Gx9_re_a4 0 x9_re_a4 p4 0 4.653270676e-08
Fx9_re_a4 0 x9_re_a4 V4 2.326635338e-06
Rp9_re_re_a4 0 x9_re_a4 1
Gp9_re_im_a4 0 x9_re_a4 x9_im_a4 0 16.64222601
Cx9_im_a4 x9_im_a4 0 1.437227943e-11
Gp9_im_re_a4 0 x9_im_a4 x9_re_a4 0 -16.64222601
Rp9_im_im_a4 0 x9_im_a4 1
Cx10_re_a4 x10_re_a4 0 3.091922882e-11
Gx10_re_a4 0 x10_re_a4 p4 0 3.312071986e-08
Fx10_re_a4 0 x10_re_a4 V4 1.656035993e-06
Rp10_re_re_a4 0 x10_re_a4 1
Gp10_re_im_a4 0 x10_re_a4 x10_im_a4 0 28.86213401
Cx10_im_a4 x10_im_a4 0 3.091922882e-11
Gp10_im_re_a4 0 x10_im_a4 x10_re_a4 0 -28.86213401
Rp10_im_im_a4 0 x10_im_a4 1
Cx11_re_a4 x11_re_a4 0 2.197240297e-11
Gx11_re_a4 0 x11_re_a4 p4 0 4.268195943e-08
Fx11_re_a4 0 x11_re_a4 V4 2.134097972e-06
Rp11_re_re_a4 0 x11_re_a4 1
Gp11_re_im_a4 0 x11_re_a4 x11_im_a4 0 23.68502501
Cx11_im_a4 x11_im_a4 0 2.197240297e-11
Gp11_im_re_a4 0 x11_im_a4 x11_re_a4 0 -23.68502501
Rp11_im_im_a4 0 x11_im_a4 1
Cx12_re_a4 x12_re_a4 0 2.154716074e-11
Gx12_re_a4 0 x12_re_a4 p4 0 4.167596373e-08
Fx12_re_a4 0 x12_re_a4 V4 2.083798186e-06
Rp12_re_re_a4 0 x12_re_a4 1
Gp12_re_im_a4 0 x12_re_a4 x12_im_a4 0 21.52683006
Cx12_im_a4 x12_im_a4 0 2.154716074e-11
Gp12_im_re_a4 0 x12_im_a4 x12_re_a4 0 -21.52683006
Rp12_im_im_a4 0 x12_im_a4 1
V5 p5 s5 0
R5 s5 0 50
Gd5_1 0 s5 p1 0 0.0001853951558
Fd5_1 0 s5 V1 0.00926975779
Gr1_5_1 0 s5 x1_a1 0 0.04649118694
Gr2_re_5_1 0 s5 x2_re_a1 0 40416.33858
Gr2_im_5_1 0 s5 x2_im_a1 0 30591.43448
Gr3_re_5_1 0 s5 x3_re_a1 0 24241.95104
Gr3_im_5_1 0 s5 x3_im_a1 0 10791.28931
Gr4_re_5_1 0 s5 x4_re_a1 0 16049.37688
Gr4_im_5_1 0 s5 x4_im_a1 0 -82483.50067
Gr5_re_5_1 0 s5 x5_re_a1 0 -22329.30384
Gr5_im_5_1 0 s5 x5_im_a1 0 45267.67358
Gr6_re_5_1 0 s5 x6_re_a1 0 5059.850454
Gr6_im_5_1 0 s5 x6_im_a1 0 10120.71847
Gr7_re_5_1 0 s5 x7_re_a1 0 -46196.71635
Gr7_im_5_1 0 s5 x7_im_a1 0 -9164.719515
Gr8_re_5_1 0 s5 x8_re_a1 0 4320.846651
Gr8_im_5_1 0 s5 x8_im_a1 0 -58981.29665
Gr9_re_5_1 0 s5 x9_re_a1 0 24084.22297
Gr9_im_5_1 0 s5 x9_im_a1 0 -15110.28188
Gr10_re_5_1 0 s5 x10_re_a1 0 -8102.201961
Gr10_im_5_1 0 s5 x10_im_a1 0 -160183.6051
Gr11_re_5_1 0 s5 x11_re_a1 0 -213233.3201
Gr11_im_5_1 0 s5 x11_im_a1 0 -14528.8077
Gr12_re_5_1 0 s5 x12_re_a1 0 76581.52175
Gr12_im_5_1 0 s5 x12_im_a1 0 163623.3273
Gd5_2 0 s5 p2 0 -0.001186048763
Fd5_2 0 s5 V2 -0.05930243815
Gr1_5_2 0 s5 x1_a2 0 0.6590019002
Gr2_re_5_2 0 s5 x2_re_a2 0 -10766.99267
Gr2_im_5_2 0 s5 x2_im_a2 0 -207868.0534
Gr3_re_5_2 0 s5 x3_re_a2 0 -13276.70531
Gr3_im_5_2 0 s5 x3_im_a2 0 -276985.1977
Gr4_re_5_2 0 s5 x4_re_a2 0 -727696.3932
Gr4_im_5_2 0 s5 x4_im_a2 0 85179.83006
Gr5_re_5_2 0 s5 x5_re_a2 0 238259.8217
Gr5_im_5_2 0 s5 x5_im_a2 0 421171.7525
Gr6_re_5_2 0 s5 x6_re_a2 0 65401.33529
Gr6_im_5_2 0 s5 x6_im_a2 0 214628.4819
Gr7_re_5_2 0 s5 x7_re_a2 0 247029.1029
Gr7_im_5_2 0 s5 x7_im_a2 0 -145604.9646
Gr8_re_5_2 0 s5 x8_re_a2 0 177792.5082
Gr8_im_5_2 0 s5 x8_im_a2 0 -34224.48369
Gr9_re_5_2 0 s5 x9_re_a2 0 48853.42075
Gr9_im_5_2 0 s5 x9_im_a2 0 -25588.05463
Gr10_re_5_2 0 s5 x10_re_a2 0 104379.4784
Gr10_im_5_2 0 s5 x10_im_a2 0 109921.6855
Gr11_re_5_2 0 s5 x11_re_a2 0 85852.17506
Gr11_im_5_2 0 s5 x11_im_a2 0 -134912.068
Gr12_re_5_2 0 s5 x12_re_a2 0 192984.1113
Gr12_im_5_2 0 s5 x12_im_a2 0 6291.888364
Gd5_3 0 s5 p3 0 -0.0002116452036
Fd5_3 0 s5 V3 -0.01058226018
Gr1_5_3 0 s5 x1_a3 0 0.5007802127
Gr2_re_5_3 0 s5 x2_re_a3 0 136252.0994
Gr2_im_5_3 0 s5 x2_im_a3 0 511932.8855
Gr3_re_5_3 0 s5 x3_re_a3 0 -352894.3376
Gr3_im_5_3 0 s5 x3_im_a3 0 312131.4743
Gr4_re_5_3 0 s5 x4_re_a3 0 -87342.7325
Gr4_im_5_3 0 s5 x4_im_a3 0 93754.64975
Gr5_re_5_3 0 s5 x5_re_a3 0 228746.0294
Gr5_im_5_3 0 s5 x5_im_a3 0 -692648.4092
Gr6_re_5_3 0 s5 x6_re_a3 0 -22079.81696
Gr6_im_5_3 0 s5 x6_im_a3 0 -177347.8734
Gr7_re_5_3 0 s5 x7_re_a3 0 -38565.53171
Gr7_im_5_3 0 s5 x7_im_a3 0 430846.8126
Gr8_re_5_3 0 s5 x8_re_a3 0 -170059.5022
Gr8_im_5_3 0 s5 x8_im_a3 0 286670.4564
Gr9_re_5_3 0 s5 x9_re_a3 0 -189785.2143
Gr9_im_5_3 0 s5 x9_im_a3 0 -78576.77944
Gr10_re_5_3 0 s5 x10_re_a3 0 -62405.5695
Gr10_im_5_3 0 s5 x10_im_a3 0 95379.6768
Gr11_re_5_3 0 s5 x11_re_a3 0 122035.4885
Gr11_im_5_3 0 s5 x11_im_a3 0 38921.51738
Gr12_re_5_3 0 s5 x12_re_a3 0 16322.38461
Gr12_im_5_3 0 s5 x12_im_a3 0 178708.4225
Gd5_4 0 s5 p4 0 -0.0002215899742
Fd5_4 0 s5 V4 -0.01107949871
Gr1_5_4 0 s5 x1_a4 0 0.3776114577
Gr2_re_5_4 0 s5 x2_re_a4 0 84000.9479
Gr2_im_5_4 0 s5 x2_im_a4 0 -668894.6612
Gr3_re_5_4 0 s5 x3_re_a4 0 -305441.4308
Gr3_im_5_4 0 s5 x3_im_a4 0 224112.3913
Gr4_re_5_4 0 s5 x4_re_a4 0 -801614.8827
Gr4_im_5_4 0 s5 x4_im_a4 0 435227.5227
Gr5_re_5_4 0 s5 x5_re_a4 0 394141.0114
Gr5_im_5_4 0 s5 x5_im_a4 0 -511409.5768
Gr6_re_5_4 0 s5 x6_re_a4 0 -16664.94374
Gr6_im_5_4 0 s5 x6_im_a4 0 332571.4098
Gr7_re_5_4 0 s5 x7_re_a4 0 355240.6936
Gr7_im_5_4 0 s5 x7_im_a4 0 469327.6879
Gr8_re_5_4 0 s5 x8_re_a4 0 -507841.6562
Gr8_im_5_4 0 s5 x8_im_a4 0 908783.3881
Gr9_re_5_4 0 s5 x9_re_a4 0 177612.0383
Gr9_im_5_4 0 s5 x9_im_a4 0 -73495.98673
Gr10_re_5_4 0 s5 x10_re_a4 0 -10145.80086
Gr10_im_5_4 0 s5 x10_im_a4 0 206496.6458
Gr11_re_5_4 0 s5 x11_re_a4 0 325405.2401
Gr11_im_5_4 0 s5 x11_im_a4 0 -95390.19936
Gr12_re_5_4 0 s5 x12_re_a4 0 221475.7207
Gr12_im_5_4 0 s5 x12_im_a4 0 270228.3191
Gd5_5 0 s5 p5 0 -0.004811592043
Fd5_5 0 s5 V5 -0.2405796021
Gr1_5_5 0 s5 x1_a5 0 -0.7297476885
Gr2_re_5_5 0 s5 x2_re_a5 0 173267.3406
Gr2_im_5_5 0 s5 x2_im_a5 0 630542.4394
Gr3_re_5_5 0 s5 x3_re_a5 0 268662.4353
Gr3_im_5_5 0 s5 x3_im_a5 0 -100680.1326
Gr4_re_5_5 0 s5 x4_re_a5 0 593427.8486
Gr4_im_5_5 0 s5 x4_im_a5 0 -718689.276
Gr5_re_5_5 0 s5 x5_re_a5 0 -439609.5037
Gr5_im_5_5 0 s5 x5_im_a5 0 609086.3407
Gr6_re_5_5 0 s5 x6_re_a5 0 -235997.4536
Gr6_im_5_5 0 s5 x6_im_a5 0 -289737.3827
Gr7_re_5_5 0 s5 x7_re_a5 0 -309734.7018
Gr7_im_5_5 0 s5 x7_im_a5 0 115981.4336
Gr8_re_5_5 0 s5 x8_re_a5 0 636.7415856
Gr8_im_5_5 0 s5 x8_im_a5 0 -1093844.792
Gr9_re_5_5 0 s5 x9_re_a5 0 14268.29406
Gr9_im_5_5 0 s5 x9_im_a5 0 508118.7062
Gr10_re_5_5 0 s5 x10_re_a5 0 -174710.018
Gr10_im_5_5 0 s5 x10_im_a5 0 -158492.2449
Gr11_re_5_5 0 s5 x11_re_a5 0 -151452.0251
Gr11_im_5_5 0 s5 x11_im_a5 0 322761.015
Gr12_re_5_5 0 s5 x12_re_a5 0 -338882.4987
Gr12_im_5_5 0 s5 x12_im_a5 0 -15369.34707
Gd5_6 0 s5 p6 0 0.001530679694
Fd5_6 0 s5 V6 0.07653398468
Gr1_5_6 0 s5 x1_a6 0 -0.6244382409
Gr2_re_5_6 0 s5 x2_re_a6 0 131759.0392
Gr2_im_5_6 0 s5 x2_im_a6 0 -340936.7614
Gr3_re_5_6 0 s5 x3_re_a6 0 191939.3148
Gr3_im_5_6 0 s5 x3_im_a6 0 -177511.1283
Gr4_re_5_6 0 s5 x4_re_a6 0 -217039.6232
Gr4_im_5_6 0 s5 x4_im_a6 0 -156747.4915
Gr5_re_5_6 0 s5 x5_re_a6 0 -169888.4302
Gr5_im_5_6 0 s5 x5_im_a6 0 -170440.92
Gr6_re_5_6 0 s5 x6_re_a6 0 -133103.8399
Gr6_im_5_6 0 s5 x6_im_a6 0 260758.4124
Gr7_re_5_6 0 s5 x7_re_a6 0 136734.7097
Gr7_im_5_6 0 s5 x7_im_a6 0 229674.6236
Gr8_re_5_6 0 s5 x8_re_a6 0 76662.19853
Gr8_im_5_6 0 s5 x8_im_a6 0 104995.1361
Gr9_re_5_6 0 s5 x9_re_a6 0 228637.089
Gr9_im_5_6 0 s5 x9_im_a6 0 292522.203
Gr10_re_5_6 0 s5 x10_re_a6 0 -102674.2223
Gr10_im_5_6 0 s5 x10_im_a6 0 48279.23078
Gr11_re_5_6 0 s5 x11_re_a6 0 143485.4031
Gr11_im_5_6 0 s5 x11_im_a6 0 33470.30931
Gr12_re_5_6 0 s5 x12_re_a6 0 4029.685931
Gr12_im_5_6 0 s5 x12_im_a6 0 176147.8147
Gd5_7 0 s5 p7 0 0.00043691046
Fd5_7 0 s5 V7 0.021845523
Gr1_5_7 0 s5 x1_a7 0 0.211974783
Gr2_re_5_7 0 s5 x2_re_a7 0 278890.7592
Gr2_im_5_7 0 s5 x2_im_a7 0 -323915.0394
Gr3_re_5_7 0 s5 x3_re_a7 0 98312.4489
Gr3_im_5_7 0 s5 x3_im_a7 0 -310509.7416
Gr4_re_5_7 0 s5 x4_re_a7 0 114527.0406
Gr4_im_5_7 0 s5 x4_im_a7 0 -419190.0815
Gr5_re_5_7 0 s5 x5_re_a7 0 -218914.0263
Gr5_im_5_7 0 s5 x5_im_a7 0 412422.604
Gr6_re_5_7 0 s5 x6_re_a7 0 -46251.73564
Gr6_im_5_7 0 s5 x6_im_a7 0 169339.3083
Gr7_re_5_7 0 s5 x7_re_a7 0 111765.5621
Gr7_im_5_7 0 s5 x7_im_a7 0 -346776.6141
Gr8_re_5_7 0 s5 x8_re_a7 0 156641.5759
Gr8_im_5_7 0 s5 x8_im_a7 0 -179446.3222
Gr9_re_5_7 0 s5 x9_re_a7 0 129578.467
Gr9_im_5_7 0 s5 x9_im_a7 0 170259.2446
Gr10_re_5_7 0 s5 x10_re_a7 0 29091.782
Gr10_im_5_7 0 s5 x10_im_a7 0 -1615.207111
Gr11_re_5_7 0 s5 x11_re_a7 0 -5616.089991
Gr11_im_5_7 0 s5 x11_im_a7 0 1892.026882
Gr12_re_5_7 0 s5 x12_re_a7 0 13377.08842
Gr12_im_5_7 0 s5 x12_im_a7 0 -33547.9592
Cx1_a5 x1_a5 0 3.599252385e-12
Gx1_a5 0 x1_a5 p5 0 0.01542312706
Fx1_a5 0 x1_a5 V5 0.771156353
Rp1_a5 0 x1_a5 1
Cx2_re_a5 x2_re_a5 0 5.856437181e-12
Gx2_re_a5 0 x2_re_a5 p5 0 3.928960576e-08
Fx2_re_a5 0 x2_re_a5 V5 1.964480288e-06
Rp2_re_re_a5 0 x2_re_a5 1
Gp2_re_im_a5 0 x2_re_a5 x2_im_a5 0 8.993009352
Cx2_im_a5 x2_im_a5 0 5.856437181e-12
Gp2_im_re_a5 0 x2_im_a5 x2_re_a5 0 -8.993009352
Rp2_im_im_a5 0 x2_im_a5 1
Cx3_re_a5 x3_re_a5 0 3.515400992e-12
Gx3_re_a5 0 x3_re_a5 p5 0 9.563687507e-08
Fx3_re_a5 0 x3_re_a5 V5 4.781843753e-06
Rp3_re_re_a5 0 x3_re_a5 1
Gp3_re_im_a5 0 x3_re_a5 x3_im_a5 0 1.725264232
Cx3_im_a5 x3_im_a5 0 3.515400992e-12
Gp3_im_re_a5 0 x3_im_a5 x3_re_a5 0 -1.725264232
Rp3_im_im_a5 0 x3_im_a5 1
Cx4_re_a5 x4_re_a5 0 3.685452367e-12
Gx4_re_a5 0 x4_re_a5 p5 0 7.571925366e-08
Fx4_re_a5 0 x4_re_a5 V5 3.785962683e-06
Rp4_re_re_a5 0 x4_re_a5 1
Gp4_re_im_a5 0 x4_re_a5 x4_im_a5 0 5.132870892
Cx4_im_a5 x4_im_a5 0 3.685452367e-12
Gp4_im_re_a5 0 x4_im_a5 x4_re_a5 0 -5.132870892
Rp4_im_im_a5 0 x4_im_a5 1
Cx5_re_a5 x5_re_a5 0 2.023593684e-12
Gx5_re_a5 0 x5_re_a5 p5 0 9.167247888e-08
Fx5_re_a5 0 x5_re_a5 V5 4.583623944e-06
Rp5_re_re_a5 0 x5_re_a5 1
Gp5_re_im_a5 0 x5_re_a5 x5_im_a5 0 1.938964343
Cx5_im_a5 x5_im_a5 0 2.023593684e-12
Gp5_im_re_a5 0 x5_im_a5 x5_re_a5 0 -1.938964343
Rp5_im_im_a5 0 x5_im_a5 1
Cx6_re_a5 x6_re_a5 0 1.536838407e-11
Gx6_re_a5 0 x6_re_a5 p5 0 3.211334105e-08
Fx6_re_a5 0 x6_re_a5 V5 1.605667052e-06
Rp6_re_re_a5 0 x6_re_a5 1
Gp6_re_im_a5 0 x6_re_a5 x6_im_a5 0 20.71158076
Cx6_im_a5 x6_im_a5 0 1.536838407e-11
Gp6_im_re_a5 0 x6_im_a5 x6_re_a5 0 -20.71158076
Rp6_im_im_a5 0 x6_im_a5 1
Cx7_re_a5 x7_re_a5 0 8.283721394e-12
Gx7_re_a5 0 x7_re_a5 p5 0 7.638313092e-08
Fx7_re_a5 0 x7_re_a5 V5 3.819156546e-06
Rp7_re_re_a5 0 x7_re_a5 1
Gp7_re_im_a5 0 x7_re_a5 x7_im_a5 0 7.243952262
Cx7_im_a5 x7_im_a5 0 8.283721394e-12
Gp7_im_re_a5 0 x7_im_a5 x7_re_a5 0 -7.243952262
Rp7_im_im_a5 0 x7_im_a5 1
Cx8_re_a5 x8_re_a5 0 6.26307816e-12
Gx8_re_a5 0 x8_re_a5 p5 0 9.557330869e-08
Fx8_re_a5 0 x8_re_a5 V5 4.778665434e-06
Rp8_re_re_a5 0 x8_re_a5 1
Gp8_re_im_a5 0 x8_re_a5 x8_im_a5 0 6.959167708
Cx8_im_a5 x8_im_a5 0 6.26307816e-12
Gp8_im_re_a5 0 x8_im_a5 x8_re_a5 0 -6.959167708
Rp8_im_im_a5 0 x8_im_a5 1
Cx9_re_a5 x9_re_a5 0 1.437227943e-11
Gx9_re_a5 0 x9_re_a5 p5 0 4.229472289e-08
Fx9_re_a5 0 x9_re_a5 V5 2.114736145e-06
Rp9_re_re_a5 0 x9_re_a5 1
Gp9_re_im_a5 0 x9_re_a5 x9_im_a5 0 16.64222601
Cx9_im_a5 x9_im_a5 0 1.437227943e-11
Gp9_im_re_a5 0 x9_im_a5 x9_re_a5 0 -16.64222601
Rp9_im_im_a5 0 x9_im_a5 1
Cx10_re_a5 x10_re_a5 0 3.091922882e-11
Gx10_re_a5 0 x10_re_a5 p5 0 3.015692117e-08
Fx10_re_a5 0 x10_re_a5 V5 1.507846058e-06
Rp10_re_re_a5 0 x10_re_a5 1
Gp10_re_im_a5 0 x10_re_a5 x10_im_a5 0 28.86213401
Cx10_im_a5 x10_im_a5 0 3.091922882e-11
Gp10_im_re_a5 0 x10_im_a5 x10_re_a5 0 -28.86213401
Rp10_im_im_a5 0 x10_im_a5 1
Cx11_re_a5 x11_re_a5 0 2.197240297e-11
Gx11_re_a5 0 x11_re_a5 p5 0 4.257249712e-08
Fx11_re_a5 0 x11_re_a5 V5 2.128624856e-06
Rp11_re_re_a5 0 x11_re_a5 1
Gp11_re_im_a5 0 x11_re_a5 x11_im_a5 0 23.68502501
Cx11_im_a5 x11_im_a5 0 2.197240297e-11
Gp11_im_re_a5 0 x11_im_a5 x11_re_a5 0 -23.68502501
Rp11_im_im_a5 0 x11_im_a5 1
Cx12_re_a5 x12_re_a5 0 2.154716074e-11
Gx12_re_a5 0 x12_re_a5 p5 0 4.24461719e-08
Fx12_re_a5 0 x12_re_a5 V5 2.122308595e-06
Rp12_re_re_a5 0 x12_re_a5 1
Gp12_re_im_a5 0 x12_re_a5 x12_im_a5 0 21.52683006
Cx12_im_a5 x12_im_a5 0 2.154716074e-11
Gp12_im_re_a5 0 x12_im_a5 x12_re_a5 0 -21.52683006
Rp12_im_im_a5 0 x12_im_a5 1
V6 p6 s6 0
R6 s6 0 50
Gd6_1 0 s6 p1 0 -0.0004381172044
Fd6_1 0 s6 V1 -0.02190586022
Gr1_6_1 0 s6 x1_a1 0 0.05935961372
Gr2_re_6_1 0 s6 x2_re_a1 0 9385.769054
Gr2_im_6_1 0 s6 x2_im_a1 0 -85375.85528
Gr3_re_6_1 0 s6 x3_re_a1 0 33126.12692
Gr3_im_6_1 0 s6 x3_im_a1 0 -18474.11556
Gr4_re_6_1 0 s6 x4_re_a1 0 -140638.6949
Gr4_im_6_1 0 s6 x4_im_a1 0 16006.48617
Gr5_re_6_1 0 s6 x5_re_a1 0 89783.7713
Gr5_im_6_1 0 s6 x5_im_a1 0 57715.75119
Gr6_re_6_1 0 s6 x6_re_a1 0 -3258.692025
Gr6_im_6_1 0 s6 x6_im_a1 0 -7035.696574
Gr7_re_6_1 0 s6 x7_re_a1 0 -36763.71763
Gr7_im_6_1 0 s6 x7_im_a1 0 64138.60773
Gr8_re_6_1 0 s6 x8_re_a1 0 -84278.09551
Gr8_im_6_1 0 s6 x8_im_a1 0 -467.4153811
Gr9_re_6_1 0 s6 x9_re_a1 0 -32087.86904
Gr9_im_6_1 0 s6 x9_im_a1 0 -38759.31664
Gr10_re_6_1 0 s6 x10_re_a1 0 -198647.416
Gr10_im_6_1 0 s6 x10_im_a1 0 -32737.6622
Gr11_re_6_1 0 s6 x11_re_a1 0 -19363.45902
Gr11_im_6_1 0 s6 x11_im_a1 0 266076.5676
Gr12_re_6_1 0 s6 x12_re_a1 0 209987.487
Gr12_im_6_1 0 s6 x12_im_a1 0 -78441.37296
Gd6_2 0 s6 p2 0 0.000615231747
Fd6_2 0 s6 V2 0.03076158735
Gr1_6_2 0 s6 x1_a2 0 -0.07314616431
Gr2_re_6_2 0 s6 x2_re_a2 0 195019.3297
Gr2_im_6_2 0 s6 x2_im_a2 0 -74305.49756
Gr3_re_6_2 0 s6 x3_re_a2 0 -191640.4549
Gr3_im_6_2 0 s6 x3_im_a2 0 -185563.7371
Gr4_re_6_2 0 s6 x4_re_a2 0 243767.3756
Gr4_im_6_2 0 s6 x4_im_a2 0 -226304.781
Gr5_re_6_2 0 s6 x5_re_a2 0 -117535.3502
Gr5_im_6_2 0 s6 x5_im_a2 0 54780.89877
Gr6_re_6_2 0 s6 x6_re_a2 0 145585.1316
Gr6_im_6_2 0 s6 x6_im_a2 0 -163168.7872
Gr7_re_6_2 0 s6 x7_re_a2 0 -148674.4936
Gr7_im_6_2 0 s6 x7_im_a2 0 -405875.1637
Gr8_re_6_2 0 s6 x8_re_a2 0 187905.7243
Gr8_im_6_2 0 s6 x8_im_a2 0 18225.34961
Gr9_re_6_2 0 s6 x9_re_a2 0 75523.04803
Gr9_im_6_2 0 s6 x9_im_a2 0 -178636.0717
Gr10_re_6_2 0 s6 x10_re_a2 0 100053.381
Gr10_im_6_2 0 s6 x10_im_a2 0 -33071.95019
Gr11_re_6_2 0 s6 x11_re_a2 0 -30637.64023
Gr11_im_6_2 0 s6 x11_im_a2 0 -100116.8339
Gr12_re_6_2 0 s6 x12_re_a2 0 41739.42994
Gr12_im_6_2 0 s6 x12_im_a2 0 -83910.48773
Gd6_3 0 s6 p3 0 -0.0001403675512
Fd6_3 0 s6 V3 -0.007018377562
Gr1_6_3 0 s6 x1_a3 0 0.4302745087
Gr2_re_6_3 0 s6 x2_re_a3 0 109399.0976
Gr2_im_6_3 0 s6 x2_im_a3 0 -797116.5815
Gr3_re_6_3 0 s6 x3_re_a3 0 -301300.7901
Gr3_im_6_3 0 s6 x3_im_a3 0 216771.8366
Gr4_re_6_3 0 s6 x4_re_a3 0 -768070.4791
Gr4_im_6_3 0 s6 x4_im_a3 0 425725.3743
Gr5_re_6_3 0 s6 x5_re_a3 0 531938.4124
Gr5_im_6_3 0 s6 x5_im_a3 0 -736500.4726
Gr6_re_6_3 0 s6 x6_re_a3 0 -32242.43211
Gr6_im_6_3 0 s6 x6_im_a3 0 414948.5393
Gr7_re_6_3 0 s6 x7_re_a3 0 412889.8036
Gr7_im_6_3 0 s6 x7_im_a3 0 545445.5867
Gr8_re_6_3 0 s6 x8_re_a3 0 -504015.0117
Gr8_im_6_3 0 s6 x8_im_a3 0 945850.4853
Gr9_re_6_3 0 s6 x9_re_a3 0 196521.841
Gr9_im_6_3 0 s6 x9_im_a3 0 -95597.06374
Gr10_re_6_3 0 s6 x10_re_a3 0 -10437.59118
Gr10_im_6_3 0 s6 x10_im_a3 0 228595.5376
Gr11_re_6_3 0 s6 x11_re_a3 0 328428.9691
Gr11_im_6_3 0 s6 x11_im_a3 0 -103434.1493
Gr12_re_6_3 0 s6 x12_re_a3 0 222586.5265
Gr12_im_6_3 0 s6 x12_im_a3 0 264295.1953
Gd6_4 0 s6 p4 0 0.00246900862
Fd6_4 0 s6 V4 0.123450431
Gr1_6_4 0 s6 x1_a4 0 -0.2119037122
Gr2_re_6_4 0 s6 x2_re_a4 0 -377238.5039
Gr2_im_6_4 0 s6 x2_im_a4 0 400479.6337
Gr3_re_6_4 0 s6 x3_re_a4 0 -375385.1681
Gr3_im_6_4 0 s6 x3_im_a4 0 262971.7622
Gr4_re_6_4 0 s6 x4_re_a4 0 846958.5398
Gr4_im_6_4 0 s6 x4_im_a4 0 501207.1843
Gr5_re_6_4 0 s6 x5_re_a4 0 -580469.6975
Gr5_im_6_4 0 s6 x5_im_a4 0 -976271.2095
Gr6_re_6_4 0 s6 x6_re_a4 0 400925.6498
Gr6_im_6_4 0 s6 x6_im_a4 0 -215025.4644
Gr7_re_6_4 0 s6 x7_re_a4 0 635997.1272
Gr7_im_6_4 0 s6 x7_im_a4 0 -125522.2958
Gr8_re_6_4 0 s6 x8_re_a4 0 595636.9428
Gr8_im_6_4 0 s6 x8_im_a4 0 783934.6432
Gr9_re_6_4 0 s6 x9_re_a4 0 181046.4423
Gr9_im_6_4 0 s6 x9_im_a4 0 -428162.3469
Gr10_re_6_4 0 s6 x10_re_a4 0 122732.4363
Gr10_im_6_4 0 s6 x10_im_a4 0 142748.4583
Gr11_re_6_4 0 s6 x11_re_a4 0 58194.18251
Gr11_im_6_4 0 s6 x11_im_a4 0 -325257.0691
Gr12_re_6_4 0 s6 x12_re_a4 0 320767.6104
Gr12_im_6_4 0 s6 x12_im_a4 0 -19429.16284
Gd6_5 0 s6 p5 0 0.001530679693
Fd6_5 0 s6 V5 0.07653398465
Gr1_6_5 0 s6 x1_a5 0 -0.771156353
Gr2_re_6_5 0 s6 x2_re_a5 0 154450.0966
Gr2_im_6_5 0 s6 x2_im_a5 0 -399651.6372
Gr3_re_6_5 0 s6 x3_re_a5 0 182216.6531
Gr3_im_6_5 0 s6 x3_im_a5 0 -168519.3246
Gr4_re_6_5 0 s6 x4_re_a5 0 -216263.7444
Gr4_im_6_5 0 s6 x4_im_a5 0 -156187.1465
Gr5_re_6_5 0 s6 x5_re_a5 0 -241443.1012
Gr5_im_6_5 0 s6 x5_im_a5 0 -242228.2921
Gr6_re_6_5 0 s6 x6_re_a5 0 -158384.2919
Gr6_im_6_5 0 s6 x6_im_a5 0 310284.3354
Gr7_re_6_5 0 s6 x7_re_a5 0 158539.4987
Gr7_im_6_5 0 s6 x7_im_a5 0 266300.3401
Gr8_re_6_5 0 s6 x8_re_a5 0 81966.88007
Gr8_im_6_5 0 s6 x8_im_a5 0 112260.3305
Gr9_re_6_5 0 s6 x9_re_a5 0 236019.9506
Gr9_im_6_5 0 s6 x9_im_a5 0 301967.9623
Gr10_re_6_5 0 s6 x10_re_a5 0 -113832.9379
Gr10_im_6_5 0 s6 x10_im_a5 0 53526.25573
Gr11_re_6_5 0 s6 x11_re_a5 0 143685.9912
Gr11_im_6_5 0 s6 x11_im_a5 0 33517.09975
Gr12_re_6_5 0 s6 x12_re_a5 0 3947.382557
Gr12_im_6_5 0 s6 x12_im_a5 0 172550.1246
Gd6_6 0 s6 p6 0 -0.003205948118
Fd6_6 0 s6 V6 -0.1602974059
Gr1_6_6 0 s6 x1_a6 0 -0.952347377
Gr2_re_6_6 0 s6 x2_re_a6 0 -372628.6878
Gr2_im_6_6 0 s6 x2_im_a6 0 518690.8124
Gr3_re_6_6 0 s6 x3_re_a6 0 137246.3779
Gr3_im_6_6 0 s6 x3_im_a6 0 -135789.8857
Gr4_re_6_6 0 s6 x4_re_a6 0 1137165.622
Gr4_im_6_6 0 s6 x4_im_a6 0 -81944.3212
Gr5_re_6_6 0 s6 x5_re_a6 0 -819904.4366
Gr5_im_6_6 0 s6 x5_im_a6 0 -33439.49959
Gr6_re_6_6 0 s6 x6_re_a6 0 300260.0938
Gr6_im_6_6 0 s6 x6_im_a6 0 -316463.2435
Gr7_re_6_6 0 s6 x7_re_a6 0 481119.2833
Gr7_im_6_6 0 s6 x7_im_a6 0 -252216.9024
Gr8_re_6_6 0 s6 x8_re_a6 0 732579.3782
Gr8_im_6_6 0 s6 x8_im_a6 0 -597196.2373
Gr9_re_6_6 0 s6 x9_re_a6 0 280052.461
Gr9_im_6_6 0 s6 x9_im_a6 0 -8539.897222
Gr10_re_6_6 0 s6 x10_re_a6 0 81481.92135
Gr10_im_6_6 0 s6 x10_im_a6 0 -9607.792131
Gr11_re_6_6 0 s6 x11_re_a6 0 -221524.3594
Gr11_im_6_6 0 s6 x11_im_a6 0 -145241.0884
Gr12_re_6_6 0 s6 x12_re_a6 0 120508.8164
Gr12_im_6_6 0 s6 x12_im_a6 0 -242305.2344
Gd6_7 0 s6 p7 0 -0.001557455498
Fd6_7 0 s6 V7 -0.07787277492
Gr1_6_7 0 s6 x1_a7 0 0.03091389314
Gr2_re_6_7 0 s6 x2_re_a7 0 -288637.7927
Gr2_im_6_7 0 s6 x2_im_a7 0 196691.7657
Gr3_re_6_7 0 s6 x3_re_a7 0 -24936.83259
Gr3_im_6_7 0 s6 x3_im_a7 0 -294677.8974
Gr4_re_6_7 0 s6 x4_re_a7 0 -122055.1287
Gr4_im_6_7 0 s6 x4_im_a7 0 279370.5519
Gr5_re_6_7 0 s6 x5_re_a7 0 264140.9923
Gr5_im_6_7 0 s6 x5_im_a7 0 188604.1993
Gr6_re_6_7 0 s6 x6_re_a7 0 180526.902
Gr6_im_6_7 0 s6 x6_im_a7 0 -169674.0586
Gr7_re_6_7 0 s6 x7_re_a7 0 -141980.8531
Gr7_im_6_7 0 s6 x7_im_a7 0 -329290.6691
Gr8_re_6_7 0 s6 x8_re_a7 0 -84751.67596
Gr8_im_6_7 0 s6 x8_im_a7 0 69699.57857
Gr9_re_6_7 0 s6 x9_re_a7 0 92667.76631
Gr9_im_6_7 0 s6 x9_im_a7 0 -173217.7788
Gr10_re_6_7 0 s6 x10_re_a7 0 116550.7084
Gr10_im_6_7 0 s6 x10_im_a7 0 -36048.13075
Gr11_re_6_7 0 s6 x11_re_a7 0 -78862.35074
Gr11_im_6_7 0 s6 x11_im_a7 0 -66599.22925
Gr12_re_6_7 0 s6 x12_re_a7 0 35315.37997
Gr12_im_6_7 0 s6 x12_im_a7 0 -148587.7719
Cx1_a6 x1_a6 0 3.599252385e-12
Gx1_a6 0 x1_a6 p6 0 0.01904694754
Fx1_a6 0 x1_a6 V6 0.952347377
Rp1_a6 0 x1_a6 1
Cx2_re_a6 x2_re_a6 0 5.856437181e-12
Gx2_re_a6 0 x2_re_a6 p6 0 4.605591724e-08
Fx2_re_a6 0 x2_re_a6 V6 2.302795862e-06
Rp2_re_re_a6 0 x2_re_a6 1
Gp2_re_im_a6 0 x2_re_a6 x2_im_a6 0 8.993009352
Cx2_im_a6 x2_im_a6 0 5.856437181e-12
Gp2_im_re_a6 0 x2_im_a6 x2_re_a6 0 -8.993009352
Rp2_im_im_a6 0 x2_im_a6 1
Cx3_re_a6 x3_re_a6 0 3.515400992e-12
Gx3_re_a6 0 x3_re_a6 p6 0 9.079240124e-08
Fx3_re_a6 0 x3_re_a6 V6 4.539620062e-06
Rp3_re_re_a6 0 x3_re_a6 1
Gp3_re_im_a6 0 x3_re_a6 x3_im_a6 0 1.725264232
Cx3_im_a6 x3_im_a6 0 3.515400992e-12
Gp3_im_re_a6 0 x3_im_a6 x3_re_a6 0 -1.725264232
Rp3_im_im_a6 0 x3_im_a6 1
Cx4_re_a6 x4_re_a6 0 3.685452367e-12
Gx4_re_a6 0 x4_re_a6 p6 0 7.544857048e-08
Fx4_re_a6 0 x4_re_a6 V6 3.772428524e-06
Rp4_re_re_a6 0 x4_re_a6 1
Gp4_re_im_a6 0 x4_re_a6 x4_im_a6 0 5.132870892
Cx4_im_a6 x4_im_a6 0 3.685452367e-12
Gp4_im_re_a6 0 x4_im_a6 x4_re_a6 0 -5.132870892
Rp4_im_im_a6 0 x4_im_a6 1
Cx5_re_a6 x5_re_a6 0 2.023593684e-12
Gx5_re_a6 0 x5_re_a6 p6 0 1.302836666e-07
Fx5_re_a6 0 x5_re_a6 V6 6.51418333e-06
Rp5_re_re_a6 0 x5_re_a6 1
Gp5_re_im_a6 0 x5_re_a6 x5_im_a6 0 1.938964343
Cx5_im_a6 x5_im_a6 0 2.023593684e-12
Gp5_im_re_a6 0 x5_im_a6 x5_re_a6 0 -1.938964343
Rp5_im_im_a6 0 x5_im_a6 1
Cx6_re_a6 x6_re_a6 0 1.536838407e-11
Gx6_re_a6 0 x6_re_a6 p6 0 3.821263748e-08
Fx6_re_a6 0 x6_re_a6 V6 1.910631874e-06
Rp6_re_re_a6 0 x6_re_a6 1
Gp6_re_im_a6 0 x6_re_a6 x6_im_a6 0 20.71158076
Cx6_im_a6 x6_im_a6 0 1.536838407e-11
Gp6_im_re_a6 0 x6_im_a6 x6_re_a6 0 -20.71158076
Rp6_im_im_a6 0 x6_im_a6 1
Cx7_re_a6 x7_re_a6 0 8.283721394e-12
Gx7_re_a6 0 x7_re_a6 p6 0 8.856378392e-08
Fx7_re_a6 0 x7_re_a6 V6 4.428189196e-06
Rp7_re_re_a6 0 x7_re_a6 1
Gp7_re_im_a6 0 x7_re_a6 x7_im_a6 0 7.243952262
Cx7_im_a6 x7_im_a6 0 8.283721394e-12
Gp7_im_re_a6 0 x7_im_a6 x7_re_a6 0 -7.243952262
Rp7_im_im_a6 0 x7_im_a6 1
Cx8_re_a6 x8_re_a6 0 6.26307816e-12
Gx8_re_a6 0 x8_re_a6 p6 0 1.021865546e-07
Fx8_re_a6 0 x8_re_a6 V6 5.109327732e-06
Rp8_re_re_a6 0 x8_re_a6 1
Gp8_re_im_a6 0 x8_re_a6 x8_im_a6 0 6.959167708
Cx8_im_a6 x8_im_a6 0 6.26307816e-12
Gp8_im_re_a6 0 x8_im_a6 x8_re_a6 0 -6.959167708
Rp8_im_im_a6 0 x8_im_a6 1
Cx9_re_a6 x9_re_a6 0 1.437227943e-11
Gx9_re_a6 0 x9_re_a6 p6 0 4.366045093e-08
Fx9_re_a6 0 x9_re_a6 V6 2.183022546e-06
Rp9_re_re_a6 0 x9_re_a6 1
Gp9_re_im_a6 0 x9_re_a6 x9_im_a6 0 16.64222601
Cx9_im_a6 x9_im_a6 0 1.437227943e-11
Gp9_im_re_a6 0 x9_im_a6 x9_re_a6 0 -16.64222601
Rp9_im_im_a6 0 x9_im_a6 1
Cx10_re_a6 x10_re_a6 0 3.091922882e-11
Gx10_re_a6 0 x10_re_a6 p6 0 3.343439917e-08
Fx10_re_a6 0 x10_re_a6 V6 1.671719959e-06
Rp10_re_re_a6 0 x10_re_a6 1
Gp10_re_im_a6 0 x10_re_a6 x10_im_a6 0 28.86213401
Cx10_im_a6 x10_im_a6 0 3.091922882e-11
Gp10_im_re_a6 0 x10_im_a6 x10_re_a6 0 -28.86213401
Rp10_im_im_a6 0 x10_im_a6 1
Cx11_re_a6 x11_re_a6 0 2.197240297e-11
Gx11_re_a6 0 x11_re_a6 p6 0 4.263201213e-08
Fx11_re_a6 0 x11_re_a6 V6 2.131600607e-06
Rp11_re_re_a6 0 x11_re_a6 1
Gp11_re_im_a6 0 x11_re_a6 x11_im_a6 0 23.68502501
Cx11_im_a6 x11_im_a6 0 2.197240297e-11
Gp11_im_re_a6 0 x11_im_a6 x11_re_a6 0 -23.68502501
Rp11_im_im_a6 0 x11_im_a6 1
Cx12_re_a6 x12_re_a6 0 2.154716074e-11
Gx12_re_a6 0 x12_re_a6 p6 0 4.15792399e-08
Fx12_re_a6 0 x12_re_a6 V6 2.078961995e-06
Rp12_re_re_a6 0 x12_re_a6 1
Gp12_re_im_a6 0 x12_re_a6 x12_im_a6 0 21.52683006
Cx12_im_a6 x12_im_a6 0 2.154716074e-11
Gp12_im_re_a6 0 x12_im_a6 x12_re_a6 0 -21.52683006
Rp12_im_im_a6 0 x12_im_a6 1
V7 p7 s7 0
R7 s7 0 50
Gd7_1 0 s7 p1 0 -7.045346301e-05
Fd7_1 0 s7 V1 -0.003522673151
Gr1_7_1 0 s7 x1_a1 0 -0.002677672703
Gr2_re_7_1 0 s7 x2_re_a1 0 -10803.26388
Gr2_im_7_1 0 s7 x2_im_a1 0 -13667.44606
Gr3_re_7_1 0 s7 x3_re_a1 0 -1996.059702
Gr3_im_7_1 0 s7 x3_im_a1 0 644.1273843
Gr4_re_7_1 0 s7 x4_re_a1 0 -9704.402561
Gr4_im_7_1 0 s7 x4_im_a1 0 25490.4486
Gr5_re_7_1 0 s7 x5_re_a1 0 8662.263087
Gr5_im_7_1 0 s7 x5_im_a1 0 -8912.249534
Gr6_re_7_1 0 s7 x6_re_a1 0 -1550.599028
Gr6_im_7_1 0 s7 x6_im_a1 0 -9387.744735
Gr7_re_7_1 0 s7 x7_re_a1 0 16478.57158
Gr7_im_7_1 0 s7 x7_im_a1 0 9122.263749
Gr8_re_7_1 0 s7 x8_re_a1 0 93.51748672
Gr8_im_7_1 0 s7 x8_im_a1 0 11526.45254
Gr9_re_7_1 0 s7 x9_re_a1 0 -14994.5729
Gr9_im_7_1 0 s7 x9_im_a1 0 -9802.056078
Gr10_re_7_1 0 s7 x10_re_a1 0 -15360.34391
Gr10_im_7_1 0 s7 x10_im_a1 0 61478.74916
Gr11_re_7_1 0 s7 x11_re_a1 0 20504.7947
Gr11_im_7_1 0 s7 x11_im_a1 0 26161.09674
Gr12_re_7_1 0 s7 x12_re_a1 0 -13740.88619
Gr12_im_7_1 0 s7 x12_im_a1 0 -37745.90371
Gd7_2 0 s7 p2 0 0.003979981604
Fd7_2 0 s7 V2 0.1989990802
Gr1_7_2 0 s7 x1_a2 0 -0.6785107484
Gr2_re_7_2 0 s7 x2_re_a2 0 -30956.22924
Gr2_im_7_2 0 s7 x2_im_a2 0 443145.0722
Gr3_re_7_2 0 s7 x3_re_a2 0 -261502.6221
Gr3_im_7_2 0 s7 x3_im_a2 0 279521.6109
Gr4_re_7_2 0 s7 x4_re_a2 0 529537.9036
Gr4_im_7_2 0 s7 x4_im_a2 0 -96074.61688
Gr5_re_7_2 0 s7 x5_re_a2 0 -508898.0648
Gr5_im_7_2 0 s7 x5_im_a2 0 -930735.1465
Gr6_re_7_2 0 s7 x6_re_a2 0 -44758.70082
Gr6_im_7_2 0 s7 x6_im_a2 0 -160191.9274
Gr7_re_7_2 0 s7 x7_re_a2 0 -135973.8927
Gr7_im_7_2 0 s7 x7_im_a2 0 166718.2907
Gr8_re_7_2 0 s7 x8_re_a2 0 606698.2052
Gr8_im_7_2 0 s7 x8_im_a2 0 231055.0135
Gr9_re_7_2 0 s7 x9_re_a2 0 -123134.7162
Gr9_im_7_2 0 s7 x9_im_a2 0 58537.17851
Gr10_re_7_2 0 s7 x10_re_a2 0 -28146.81415
Gr10_im_7_2 0 s7 x10_im_a2 0 -20999.56806
Gr11_re_7_2 0 s7 x11_re_a2 0 -38539.22293
Gr11_im_7_2 0 s7 x11_im_a2 0 -47069.34019
Gr12_re_7_2 0 s7 x12_re_a2 0 -9499.430807
Gr12_im_7_2 0 s7 x12_im_a2 0 13575.74627
Gd7_3 0 s7 p3 0 -0.001134031053
Fd7_3 0 s7 V3 -0.05670155267
Gr1_7_3 0 s7 x1_a3 0 0.6305248042
Gr2_re_7_3 0 s7 x2_re_a3 0 1304.147613
Gr2_im_7_3 0 s7 x2_im_a3 0 -150892.2438
Gr3_re_7_3 0 s7 x3_re_a3 0 -24763.44561
Gr3_im_7_3 0 s7 x3_im_a3 0 -222432.739
Gr4_re_7_3 0 s7 x4_re_a3 0 -547465.8153
Gr4_im_7_3 0 s7 x4_im_a3 0 63583.94935
Gr5_re_7_3 0 s7 x5_re_a3 0 265489.8263
Gr5_im_7_3 0 s7 x5_im_a3 0 440087.4921
Gr6_re_7_3 0 s7 x6_re_a3 0 18180.09058
Gr6_im_7_3 0 s7 x6_im_a3 0 128970.6322
Gr7_re_7_3 0 s7 x7_re_a3 0 170970.0137
Gr7_im_7_3 0 s7 x7_im_a3 0 -85048.24238
Gr8_re_7_3 0 s7 x8_re_a3 0 139917.8618
Gr8_im_7_3 0 s7 x8_im_a3 0 -3139.60251
Gr9_re_7_3 0 s7 x9_re_a3 0 26034.32713
Gr9_im_7_3 0 s7 x9_im_a3 0 -20799.66347
Gr10_re_7_3 0 s7 x10_re_a3 0 65345.7761
Gr10_im_7_3 0 s7 x10_im_a3 0 70968.4703
Gr11_re_7_3 0 s7 x11_re_a3 0 49154.86074
Gr11_im_7_3 0 s7 x11_im_a3 0 -73449.6193
Gr12_re_7_3 0 s7 x12_re_a3 0 111416.8023
Gr12_im_7_3 0 s7 x12_im_a3 0 7284.544177
Gd7_4 0 s7 p4 0 0.00076092164
Fd7_4 0 s7 V4 0.038046082
Gr1_7_4 0 s7 x1_a4 0 -0.05016100139
Gr2_re_7_4 0 s7 x2_re_a4 0 128593.8929
Gr2_im_7_4 0 s7 x2_im_a4 0 -56758.68792
Gr3_re_7_4 0 s7 x3_re_a4 0 -181526.5776
Gr3_im_7_4 0 s7 x3_im_a4 0 -149117.0826
Gr4_re_7_4 0 s7 x4_re_a4 0 202584.4738
Gr4_im_7_4 0 s7 x4_im_a4 0 -159393.1672
Gr5_re_7_4 0 s7 x5_re_a4 0 -113594.3465
Gr5_im_7_4 0 s7 x5_im_a4 0 13458.39923
Gr6_re_7_4 0 s7 x6_re_a4 0 85348.91947
Gr6_im_7_4 0 s7 x6_im_a4 0 -61320.95321
Gr7_re_7_4 0 s7 x7_re_a4 0 -78067.29746
Gr7_im_7_4 0 s7 x7_im_a4 0 -228708.1886
Gr8_re_7_4 0 s7 x8_re_a4 0 167953.0672
Gr8_im_7_4 0 s7 x8_im_a4 0 28813.86669
Gr9_re_7_4 0 s7 x9_re_a4 0 37558.57783
Gr9_im_7_4 0 s7 x9_im_a4 0 -93891.97574
Gr10_re_7_4 0 s7 x10_re_a4 0 55220.25439
Gr10_im_7_4 0 s7 x10_im_a4 0 -16605.38658
Gr11_re_7_4 0 s7 x11_re_a4 0 -16384.95604
Gr11_im_7_4 0 s7 x11_im_a4 0 -56670.82316
Gr12_re_7_4 0 s7 x12_re_a4 0 28405.29709
Gr12_im_7_4 0 s7 x12_im_a4 0 -46524.0271
Gd7_5 0 s7 p5 0 0.0004369104603
Fd7_5 0 s7 V5 0.02184552301
Gr1_7_5 0 s7 x1_a5 0 0.1966707875
Gr2_re_7_5 0 s7 x2_re_a5 0 231077.7264
Gr2_im_7_5 0 s7 x2_im_a5 0 -268383.0439
Gr3_re_7_5 0 s7 x3_re_a5 0 83996.38801
Gr3_im_7_5 0 s7 x3_im_a5 0 -265293.9382
Gr4_re_7_5 0 s7 x4_re_a5 0 87915.17796
Gr4_im_7_5 0 s7 x4_im_a5 0 -321785.7584
Gr5_re_7_5 0 s7 x5_re_a5 0 -249232.2102
Gr5_im_7_5 0 s7 x5_im_a5 0 469540.4806
Gr6_re_7_5 0 s7 x6_re_a5 0 -28547.97732
Gr6_im_7_5 0 s7 x6_im_a5 0 104521.3691
Gr7_re_7_5 0 s7 x7_re_a5 0 75087.12623
Gr7_im_7_5 0 s7 x7_im_a5 0 -232973.9045
Gr8_re_7_5 0 s7 x8_re_a5 0 122862.4272
Gr8_im_7_5 0 s7 x8_im_a5 0 -140749.4183
Gr9_re_7_5 0 s7 x9_re_a5 0 74499.21305
Gr9_im_7_5 0 s7 x9_im_a5 0 97888.02133
Gr10_re_7_5 0 s7 x10_re_a5 0 18082.70929
Gr10_im_7_5 0 s7 x10_im_a5 0 -1003.971532
Gr11_re_7_5 0 s7 x11_re_a5 0 -2879.338433
Gr11_im_7_5 0 s7 x11_im_a5 0 970.0317573
Gr12_re_7_5 0 s7 x12_re_a5 0 7596.518061
Gr12_im_7_5 0 s7 x12_im_a5 0 -19051.05728
Gd7_6 0 s7 p6 0 -0.001557455498
Fd7_6 0 s7 V6 -0.07787277491
Gr1_7_6 0 s7 x1_a6 0 0.02322503676
Gr2_re_7_6 0 s7 x2_re_a6 0 -204018.4252
Gr2_im_7_6 0 s7 x2_im_a6 0 139028.0321
Gr3_re_7_6 0 s7 x3_re_a6 0 -22442.39807
Gr3_im_7_6 0 s7 x3_im_a6 0 -265201.23
Gr4_re_7_6 0 s7 x4_re_a6 0 -94030.15739
Gr4_im_7_6 0 s7 x4_im_a6 0 215224.5238
Gr5_re_7_6 0 s7 x5_re_a6 0 211599.8657
Gr5_im_7_6 0 s7 x5_im_a6 0 151088.3369
Gr6_re_7_6 0 s7 x6_re_a6 0 93641.36055
Gr6_im_7_6 0 s7 x6_im_a6 0 -88011.86705
Gr7_re_7_6 0 s7 x7_re_a6 0 -82267.54741
Gr7_im_7_6 0 s7 x7_im_a6 0 -190799.9222
Gr8_re_7_6 0 s7 x8_re_a6 0 -62173.19801
Gr8_im_7_6 0 s7 x8_im_a6 0 51131.09149
Gr9_re_7_6 0 s7 x9_re_a6 0 51611.38453
Gr9_im_7_6 0 s7 x9_im_a6 0 -96473.77664
Gr10_re_7_6 0 s7 x10_re_a6 0 65343.3763
Gr10_im_7_6 0 s7 x10_im_a6 0 -20210.14376
Gr11_re_7_6 0 s7 x11_re_a6 0 -40375.84896
Gr11_im_7_6 0 s7 x11_im_a6 0 -34097.39115
Gr12_re_7_6 0 s7 x12_re_a6 0 20472.87536
Gr12_im_7_6 0 s7 x12_im_a6 0 -86138.64376
Gd7_7 0 s7 p7 0 -0.001994356881
Fd7_7 0 s7 V7 -0.09971784406
Gr1_7_7 0 s7 x1_a7 0 -0.7154809881
Gr2_re_7_7 0 s7 x2_re_a7 0 16100.34452
Gr2_im_7_7 0 s7 x2_im_a7 0 180159.0488
Gr3_re_7_7 0 s7 x3_re_a7 0 -167303.3305
Gr3_im_7_7 0 s7 x3_im_a7 0 281855.5882
Gr4_re_7_7 0 s7 x4_re_a7 0 781668.0723
Gr4_im_7_7 0 s7 x4_im_a7 0 -364151.8216
Gr5_re_7_7 0 s7 x5_re_a7 0 -535552.2392
Gr5_im_7_7 0 s7 x5_im_a7 0 -308641.9109
Gr6_re_7_7 0 s7 x6_re_a7 0 -98632.35675
Gr6_im_7_7 0 s7 x6_im_a7 0 -142254.3345
Gr7_re_7_7 0 s7 x7_re_a7 0 -182015.713
Gr7_im_7_7 0 s7 x7_im_a7 0 129274.5839
Gr8_re_7_7 0 s7 x8_re_a7 0 392638.619
Gr8_im_7_7 0 s7 x8_im_a7 0 -573723.4538
Gr9_re_7_7 0 s7 x9_re_a7 0 36010.12033
Gr9_im_7_7 0 s7 x9_im_a7 0 305927.6684
Gr10_re_7_7 0 s7 x10_re_a7 0 -36805.57167
Gr10_im_7_7 0 s7 x10_im_a7 0 -92650.4635
Gr11_re_7_7 0 s7 x11_re_a7 0 -195408.3042
Gr11_im_7_7 0 s7 x11_im_a7 0 97349.73692
Gr12_re_7_7 0 s7 x12_re_a7 0 -115879.9688
Gr12_im_7_7 0 s7 x12_im_a7 0 -108964.2293
Cx1_a7 x1_a7 0 3.599252385e-12
Gx1_a7 0 x1_a7 p7 0 0.01430961976
Fx1_a7 0 x1_a7 V7 0.7154809881
Rp1_a7 0 x1_a7 1
Cx2_re_a7 x2_re_a7 0 5.856437181e-12
Gx2_re_a7 0 x2_re_a7 p7 0 3.255379561e-08
Fx2_re_a7 0 x2_re_a7 V7 1.62768978e-06
Rp2_re_re_a7 0 x2_re_a7 1
Gp2_re_im_a7 0 x2_re_a7 x2_im_a7 0 8.993009352
Cx2_im_a7 x2_im_a7 0 5.856437181e-12
Gp2_im_re_a7 0 x2_im_a7 x2_re_a7 0 -8.993009352
Rp2_im_im_a7 0 x2_im_a7 1
Cx3_re_a7 x3_re_a7 0 3.515400992e-12
Gx3_re_a7 0 x3_re_a7 p7 0 8.171042586e-08
Fx3_re_a7 0 x3_re_a7 V7 4.085521293e-06
Rp3_re_re_a7 0 x3_re_a7 1
Gp3_re_im_a7 0 x3_re_a7 x3_im_a7 0 1.725264232
Cx3_im_a7 x3_im_a7 0 3.515400992e-12
Gp3_im_re_a7 0 x3_im_a7 x3_re_a7 0 -1.725264232
Rp3_im_im_a7 0 x3_im_a7 1
Cx4_re_a7 x4_re_a7 0 3.685452367e-12
Gx4_re_a7 0 x4_re_a7 p7 0 5.812489021e-08
Fx4_re_a7 0 x4_re_a7 V7 2.906244511e-06
Rp4_re_re_a7 0 x4_re_a7 1
Gp4_re_im_a7 0 x4_re_a7 x4_im_a7 0 5.132870892
Cx4_im_a7 x4_im_a7 0 3.685452367e-12
Gp4_im_re_a7 0 x4_im_a7 x4_re_a7 0 -5.132870892
Rp4_im_im_a7 0 x4_im_a7 1
Cx5_re_a7 x5_re_a7 0 2.023593684e-12
Gx5_re_a7 0 x5_re_a7 p7 0 1.043685273e-07
Fx5_re_a7 0 x5_re_a7 V7 5.218426364e-06
Rp5_re_re_a7 0 x5_re_a7 1
Gp5_re_im_a7 0 x5_re_a7 x5_im_a7 0 1.938964343
Cx5_im_a7 x5_im_a7 0 2.023593684e-12
Gp5_im_re_a7 0 x5_im_a7 x5_re_a7 0 -1.938964343
Rp5_im_im_a7 0 x5_im_a7 1
Cx6_re_a7 x6_re_a7 0 1.536838407e-11
Gx6_re_a7 0 x6_re_a7 p7 0 1.982133036e-08
Fx6_re_a7 0 x6_re_a7 V7 9.910665181e-07
Rp6_re_re_a7 0 x6_re_a7 1
Gp6_re_im_a7 0 x6_re_a7 x6_im_a7 0 20.71158076
Cx6_im_a7 x6_im_a7 0 1.536838407e-11
Gp6_im_re_a7 0 x6_im_a7 x6_re_a7 0 -20.71158076
Rp6_im_im_a7 0 x6_im_a7 1
Cx7_re_a7 x7_re_a7 0 8.283721394e-12
Gx7_re_a7 0 x7_re_a7 p7 0 5.131625237e-08
Fx7_re_a7 0 x7_re_a7 V7 2.565812619e-06
Rp7_re_re_a7 0 x7_re_a7 1
Gp7_re_im_a7 0 x7_re_a7 x7_im_a7 0 7.243952262
Cx7_im_a7 x7_im_a7 0 8.283721394e-12
Gp7_im_re_a7 0 x7_im_a7 x7_re_a7 0 -7.243952262
Rp7_im_im_a7 0 x7_im_a7 1
Cx8_re_a7 x8_re_a7 0 6.26307816e-12
Gx8_re_a7 0 x8_re_a7 p7 0 7.496329511e-08
Fx8_re_a7 0 x8_re_a7 V7 3.748164755e-06
Rp8_re_re_a7 0 x8_re_a7 1
Gp8_re_im_a7 0 x8_re_a7 x8_im_a7 0 6.959167708
Cx8_im_a7 x8_im_a7 0 6.26307816e-12
Gp8_im_re_a7 0 x8_im_a7 x8_re_a7 0 -6.959167708
Rp8_im_im_a7 0 x8_im_a7 1
Cx9_re_a7 x9_re_a7 0 1.437227943e-11
Gx9_re_a7 0 x9_re_a7 p7 0 2.431672211e-08
Fx9_re_a7 0 x9_re_a7 V7 1.215836105e-06
Rp9_re_re_a7 0 x9_re_a7 1
Gp9_re_im_a7 0 x9_re_a7 x9_im_a7 0 16.64222601
Cx9_im_a7 x9_im_a7 0 1.437227943e-11
Gp9_im_re_a7 0 x9_im_a7 x9_re_a7 0 -16.64222601
Rp9_im_im_a7 0 x9_im_a7 1
Cx10_re_a7 x10_re_a7 0 3.091922882e-11
Gx10_re_a7 0 x10_re_a7 p7 0 1.874477261e-08
Fx10_re_a7 0 x10_re_a7 V7 9.372386304e-07
Rp10_re_re_a7 0 x10_re_a7 1
Gp10_re_im_a7 0 x10_re_a7 x10_im_a7 0 28.86213401
Cx10_im_a7 x10_im_a7 0 3.091922882e-11
Gp10_im_re_a7 0 x10_im_a7 x10_re_a7 0 -28.86213401
Rp10_im_im_a7 0 x10_im_a7 1
Cx11_re_a7 x11_re_a7 0 2.197240297e-11
Gx11_re_a7 0 x11_re_a7 p7 0 2.182668493e-08
Fx11_re_a7 0 x11_re_a7 V7 1.091334247e-06
Rp11_re_re_a7 0 x11_re_a7 1
Gp11_re_im_a7 0 x11_re_a7 x11_im_a7 0 23.68502501
Cx11_im_a7 x11_im_a7 0 2.197240297e-11
Gp11_im_re_a7 0 x11_im_a7 x11_re_a7 0 -23.68502501
Rp11_im_im_a7 0 x11_im_a7 1
Cx12_re_a7 x12_re_a7 0 2.154716074e-11
Gx12_re_a7 0 x12_re_a7 p7 0 2.410413245e-08
Fx12_re_a7 0 x12_re_a7 V7 1.205206623e-06
Rp12_re_re_a7 0 x12_re_a7 1
Gp12_re_im_a7 0 x12_re_a7 x12_im_a7 0 21.52683006
Cx12_im_a7 x12_im_a7 0 2.154716074e-11
Gp12_im_re_a7 0 x12_im_a7 x12_re_a7 0 -21.52683006
Rp12_im_im_a7 0 x12_im_a7 1
.ENDS sparx_core_le
