* sparx_bpf_le - lumped-element equivalent (Ngspice / SPICE3)
* generated by snp2le
* EQUIVALENT CIRCUIT FOR VECTOR FITTED S-MATRIX
* Created using scikit-rf vectorFitting.py
*
*
.SUBCKT sparx_bpf_le p1 p2
V1 p1 s1 0
R1 s1 0 50
Gd1_1 0 s1 p1 0 -0.01123545519
Fd1_1 0 s1 V1 -0.5617727596
Gr1_re_1_1 0 s1 x1_re_a1 0 294169.68
Gr1_im_1_1 0 s1 x1_im_a1 0 1332096.802
Gr2_1_1 0 s1 x2_a1 0 1.583873875
Gr3_re_1_1 0 s1 x3_re_a1 0 972472.7727
Gr3_im_1_1 0 s1 x3_im_a1 0 283887.4505
Gr4_re_1_1 0 s1 x4_re_a1 0 181796.7168
Gr4_im_1_1 0 s1 x4_im_a1 0 337725.604
Gr5_re_1_1 0 s1 x5_re_a1 0 331356.5498
Gr5_im_1_1 0 s1 x5_im_a1 0 -72053.72691
Gr6_re_1_1 0 s1 x6_re_a1 0 423473.6609
Gr6_im_1_1 0 s1 x6_im_a1 0 -157964.806
Gr7_re_1_1 0 s1 x7_re_a1 0 310487.4699
Gr7_im_1_1 0 s1 x7_im_a1 0 -291835.9645
Gd1_2 0 s1 p2 0 3.437903861e-05
Fd1_2 0 s1 V2 0.00171895193
Gr1_re_1_2 0 s1 x1_re_a2 0 -2773.538951
Gr1_im_1_2 0 s1 x1_im_a2 0 -3618.314203
Gr2_1_2 0 s1 x2_a2 0 -0.001757037165
Gr3_re_1_2 0 s1 x3_re_a2 0 39406.7567
Gr3_im_1_2 0 s1 x3_im_a2 0 41855.51262
Gr4_re_1_2 0 s1 x4_re_a2 0 -73177.50783
Gr4_im_1_2 0 s1 x4_im_a2 0 -196266.3809
Gr5_re_1_2 0 s1 x5_re_a2 0 -326206.9055
Gr5_im_1_2 0 s1 x5_im_a2 0 98602.58934
Gr6_re_1_2 0 s1 x6_re_a2 0 413463.7682
Gr6_im_1_2 0 s1 x6_im_a2 0 -177398.1174
Gr7_re_1_2 0 s1 x7_re_a2 0 -293948.266
Gr7_im_1_2 0 s1 x7_im_a2 0 312866.1243
Cx1_re_a1 x1_re_a1 0 1.011233988e-12
Gx1_re_a1 0 x1_re_a1 p1 0 4.01098296e-08
Fx1_re_a1 0 x1_re_a1 V1 2.00549148e-06
Rp1_re_re_a1 0 x1_re_a1 1
Gp1_re_im_a1 0 x1_re_a1 x1_im_a1 0 2.231940874
Cx1_im_a1 x1_im_a1 0 1.011233988e-12
Gp1_im_re_a1 0 x1_im_a1 x1_re_a1 0 -2.231940874
Rp1_im_im_a1 0 x1_im_a1 1
Cx2_a1 x2_a1 0 2.496532956e-12
Gx2_a1 0 x2_a1 p1 0 0.0316774775
Fx2_a1 0 x2_a1 V1 1.583873875
Rp2_a1 0 x2_a1 1
Cx3_re_a1 x3_re_a1 0 9.892471124e-12
Gx3_re_a1 0 x3_re_a1 p1 0 6.331691544e-08
Fx3_re_a1 0 x3_re_a1 V1 3.165845772e-06
Rp3_re_re_a1 0 x3_re_a1 1
Gp3_re_im_a1 0 x3_re_a1 x3_im_a1 0 11.6094558
Cx3_im_a1 x3_im_a1 0 9.892471124e-12
Gp3_im_re_a1 0 x3_im_a1 x3_re_a1 0 -11.6094558
Rp3_im_im_a1 0 x3_im_a1 1
Cx4_re_a1 x4_re_a1 0 1.324281426e-11
Gx4_re_a1 0 x4_re_a1 p1 0 2.992596e-08
Fx4_re_a1 0 x4_re_a1 V1 1.496298e-06
Rp4_re_re_a1 0 x4_re_a1 1
Gp4_re_im_a1 0 x4_re_a1 x4_im_a1 0 15.50680072
Cx4_im_a1 x4_im_a1 0 1.324281426e-11
Gp4_im_re_a1 0 x4_im_a1 x4_re_a1 0 -15.50680072
Rp4_im_im_a1 0 x4_im_a1 1
Cx5_re_a1 x5_re_a1 0 3.907772244e-11
Gx5_re_a1 0 x5_re_a1 p1 0 2.764808462e-08
Fx5_re_a1 0 x5_re_a1 V1 1.382404231e-06
Rp5_re_re_a1 0 x5_re_a1 1
Gp5_re_im_a1 0 x5_re_a1 x5_im_a1 0 36.18015431
Cx5_im_a1 x5_im_a1 0 3.907772244e-11
Gp5_im_re_a1 0 x5_im_a1 x5_re_a1 0 -36.18015431
Rp5_im_im_a1 0 x5_im_a1 1
Cx6_re_a1 x6_re_a1 0 2.768289015e-11
Gx6_re_a1 0 x6_re_a1 p1 0 3.959051221e-08
Fx6_re_a1 0 x6_re_a1 V1 1.979525611e-06
Rp6_re_re_a1 0 x6_re_a1 1
Gp6_re_im_a1 0 x6_re_a1 x6_im_a1 0 27.40708138
Cx6_im_a1 x6_im_a1 0 2.768289015e-11
Gp6_im_re_a1 0 x6_im_a1 x6_re_a1 0 -27.40708138
Rp6_im_im_a1 0 x6_im_a1 1
Cx7_re_a1 x7_re_a1 0 2.769933638e-11
Gx7_re_a1 0 x7_re_a1 p1 0 4.109832512e-08
Fx7_re_a1 0 x7_re_a1 V1 2.054916256e-06
Rp7_re_re_a1 0 x7_re_a1 1
Gp7_re_im_a1 0 x7_re_a1 x7_im_a1 0 29.60557976
Cx7_im_a1 x7_im_a1 0 2.769933638e-11
Gp7_im_re_a1 0 x7_im_a1 x7_re_a1 0 -29.60557976
Rp7_im_im_a1 0 x7_im_a1 1
V2 p2 s2 0
R2 s2 0 50
Gd2_1 0 s2 p1 0 3.437903861e-05
Fd2_1 0 s2 V1 0.001718951931
Gr1_re_2_1 0 s2 x1_re_a1 0 -3453.094546
Gr1_im_2_1 0 s2 x1_im_a1 0 -4504.851478
Gr2_2_1 0 s2 x2_a1 0 -0.00178962507
Gr3_re_2_1 0 s2 x3_re_a1 0 31350.06109
Gr3_im_2_1 0 s2 x3_im_a1 0 33298.16984
Gr4_re_2_1 0 s2 x4_re_a1 0 -76964.18181
Gr4_im_2_1 0 s2 x4_im_a1 0 -206422.4633
Gr5_re_2_1 0 s2 x5_re_a1 0 -327108.4154
Gr5_im_2_1 0 s2 x5_im_a1 0 98875.08882
Gr6_re_2_1 0 s2 x6_re_a1 0 422782.5113
Gr6_im_2_1 0 s2 x6_im_a1 0 -181396.3576
Gr7_re_2_1 0 s2 x7_re_a1 0 -291940.9017
Gr7_im_2_1 0 s2 x7_im_a1 0 310729.5705
Gd2_2 0 s2 p2 0 -0.01171588976
Fd2_2 0 s2 V2 -0.5857944879
Gr1_re_2_2 0 s2 x1_re_a2 0 469274.7747
Gr1_im_2_2 0 s2 x1_im_a2 0 1294359.406
Gr2_2_2 0 s2 x2_a2 0 1.613250108
Gr3_re_2_2 0 s2 x3_re_a2 0 1483001.547
Gr3_im_2_2 0 s2 x3_im_a2 0 117819.5715
Gr4_re_2_2 0 s2 x4_re_a2 0 -135511.5673
Gr4_im_2_2 0 s2 x4_im_a2 0 501182.3155
Gr5_re_2_2 0 s2 x5_re_a2 0 319174.0016
Gr5_im_2_2 0 s2 x5_im_a2 0 -100991.8736
Gr6_re_2_2 0 s2 x6_re_a2 0 389880.398
Gr6_im_2_2 0 s2 x6_im_a2 0 -194256.9737
Gr7_re_2_2 0 s2 x7_re_a2 0 269933.2089
Gr7_im_2_2 0 s2 x7_im_a2 0 -323745.5782
Cx1_re_a2 x1_re_a2 0 1.011233988e-12
Gx1_re_a2 0 x1_re_a2 p2 0 4.993729538e-08
Fx1_re_a2 0 x1_re_a2 V2 2.496864769e-06
Rp1_re_re_a2 0 x1_re_a2 1
Gp1_re_im_a2 0 x1_re_a2 x1_im_a2 0 2.231940874
Cx1_im_a2 x1_im_a2 0 1.011233988e-12
Gp1_im_re_a2 0 x1_im_a2 x1_re_a2 0 -2.231940874
Rp1_im_im_a2 0 x1_im_a2 1
Cx2_a2 x2_a2 0 2.496532956e-12
Gx2_a2 0 x2_a2 p2 0 0.03226500215
Fx2_a2 0 x2_a2 V2 1.613250108
Rp2_a2 0 x2_a2 1
Cx3_re_a2 x3_re_a2 0 9.892471124e-12
Gx3_re_a2 0 x3_re_a2 p2 0 5.037179745e-08
Fx3_re_a2 0 x3_re_a2 V2 2.518589873e-06
Rp3_re_re_a2 0 x3_re_a2 1
Gp3_re_im_a2 0 x3_re_a2 x3_im_a2 0 11.6094558
Cx3_im_a2 x3_im_a2 0 9.892471124e-12
Gp3_im_re_a2 0 x3_im_a2 x3_re_a2 0 -11.6094558
Rp3_im_im_a2 0 x3_im_a2 1
Cx4_re_a2 x4_re_a2 0 1.324281426e-11
Gx4_re_a2 0 x4_re_a2 p2 0 3.147452127e-08
Fx4_re_a2 0 x4_re_a2 V2 1.573726063e-06
Rp4_re_re_a2 0 x4_re_a2 1
Gp4_re_im_a2 0 x4_re_a2 x4_im_a2 0 15.50680072
Cx4_im_a2 x4_im_a2 0 1.324281426e-11
Gp4_im_re_a2 0 x4_im_a2 x4_re_a2 0 -15.50680072
Rp4_im_im_a2 0 x4_im_a2 1
Cx5_re_a2 x5_re_a2 0 3.907772244e-11
Gx5_re_a2 0 x5_re_a2 p2 0 2.772449325e-08
Fx5_re_a2 0 x5_re_a2 V2 1.386224663e-06
Rp5_re_re_a2 0 x5_re_a2 1
Gp5_re_im_a2 0 x5_re_a2 x5_im_a2 0 36.18015431
Cx5_im_a2 x5_im_a2 0 3.907772244e-11
Gp5_im_re_a2 0 x5_im_a2 x5_re_a2 0 -36.18015431
Rp5_im_im_a2 0 x5_im_a2 1
Cx6_re_a2 x6_re_a2 0 2.768289015e-11
Gx6_re_a2 0 x6_re_a2 p2 0 4.048281243e-08
Fx6_re_a2 0 x6_re_a2 V2 2.024140621e-06
Rp6_re_re_a2 0 x6_re_a2 1
Gp6_re_im_a2 0 x6_re_a2 x6_im_a2 0 27.40708138
Cx6_im_a2 x6_im_a2 0 2.768289015e-11
Gp6_im_re_a2 0 x6_im_a2 x6_re_a2 0 -27.40708138
Rp6_im_im_a2 0 x6_im_a2 1
Cx7_re_a2 x7_re_a2 0 2.769933638e-11
Gx7_re_a2 0 x7_re_a2 p2 0 4.081766584e-08
Fx7_re_a2 0 x7_re_a2 V2 2.040883292e-06
Rp7_re_re_a2 0 x7_re_a2 1
Gp7_re_im_a2 0 x7_re_a2 x7_im_a2 0 29.60557976
Cx7_im_a2 x7_im_a2 0 2.769933638e-11
Gp7_im_re_a2 0 x7_im_a2 x7_re_a2 0 -29.60557976
Rp7_im_im_a2 0 x7_im_a2 1
.ENDS sparx_bpf_le
