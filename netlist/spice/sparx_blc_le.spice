* sparx_blc_le - lumped-element equivalent (Ngspice / SPICE3)
* generated by snp2le
* EQUIVALENT CIRCUIT FOR VECTOR FITTED S-MATRIX
* Created using scikit-rf vectorFitting.py
*
*
.SUBCKT sparx_blc_le p1 p2 p3 p4
V1 p1 s1 0
R1 s1 0 50 noisy=0
Gd1_1 0 s1 p1 0 -0.008233022819
Fd1_1 0 s1 V1 -0.411651141
Gr1_1_1 0 s1 x1_a1 0 -1.368097155
Gr2_1_1 0 s1 x2_a1 0 1.392217506
Gr3_re_1_1 0 s1 x3_re_a1 0 9263.05253
Gr3_im_1_1 0 s1 x3_im_a1 0 155476.8632
Gr4_re_1_1 0 s1 x4_re_a1 0 596902.8723
Gr4_im_1_1 0 s1 x4_im_a1 0 36186.50124
Gd1_2 0 s1 p2 0 0.007915670847
Fd1_2 0 s1 V2 0.3957835423
Gr1_1_2 0 s1 x1_a2 0 -3.223500662
Gr2_1_2 0 s1 x2_a2 0 3.090231479
Gr3_re_1_2 0 s1 x3_re_a2 0 637057.0772
Gr3_im_1_2 0 s1 x3_im_a2 0 60642.33186
Gr4_re_1_2 0 s1 x4_re_a2 0 177913.7535
Gr4_im_1_2 0 s1 x4_im_a2 0 -536797.2301
Gd1_3 0 s1 p3 0 -0.003955546335
Fd1_3 0 s1 V3 -0.1977773167
Gr1_1_3 0 s1 x1_a3 0 0.6162843468
Gr2_1_3 0 s1 x2_a3 0 -0.2461497764
Gr3_re_1_3 0 s1 x3_re_a3 0 -72101.94779
Gr3_im_1_3 0 s1 x3_im_a3 0 291310.1968
Gr4_re_1_3 0 s1 x4_re_a3 0 -495740.8679
Gr4_im_1_3 0 s1 x4_im_a3 0 72973.83289
Gd1_4 0 s1 p4 0 -0.002901725268
Fd1_4 0 s1 V4 -0.1450862634
Gr1_1_4 0 s1 x1_a4 0 0.4280981397
Gr2_1_4 0 s1 x2_a4 0 -0.2101139346
Gr3_re_1_4 0 s1 x3_re_a4 0 -352528.7394
Gr3_im_1_4 0 s1 x3_im_a4 0 -546859.2093
Gr4_re_1_4 0 s1 x4_re_a4 0 -237547.2079
Gr4_im_1_4 0 s1 x4_im_a4 0 419483.4831
Cx1_a1 x1_a1 0 7.197139996e-13
Gx1_a1 0 x1_a1 p1 0 0.06447001325
Fx1_a1 0 x1_a1 V1 3.223500662
Rp1_a1 0 x1_a1 1 noisy=0
Cx2_a1 x2_a1 0 9.088668115e-13
Gx2_a1 0 x2_a1 p1 0 0.06180462959
Fx2_a1 0 x2_a1 V1 3.090231479
Rp2_a1 0 x2_a1 1 noisy=0
Cx3_re_a1 x3_re_a1 0 1.675443512e-12
Gx3_re_a1 0 x3_re_a1 p1 0 6.02583377e-08
Fx3_re_a1 0 x3_re_a1 V1 3.012916885e-06
Rp3_re_re_a1 0 x3_re_a1 1 noisy=0
Gp3_re_im_a1 0 x3_re_a1 x3_im_a1 0 2.355967946
Cx3_im_a1 x3_im_a1 0 1.675443512e-12
Gp3_im_re_a1 0 x3_im_a1 x3_re_a1 0 -2.355967946
Rp3_im_im_a1 0 x3_im_a1 1 noisy=0
Cx4_re_a1 x4_re_a1 0 2.635686614e-12
Gx4_re_a1 0 x4_re_a1 p1 0 7.742161785e-08
Fx4_re_a1 0 x4_re_a1 V1 3.871080893e-06
Rp4_re_re_a1 0 x4_re_a1 1 noisy=0
Gp4_re_im_a1 0 x4_re_a1 x4_im_a1 0 2.720411743
Cx4_im_a1 x4_im_a1 0 2.635686614e-12
Gp4_im_re_a1 0 x4_im_a1 x4_re_a1 0 -2.720411743
Rp4_im_im_a1 0 x4_im_a1 1 noisy=0
V2 p2 s2 0
R2 s2 0 50 noisy=0
Gd2_1 0 s2 p1 0 0.007915670847
Fd2_1 0 s2 V1 0.3957835423
Gr1_2_1 0 s2 x1_a1 0 -3.223500662
Gr2_2_1 0 s2 x2_a1 0 3.090231479
Gr3_re_2_1 0 s2 x3_re_a1 0 640855.8283
Gr3_im_2_1 0 s2 x3_im_a1 0 61003.94016
Gr4_re_2_1 0 s2 x4_re_a1 0 177284.9283
Gr4_im_2_1 0 s2 x4_im_a1 0 -534899.9535
Gd2_2 0 s2 p2 0 3.636417935e-05
Fd2_2 0 s2 V2 0.001818208968
Gr1_2_2 0 s2 x1_a2 0 -1.69245914
Gr2_2_2 0 s2 x2_a2 0 1.555597899
Gr3_re_2_2 0 s2 x3_re_a2 0 -76604.60606
Gr3_im_2_2 0 s2 x3_im_a2 0 54332.36406
Gr4_re_2_2 0 s2 x4_re_a2 0 590596.0671
Gr4_im_2_2 0 s2 x4_im_a2 0 2693.919074
Gd2_3 0 s2 p3 0 -0.002075881252
Fd2_3 0 s2 V3 -0.1037940626
Gr1_2_3 0 s2 x1_a3 0 0.42360923
Gr2_2_3 0 s2 x2_a3 0 -0.1877681489
Gr3_re_2_3 0 s2 x3_re_a3 0 -488559.4183
Gr3_im_2_3 0 s2 x3_im_a3 0 -556700.3716
Gr4_re_2_3 0 s2 x4_re_a3 0 -178299.6104
Gr4_im_2_3 0 s2 x4_im_a3 0 472025.6427
Gd2_4 0 s2 p4 0 -0.003648445403
Fd2_4 0 s2 V4 -0.1824222702
Gr1_2_4 0 s2 x1_a4 0 0.230582956
Gr2_2_4 0 s2 x2_a4 0 0.1404271023
Gr3_re_2_4 0 s2 x3_re_a4 0 78237.81256
Gr3_im_2_4 0 s2 x3_im_a4 0 359561.8135
Gr4_re_2_4 0 s2 x4_re_a4 0 -481712.5494
Gr4_im_2_4 0 s2 x4_im_a4 0 40601.67372
Cx1_a2 x1_a2 0 7.197139996e-13
Gx1_a2 0 x1_a2 p2 0 0.06447001325
Fx1_a2 0 x1_a2 V2 3.223500662
Rp1_a2 0 x1_a2 1 noisy=0
Cx2_a2 x2_a2 0 9.088668115e-13
Gx2_a2 0 x2_a2 p2 0 0.06180462959
Fx2_a2 0 x2_a2 V2 3.090231479
Rp2_a2 0 x2_a2 1 noisy=0
Cx3_re_a2 x3_re_a2 0 1.675443512e-12
Gx3_re_a2 0 x3_re_a2 p2 0 6.061765626e-08
Fx3_re_a2 0 x3_re_a2 V2 3.030882813e-06
Rp3_re_re_a2 0 x3_re_a2 1 noisy=0
Gp3_re_im_a2 0 x3_re_a2 x3_im_a2 0 2.355967946
Cx3_im_a2 x3_im_a2 0 1.675443512e-12
Gp3_im_re_a2 0 x3_im_a2 x3_re_a2 0 -2.355967946
Rp3_im_im_a2 0 x3_im_a2 1 noisy=0
Cx4_re_a2 x4_re_a2 0 2.635686614e-12
Gx4_re_a2 0 x4_re_a2 p2 0 7.714797593e-08
Fx4_re_a2 0 x4_re_a2 V2 3.857398797e-06
Rp4_re_re_a2 0 x4_re_a2 1 noisy=0
Gp4_re_im_a2 0 x4_re_a2 x4_im_a2 0 2.720411743
Cx4_im_a2 x4_im_a2 0 2.635686614e-12
Gp4_im_re_a2 0 x4_im_a2 x4_re_a2 0 -2.720411743
Rp4_im_im_a2 0 x4_im_a2 1 noisy=0
V3 p3 s3 0
R3 s3 0 50 noisy=0
Gd3_1 0 s3 p1 0 -0.003955546335
Fd3_1 0 s3 V1 -0.1977773167
Gr1_3_1 0 s3 x1_a1 0 0.6560974966
Gr2_3_1 0 s3 x2_a1 0 -0.2608471515
Gr3_re_3_1 0 s3 x3_re_a1 0 -74297.90962
Gr3_im_3_1 0 s3 x3_im_a1 0 300182.4407
Gr4_re_3_1 0 s3 x4_re_a1 0 -518386.1198
Gr4_im_3_1 0 s3 x4_im_a1 0 76307.24947
Gd3_2 0 s3 p2 0 -0.002075881252
Fd3_2 0 s3 V2 -0.1037940626
Gr1_3_2 0 s3 x1_a2 0 0.450975198
Gr2_3_2 0 s3 x2_a2 0 -0.1989796111
Gr3_re_3_2 0 s3 x3_re_a2 0 -500454.9557
Gr3_im_3_2 0 s3 x3_im_a2 0 -570255.0179
Gr4_re_3_2 0 s3 x4_re_a2 0 -187105.581
Gr4_im_3_2 0 s3 x4_im_a2 0 495338.3349
Gd3_3 0 s3 p3 0 0.001554504052
Fd3_3 0 s3 V3 0.07772520258
Gr1_3_3 0 s3 x1_a3 0 -2.166017253
Gr2_3_3 0 s3 x2_a3 0 2.011069858
Gr3_re_3_3 0 s3 x3_re_a3 0 86029.96062
Gr3_im_3_3 0 s3 x3_im_a3 0 178763.7132
Gr4_re_3_3 0 s3 x4_re_a3 0 634888.5363
Gr4_im_3_3 0 s3 x4_im_a3 0 -131630.0878
Gd3_4 0 s3 p4 0 0.0101251198
Fd3_4 0 s3 V4 0.5062559898
Gr1_3_4 0 s3 x1_a4 0 -3.431744982
Gr2_3_4 0 s3 x2_a4 0 3.274746339
Gr3_re_3_4 0 s3 x3_re_a4 0 688815.8806
Gr3_im_3_4 0 s3 x3_im_a4 0 39525.87721
Gr4_re_3_4 0 s3 x4_re_a4 0 186408.02
Gr4_im_3_4 0 s3 x4_im_a4 0 -558165.792
Cx1_a3 x1_a3 0 7.197139996e-13
Gx1_a3 0 x1_a3 p3 0 0.06863489965
Fx1_a3 0 x1_a3 V3 3.431744982
Rp1_a3 0 x1_a3 1 noisy=0
Cx2_a3 x2_a3 0 9.088668115e-13
Gx2_a3 0 x2_a3 p3 0 0.06549492677
Fx2_a3 0 x2_a3 V3 3.274746339
Rp2_a3 0 x2_a3 1 noisy=0
Cx3_re_a3 x3_re_a3 0 1.675443512e-12
Gx3_re_a3 0 x3_re_a3 p3 0 6.209358645e-08
Fx3_re_a3 0 x3_re_a3 V3 3.104679322e-06
Rp3_re_re_a3 0 x3_re_a3 1 noisy=0
Gp3_re_im_a3 0 x3_re_a3 x3_im_a3 0 2.355967946
Cx3_im_a3 x3_im_a3 0 1.675443512e-12
Gp3_im_re_a3 0 x3_im_a3 x3_re_a3 0 -2.355967946
Rp3_im_im_a3 0 x3_im_a3 1 noisy=0
Cx4_re_a3 x4_re_a3 0 2.635686614e-12
Gx4_re_a3 0 x4_re_a3 p3 0 8.095820754e-08
Fx4_re_a3 0 x4_re_a3 V3 4.047910377e-06
Rp4_re_re_a3 0 x4_re_a3 1 noisy=0
Gp4_re_im_a3 0 x4_re_a3 x4_im_a3 0 2.720411743
Cx4_im_a3 x4_im_a3 0 2.635686614e-12
Gp4_im_re_a3 0 x4_im_a3 x4_re_a3 0 -2.720411743
Rp4_im_im_a3 0 x4_im_a3 1 noisy=0
V4 p4 s4 0
R4 s4 0 50 noisy=0
Gd4_1 0 s4 p1 0 -0.002901725268
Fd4_1 0 s4 V1 -0.1450862634
Gr1_4_1 0 s4 x1_a1 0 0.4557540999
Gr2_4_1 0 s4 x2_a1 0 -0.222659643
Gr3_re_4_1 0 s4 x3_re_a1 0 -361112.1761
Gr3_im_4_1 0 s4 x3_im_a1 0 -560174.2411
Gr4_re_4_1 0 s4 x4_re_a1 0 -244715.446
Gr4_im_4_1 0 s4 x4_im_a1 0 432141.8405
Gd4_2 0 s4 p2 0 -0.003648445403
Fd4_2 0 s4 V2 -0.1824222702
Gr1_4_2 0 s4 x1_a2 0 0.2454790568
Gr2_4_2 0 s4 x2_a2 0 0.1488118745
Gr3_re_4_2 0 s4 x3_re_a2 0 79667.70566
Gr3_im_4_2 0 s4 x3_im_a2 0 366133.2517
Gr4_re_4_2 0 s4 x4_re_a2 0 -498008.9164
Gr4_im_4_2 0 s4 x4_im_a2 0 41975.23099
Gd4_3 0 s4 p3 0 0.0101251198
Fd4_3 0 s4 V3 0.5062559898
Gr1_4_3 0 s4 x1_a3 0 -3.431744982
Gr2_4_3 0 s4 x2_a3 0 3.274746339
Gr3_re_4_3 0 s4 x3_re_a3 0 684732.8404
Gr3_im_4_3 0 s4 x3_im_a3 0 39291.58275
Gr4_re_4_3 0 s4 x4_re_a3 0 183644.279
Gr4_im_4_3 0 s4 x4_im_a3 0 -549890.2594
Gd4_4 0 s4 p4 0 0.0005503788413
Fd4_4 0 s4 V4 0.02751894207
Gr1_4_4 0 s4 x1_a4 0 -1.788501914
Gr2_4_4 0 s4 x2_a4 0 1.662751226
Gr3_re_4_4 0 s4 x3_re_a4 0 -29462.18238
Gr3_im_4_4 0 s4 x3_im_a4 0 116382.9898
Gr4_re_4_4 0 s4 x4_re_a4 0 607066.0084
Gr4_im_4_4 0 s4 x4_im_a4 0 -45337.40843
Cx1_a4 x1_a4 0 7.197139996e-13
Gx1_a4 0 x1_a4 p4 0 0.06863489965
Fx1_a4 0 x1_a4 V4 3.431744982
Rp1_a4 0 x1_a4 1 noisy=0
Cx2_a4 x2_a4 0 9.088668115e-13
Gx2_a4 0 x2_a4 p4 0 0.06549492677
Fx2_a4 0 x2_a4 V4 3.274746339
Rp2_a4 0 x2_a4 1 noisy=0
Cx3_re_a4 x3_re_a4 0 1.675443512e-12
Gx3_re_a4 0 x3_re_a4 p4 0 6.172551914e-08
Fx3_re_a4 0 x3_re_a4 V4 3.086275957e-06
Rp3_re_re_a4 0 x3_re_a4 1 noisy=0
Gp3_re_im_a4 0 x3_re_a4 x3_im_a4 0 2.355967946
Cx3_im_a4 x3_im_a4 0 1.675443512e-12
Gp3_im_re_a4 0 x3_im_a4 x3_re_a4 0 -2.355967946
Rp3_im_im_a4 0 x3_im_a4 1 noisy=0
Cx4_re_a4 x4_re_a4 0 2.635686614e-12
Gx4_re_a4 0 x4_re_a4 p4 0 7.9757897e-08
Fx4_re_a4 0 x4_re_a4 V4 3.98789485e-06
Rp4_re_re_a4 0 x4_re_a4 1 noisy=0
Gp4_re_im_a4 0 x4_re_a4 x4_im_a4 0 2.720411743
Cx4_im_a4 x4_im_a4 0 2.635686614e-12
Gp4_im_re_a4 0 x4_im_a4 x4_re_a4 0 -2.720411743
Rp4_im_im_a4 0 x4_im_a4 1 noisy=0
.ENDS sparx_blc_le
