* Extracted by KLayout with SG13G2 LVS runset on : 22/07/2026 11:32

.SUBCKT sparx_powdet_sbd rfin vdd vout vref vss
R$1 vdd \$I52 vss rhigh w=0.5u l=2u ps=0u b=0 m=1
C$2 vdd vss cap_cmim w=6.8u l=9u A=61.2p P=31.6u m=2
R$4 \$I52 \$I56 vss rsil w=0.5u l=2.5u ps=0u b=0 m=1
R$5 \$I52 \$I54 vss rsil w=0.5u l=2.5u ps=0u b=0 m=1
D$6 \$I56 \$I60 vss schottky_nbl1 m=1
D$7 \$I54 \$I39 vss schottky_nbl1 m=1
R$8 vout \$I39 vss rppd w=0.5u l=1.5u ps=0u b=0 m=1
R$9 \$I60 vref vss rppd w=0.5u l=1.5u ps=0u b=0 m=1
M$10 vdd vdd vdd vdd sg13_lv_pmos L=0.13u W=10u AS=2.65p AD=2.65p PS=16.06u
+ PD=16.06u rfmode=0
M$11 vdd \$I39 vout vdd sg13_lv_pmos L=0.13u W=100u AS=19p AD=19p PS=107.6u
+ PD=107.6u rfmode=0
M$21 vdd \$I60 vref vdd sg13_lv_pmos L=0.13u W=10u AS=1.9p AD=1.9p PS=10.76u
+ PD=10.76u rfmode=0
M$34 vss vss vss vss sg13_lv_nmos L=0.13u W=5u AS=1.325p AD=1.325p PS=8.56u
+ PD=8.56u rfmode=0
M$35 vss \$I39 vout vss sg13_lv_nmos L=0.13u W=50u AS=9.5p AD=9.5p PS=57.6u
+ PD=57.6u rfmode=0
M$45 vss \$I60 vref vss sg13_lv_nmos L=0.13u W=5u AS=0.95p AD=0.95p PS=5.76u
+ PD=5.76u rfmode=0
C$58 rfin \$I54 cap_cmim w=10u l=10u A=100p P=40u m=1
C$59 vdd vss cap_cmim w=10u l=10u A=100p P=40u m=28
C$87 \$I52 vss cap_cmim w=10u l=10u A=100p P=40u m=30
.ENDS sparx_powdet_sbd
