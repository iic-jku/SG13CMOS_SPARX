** sch_path: /foss/designs/SG13CMOS_SPARX/schematic/sparx_powdet_sbd.sch
.subckt sparx_powdet_sbd vout vref vdd rfin vss
*.PININFO rfin:I vout:O vss:B vdd:B vref:O
XR1 bias1 rfin_int vss rsil w=0.5e-6 l=2.5e-6 m=1 mm_ok=1
XD1 rfin_int bb_int vss schottky_nbl1 Nx=1 Ny=1
XC2 bias1 vss cap_cmim w=10e-6 l=10e-6 m=30 mm_ok=1
XM4 vout bb_int vdd vdd sg13_lv_pmos w=100u l=0.13u ng=20 m=1 mm_ok=1
XM3 vout bb_int vss vss sg13_lv_nmos w=50u l=0.13u ng=20 m=1 mm_ok=1
XR2 vout bb_int vss rppd w=0.5e-6 l=1.5e-6 m=1 b=0 mm_ok=1
XM2 vref bias2 vdd vdd sg13_lv_pmos w=10u l=0.13u ng=2 m=1 mm_ok=1
XM1 vref bias2 vss vss sg13_lv_nmos w=5u l=0.13u ng=2 m=1 mm_ok=1
XC3 vdd vss cap_cmim w=10e-6 l=10e-6 m=28 mm_ok=1
XD2 net1 bias2 vss schottky_nbl1 Nx=1 Ny=1
XR3 bias1 vdd vss rhigh w=0.5e-6 l=2e-6 m=1 b=0 mm_ok=1
XR4 vref bias2 vss rppd w=0.5e-6 l=1.5e-6 m=1 b=0 mm_ok=1
XR5 bias1 net1 vss rsil w=0.5e-6 l=2.5e-6 m=1 mm_ok=1
XMdummy1 vss vss vss vss sg13_lv_nmos w=5u l=0.13u ng=2 m=1 mm_ok=1
XMdummy2 vdd vdd vdd vdd sg13_lv_pmos w=10u l=0.13u ng=2 m=1 mm_ok=1
XC1 rfin rfin_int cap_cmim w=10e-6 l=10e-6 m=1 mm_ok=1
XC4 vdd vss cap_cmim w=6.8e-6 l=9e-6 m=2 mm_ok=1
.ends
