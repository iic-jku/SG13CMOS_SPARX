*********************************************************
*** NGSPICE file created by KLayout-PEX 0.9.0
*** -----------------------------------------------------
***     Extraction Engine: KPEX/2.5D
***     Technology: ihp_sg13g2
***     Date: 2026-11-13 09:04:31
*********************************************************

.SUBCKT sparx_powdet_sbd_pex vout vref vdd rfin vss
X$16 vdd.P0.GatPoly \$I52.P0.GatPoly vss rhigh w=5e-07 l=2e-06 ps=0 b=0 m=1
X$39 \$I52.P1.GatPoly \$I47 vss rsil w=5e-07 l=2.5e-06 m=1
X$40 \$I52.P2.GatPoly \$I44.P0.GatPoly vss rsil w=5e-07 l=2.5e-06 m=1
X$65 \$I47.P0.Metal1 \$I67 vss schottky_nbl1 m=1
X$66 \$I44 \$I66 vss schottky_nbl1 m=1
X$67 vout.P0.GatPoly \$I66.P0.GatPoly vss rppd w=5e-07 l=1.5e-06 ps=0 b=0 m=1
X$68 \$I67.P0.GatPoly vref.P0.GatPoly vss rppd w=5e-07 l=1.5e-06 ps=0 b=0 m=1
X$69 vdd.P1.pSD vdd.P1.GatPoly vdd.P0.pSD \$I78 sg13_lv_pmos w=5e-06 l=1.3e-07
+ as=1.7e-12 ad=9.5e-13 ps=1.068e-05 pd=5.38e-06
X$70 vout.P0.pSD \$I66.P1.GatPoly vdd.P1.pSD \$I78 sg13_lv_pmos w=5e-06
+ l=1.3e-07 as=9.5e-13 ad=9.5e-13 ps=5.38e-06 pd=5.38e-06
X$71 vdd.P3.pSD \$I66.P2.GatPoly vout.P0.pSD \$I78 sg13_lv_pmos w=5e-06
+ l=1.3e-07 as=9.5e-13 ad=9.5e-13 ps=5.38e-06 pd=5.38e-06
X$72 vout.P2.pSD \$I66.P3.GatPoly vdd.P3.pSD \$I78 sg13_lv_pmos w=5e-06
+ l=1.3e-07 as=9.5e-13 ad=9.5e-13 ps=5.38e-06 pd=5.38e-06
X$73 vdd.P5.pSD \$I66.P4.GatPoly vout.P2.pSD \$I78 sg13_lv_pmos w=5e-06
+ l=1.3e-07 as=9.5e-13 ad=9.5e-13 ps=5.38e-06 pd=5.38e-06
X$74 vout.P4.pSD \$I66.P5.GatPoly vdd.P5.pSD \$I78 sg13_lv_pmos w=5e-06
+ l=1.3e-07 as=9.5e-13 ad=9.5e-13 ps=5.38e-06 pd=5.38e-06
X$75 vdd.P7.pSD \$I66.P6.GatPoly vout.P4.pSD \$I78 sg13_lv_pmos w=5e-06
+ l=1.3e-07 as=9.5e-13 ad=9.5e-13 ps=5.38e-06 pd=5.38e-06
X$76 vout.P6.pSD \$I66.P7.GatPoly vdd.P7.pSD \$I78 sg13_lv_pmos w=5e-06
+ l=1.3e-07 as=9.5e-13 ad=9.5e-13 ps=5.38e-06 pd=5.38e-06
X$77 vdd.P10.pSD \$I66.P8.GatPoly vout.P6.pSD \$I78 sg13_lv_pmos w=5e-06
+ l=1.3e-07 as=9.5e-13 ad=9.5e-13 ps=5.38e-06 pd=5.38e-06
X$78 vout.P8.pSD \$I66.P9.GatPoly vdd.P10.pSD \$I78 sg13_lv_pmos w=5e-06
+ l=1.3e-07 as=9.5e-13 ad=9.5e-13 ps=5.38e-06 pd=5.38e-06
X$79 vdd.P11.pSD \$I66.P10.GatPoly vout.P8.pSD \$I78 sg13_lv_pmos w=5e-06
+ l=1.3e-07 as=9.5e-13 ad=9.5e-13 ps=5.38e-06 pd=5.38e-06
X$80 vref.P0.pSD \$I67.P1.GatPoly vdd.P11.pSD \$I78 sg13_lv_pmos w=5e-06
+ l=1.3e-07 as=9.5e-13 ad=9.5e-13 ps=5.38e-06 pd=5.38e-06
X$81 vdd.P13.pSD \$I67.P2.GatPoly vref.P0.pSD \$I78 sg13_lv_pmos w=5e-06
+ l=1.3e-07 as=9.5e-13 ad=9.5e-13 ps=5.38e-06 pd=5.38e-06
X$82 vout.P10.pSD \$I66.P11.GatPoly vdd.P13.pSD \$I78 sg13_lv_pmos w=5e-06
+ l=1.3e-07 as=9.5e-13 ad=9.5e-13 ps=5.38e-06 pd=5.38e-06
X$83 vdd.P15.pSD \$I66.P12.GatPoly vout.P10.pSD \$I78 sg13_lv_pmos w=5e-06
+ l=1.3e-07 as=9.5e-13 ad=9.5e-13 ps=5.38e-06 pd=5.38e-06
X$84 vout.P12.pSD \$I66.P13.GatPoly vdd.P15.pSD \$I78 sg13_lv_pmos w=5e-06
+ l=1.3e-07 as=9.5e-13 ad=9.5e-13 ps=5.38e-06 pd=5.38e-06
X$85 vdd.P17.pSD \$I66.P14.GatPoly vout.P12.pSD \$I78 sg13_lv_pmos w=5e-06
+ l=1.3e-07 as=9.5e-13 ad=9.5e-13 ps=5.38e-06 pd=5.38e-06
X$86 vout.P14.pSD \$I66.P15.GatPoly vdd.P17.pSD \$I78 sg13_lv_pmos w=5e-06
+ l=1.3e-07 as=9.5e-13 ad=9.5e-13 ps=5.38e-06 pd=5.38e-06
X$87 vdd.P19.pSD \$I66.P16.GatPoly vout.P14.pSD \$I78 sg13_lv_pmos w=5e-06
+ l=1.3e-07 as=9.5e-13 ad=9.5e-13 ps=5.38e-06 pd=5.38e-06
X$88 vout.P16.pSD \$I66.P17.GatPoly vdd.P19.pSD \$I78 sg13_lv_pmos w=5e-06
+ l=1.3e-07 as=9.5e-13 ad=9.5e-13 ps=5.38e-06 pd=5.38e-06
X$89 vdd.P21.pSD \$I66.P18.GatPoly vout.P16.pSD \$I78 sg13_lv_pmos w=5e-06
+ l=1.3e-07 as=9.5e-13 ad=9.5e-13 ps=5.38e-06 pd=5.38e-06
X$90 vout.P18.pSD \$I66.P19.GatPoly vdd.P21.pSD \$I78 sg13_lv_pmos w=5e-06
+ l=1.3e-07 as=9.5e-13 ad=9.5e-13 ps=5.38e-06 pd=5.38e-06
X$91 vdd.P23.pSD \$I66.P20.GatPoly vout.P18.pSD \$I78 sg13_lv_pmos w=5e-06
+ l=1.3e-07 as=9.5e-13 ad=9.5e-13 ps=5.38e-06 pd=5.38e-06
X$92 vdd.P25.pSD vdd.P2.GatPoly vdd.P23.pSD \$I78 sg13_lv_pmos w=5e-06
+ l=1.3e-07 as=9.5e-13 ad=1.7e-12 ps=5.38e-06 pd=1.068e-05
X$93 vdd.P0.nSD \$I78 ntap1
X$94 vss.P1.nSD vss.P0.GatPoly vss.P0.nSD vss sg13_lv_nmos w=2.5e-06 l=1.3e-07
+ as=8.5e-13 ad=4.75e-13 ps=5.68e-06 pd=2.88e-06
X$95 vout.P0.nSD \$I66.P21.GatPoly vss.P1.nSD vss sg13_lv_nmos w=2.5e-06
+ l=1.3e-07 as=4.75e-13 ad=4.75e-13 ps=2.88e-06 pd=2.88e-06
X$96 vss.P3.nSD \$I66.P22.GatPoly vout.P0.nSD vss sg13_lv_nmos w=2.5e-06
+ l=1.3e-07 as=4.75e-13 ad=4.75e-13 ps=2.88e-06 pd=2.88e-06
X$97 vout.P2.nSD \$I66.P23.GatPoly vss.P3.nSD vss sg13_lv_nmos w=2.5e-06
+ l=1.3e-07 as=4.75e-13 ad=4.75e-13 ps=2.88e-06 pd=2.88e-06
X$98 vss.P5.nSD \$I66.P24.GatPoly vout.P2.nSD vss sg13_lv_nmos w=2.5e-06
+ l=1.3e-07 as=4.75e-13 ad=4.75e-13 ps=2.88e-06 pd=2.88e-06
X$99 vout.P4.nSD \$I66.P25.GatPoly vss.P5.nSD vss sg13_lv_nmos w=2.5e-06
+ l=1.3e-07 as=4.75e-13 ad=4.75e-13 ps=2.88e-06 pd=2.88e-06
X$100 vss.P7.nSD \$I66.P26.GatPoly vout.P4.nSD vss sg13_lv_nmos w=2.5e-06
+ l=1.3e-07 as=4.75e-13 ad=4.75e-13 ps=2.88e-06 pd=2.88e-06
X$101 vout.P6.nSD \$I66.P27.GatPoly vss.P7.nSD vss sg13_lv_nmos w=2.5e-06
+ l=1.3e-07 as=4.75e-13 ad=4.75e-13 ps=2.88e-06 pd=2.88e-06
X$102 vss.P10.nSD \$I66.P28.GatPoly vout.P6.nSD vss sg13_lv_nmos w=2.5e-06
+ l=1.3e-07 as=4.75e-13 ad=4.75e-13 ps=2.88e-06 pd=2.88e-06
X$103 vout.P8.nSD \$I66.P29.GatPoly vss.P10.nSD vss sg13_lv_nmos w=2.5e-06
+ l=1.3e-07 as=4.75e-13 ad=4.75e-13 ps=2.88e-06 pd=2.88e-06
X$104 vss.P11.nSD \$I66.P30.GatPoly vout.P8.nSD vss sg13_lv_nmos w=2.5e-06
+ l=1.3e-07 as=4.75e-13 ad=4.75e-13 ps=2.88e-06 pd=2.88e-06
X$105 vref.P0.nSD \$I67.P3.GatPoly vss.P11.nSD vss sg13_lv_nmos w=2.5e-06
+ l=1.3e-07 as=4.75e-13 ad=4.75e-13 ps=2.88e-06 pd=2.88e-06
X$106 vss.P13.nSD \$I67.P4.GatPoly vref.P0.nSD vss sg13_lv_nmos w=2.5e-06
+ l=1.3e-07 as=4.75e-13 ad=4.75e-13 ps=2.88e-06 pd=2.88e-06
X$107 vout.P10.nSD \$I66.P31.GatPoly vss.P13.nSD vss sg13_lv_nmos w=2.5e-06
+ l=1.3e-07 as=4.75e-13 ad=4.75e-13 ps=2.88e-06 pd=2.88e-06
X$108 vss.P15.nSD \$I66.P32.GatPoly vout.P10.nSD vss sg13_lv_nmos w=2.5e-06
+ l=1.3e-07 as=4.75e-13 ad=4.75e-13 ps=2.88e-06 pd=2.88e-06
X$109 vout.P12.nSD \$I66.P33.GatPoly vss.P15.nSD vss sg13_lv_nmos w=2.5e-06
+ l=1.3e-07 as=4.75e-13 ad=4.75e-13 ps=2.88e-06 pd=2.88e-06
X$110 vss.P17.nSD \$I66.P34.GatPoly vout.P12.nSD vss sg13_lv_nmos w=2.5e-06
+ l=1.3e-07 as=4.75e-13 ad=4.75e-13 ps=2.88e-06 pd=2.88e-06
X$111 vout.P14.nSD \$I66.P35.GatPoly vss.P17.nSD vss sg13_lv_nmos w=2.5e-06
+ l=1.3e-07 as=4.75e-13 ad=4.75e-13 ps=2.88e-06 pd=2.88e-06
X$112 vss.P19.nSD \$I66.P36.GatPoly vout.P14.nSD vss sg13_lv_nmos w=2.5e-06
+ l=1.3e-07 as=4.75e-13 ad=4.75e-13 ps=2.88e-06 pd=2.88e-06
X$113 vout.P16.nSD \$I66.P37.GatPoly vss.P19.nSD vss sg13_lv_nmos w=2.5e-06
+ l=1.3e-07 as=4.75e-13 ad=4.75e-13 ps=2.88e-06 pd=2.88e-06
X$114 vss.P21.nSD \$I66.P38.GatPoly vout.P16.nSD vss sg13_lv_nmos w=2.5e-06
+ l=1.3e-07 as=4.75e-13 ad=4.75e-13 ps=2.88e-06 pd=2.88e-06
X$115 vout.P18.nSD \$I66.P39.GatPoly vss.P21.nSD vss sg13_lv_nmos w=2.5e-06
+ l=1.3e-07 as=4.75e-13 ad=4.75e-13 ps=2.88e-06 pd=2.88e-06
X$116 vss.P23.nSD \$I66.P40.GatPoly vout.P18.nSD vss sg13_lv_nmos w=2.5e-06
+ l=1.3e-07 as=4.75e-13 ad=4.75e-13 ps=2.88e-06 pd=2.88e-06
X$117 vss.P25.nSD vss.P1.GatPoly vss.P23.nSD vss sg13_lv_nmos w=2.5e-06
+ l=1.3e-07 as=4.75e-13 ad=8.5e-13 ps=2.88e-06 pd=5.68e-06
X$118 vss.P0.pSD vss ptap1
* netlist reduce (TICER tau=0.1ps max degree 5, floating max degree 64): 7205 R, 12352 C, 4416 nodes -> 2430 R, 10488 C, 686 nodes
Cred_1 \$I44 \$I44.P0.GatPoly 0.0111742f
Cred_2 \$I44 \$I47 0.0429629f
Cred_3 \$I44 \$I47.P0.Metal1 0.17236f
Cred_4 \$I44 \$I52.$2169.TopMetal1 0.0178026f
Cred_5 \$I44 \$I52.P0.GatPoly 0.00917162f
Cred_6 \$I44 \$I52.P1.GatPoly 0.0287957f
Cred_7 \$I44 \$I52.P2.GatPoly 0.0298247f
Cred_8 \$I44 \$I66 0.733776f
Cred_9 \$I44 \$I66.$692.Metal3 0.0218648f
Cred_10 \$I44 \$I66.$748.Metal3 0.0336675f
Cred_11 \$I44 \$I67 0.0860964f
Cred_12 \$I44 \$I67.$82.Metal2 0.00483324f
Cred_13 \$I44 rfin 152.681f
Cred_14 \$I44 vss 3.00359f
Cred_15 \$I44.P0.GatPoly \$I47 0.00209179f
Cred_16 \$I44.P0.GatPoly \$I47.P0.Metal1 0.00803964f
Cred_17 \$I44.P0.GatPoly \$I52.$2169.TopMetal1 0.000281505f
Cred_18 \$I44.P0.GatPoly \$I52.P0.GatPoly 0.000145027f
Cred_19 \$I44.P0.GatPoly \$I52.P1.GatPoly 0.000502921f
Cred_20 \$I44.P0.GatPoly \$I52.P2.GatPoly 0.00409973f
Cred_21 \$I44.P0.GatPoly \$I66 0.0764788f
Cred_22 \$I44.P0.GatPoly \$I66.$692.Metal3 0.000914633f
Cred_23 \$I44.P0.GatPoly \$I66.$748.Metal3 0.00140835f
Cred_24 \$I44.P0.GatPoly \$I67 1.20293e-05f
Cred_25 \$I44.P0.GatPoly \$I67.$82.Metal2 3.76559e-07f
Cred_26 \$I44.P0.GatPoly rfin 0.030263f
Cred_27 \$I44.P0.GatPoly vss 0.273357f
Cred_28 \$I47 \$I47.P0.Metal1 0.0036912f
Cred_29 \$I47 \$I52.$2169.TopMetal1 0.00181532f
Cred_30 \$I47 \$I52.P0.GatPoly 0.000935225f
Cred_31 \$I47 \$I52.P1.GatPoly 0.0055727f
Cred_32 \$I47 \$I52.P2.GatPoly 0.00278415f
Cred_33 \$I47 \$I66 0.000309811f
Cred_34 \$I47 \$I66.$692.Metal3 1.69648e-06f
Cred_35 \$I47 \$I66.$748.Metal3 2.61224e-06f
Cred_36 \$I47 \$I67 0.038927f
Cred_37 \$I47 \$I67.$82.Metal2 0.00115413f
Cred_38 \$I47 rfin 0.0160403f
Cred_39 \$I47 vss 0.264754f
Cred_40 \$I47.P0.Metal1 \$I52.$2169.TopMetal1 0.00495725f
Cred_41 \$I47.P0.Metal1 \$I52.P0.GatPoly 0.0025539f
Cred_42 \$I47.P0.Metal1 \$I52.P1.GatPoly 0.00886287f
Cred_43 \$I47.P0.Metal1 \$I52.P2.GatPoly 0.00760293f
Cred_44 \$I47.P0.Metal1 \$I66 0.0016017f
Cred_45 \$I47.P0.Metal1 \$I66.$692.Metal3 8.76669e-06f
Cred_46 \$I47.P0.Metal1 \$I66.$748.Metal3 1.3499e-05f
Cred_47 \$I47.P0.Metal1 \$I67 0.360621f
Cred_48 \$I47.P0.Metal1 \$I67.$82.Metal2 0.00636122f
Cred_49 \$I47.P0.Metal1 rfin 0.0751165f
Cred_50 \$I47.P0.Metal1 vss 0.666233f
Cred_51 \$I52.$2169.TopMetal1 \$I66 0.0212112f
Cred_52 \$I52.$2169.TopMetal1 \$I66.$689.Metal3 0.00431124f
Cred_53 \$I52.$2169.TopMetal1 \$I66.$692.Metal3 0.00569997f
Cred_54 \$I52.$2169.TopMetal1 \$I66.$748.Metal3 0.00877683f
Cred_55 \$I52.$2169.TopMetal1 \$I66.P21.GatPoly 3.26271e-06f
Cred_56 \$I52.$2169.TopMetal1 \$I66.P22.GatPoly 1.63105e-06f
Cred_57 \$I52.$2169.TopMetal1 \$I67 0.0506355f
Cred_58 \$I52.$2169.TopMetal1 \$I67.$82.Metal2 0.0222812f
Cred_59 \$I52.$2169.TopMetal1 \$I78 0.0806991f
Cred_60 \$I52.$2169.TopMetal1 rfin 0.0127796f
Cred_61 \$I52.$2169.TopMetal1 vss 11.7557f
Cred_62 \$I52.$2169.TopMetal1 vdd 3.56297f
Cred_63 \$I52.$2169.TopMetal1 vdd.$2365.Metal1 0.00215543f
Cred_64 \$I52.$2169.TopMetal1 vdd.$2370.Metal1 2.02039e-06f
Cred_65 \$I52.$2169.TopMetal1 vdd.$2375.Metal1 2.27242e-06f
Cred_66 \$I52.$2169.TopMetal1 vdd.$2389.Metal1 2.27242e-06f
Cred_67 \$I52.$2169.TopMetal1 vdd.$2394.Metal1 2.02039e-06f
Cred_68 \$I52.$2169.TopMetal1 vdd.$2399.Metal1 0.00215543f
Cred_69 \$I52.$2169.TopMetal1 vdd.$2747.Metal2 0.00164917f
Cred_70 \$I52.$2169.TopMetal1 vdd.$2749.Metal2 0.00134322f
Cred_71 \$I52.$2169.TopMetal1 vdd.$2751.Metal2 0.000734543f
Cred_72 \$I52.$2169.TopMetal1 vdd.$2755.Metal2 0.00160168f
Cred_73 \$I52.$2169.TopMetal1 vdd.$2759.Metal2 0.00125649f
Cred_74 \$I52.$2169.TopMetal1 vdd.$2761.Metal2 0.000712654f
Cred_75 \$I52.$2169.TopMetal1 vdd.$2765.Metal2 0.00157939f
Cred_76 \$I52.$2169.TopMetal1 vdd.$2769.Metal2 0.00129998f
Cred_77 \$I52.$2169.TopMetal1 vdd.$2771.Metal2 0.00047666f
Cred_78 \$I52.$2169.TopMetal1 vdd.$2773.Metal2 0.000275228f
Cred_79 \$I52.$2169.TopMetal1 vdd.$2775.Metal2 0.000853207f
Cred_80 \$I52.$2169.TopMetal1 vdd.$2779.Metal2 0.000853207f
Cred_81 \$I52.$2169.TopMetal1 vdd.$2781.Metal2 0.000275228f
Cred_82 \$I52.$2169.TopMetal1 vdd.$2783.Metal2 0.00047666f
Cred_83 \$I52.$2169.TopMetal1 vdd.$2785.Metal2 0.00129998f
Cred_84 \$I52.$2169.TopMetal1 vdd.$2789.Metal2 0.00157939f
Cred_85 \$I52.$2169.TopMetal1 vdd.$2793.Metal2 0.000712654f
Cred_86 \$I52.$2169.TopMetal1 vdd.$2795.Metal2 0.00125649f
Cred_87 \$I52.$2169.TopMetal1 vdd.$2799.Metal2 0.00160168f
Cred_88 \$I52.$2169.TopMetal1 vdd.$2803.Metal2 0.000734543f
Cred_89 \$I52.$2169.TopMetal1 vdd.$2805.Metal2 0.00134322f
Cred_90 \$I52.$2169.TopMetal1 vdd.$2807.Metal2 0.00164917f
Cred_91 \$I52.$2169.TopMetal1 vdd.$2987.Metal3 2.02039e-06f
Cred_92 \$I52.$2169.TopMetal1 vdd.$2997.Metal3 2.27242e-06f
Cred_93 \$I52.$2169.TopMetal1 vdd.$3025.Metal3 2.27242e-06f
Cred_94 \$I52.$2169.TopMetal1 vdd.$3035.Metal3 2.02039e-06f
Cred_95 \$I52.$2169.TopMetal1 vdd.$3213.Metal4 1.16861e-08f
Cred_96 \$I52.$2169.TopMetal1 vdd.$3215.Metal4 4.17696e-08f
Cred_97 \$I52.$2169.TopMetal1 vdd.$3223.Metal4 2.31561e-07f
Cred_98 \$I52.$2169.TopMetal1 vdd.$3267.Metal4 2.31561e-07f
Cred_99 \$I52.$2169.TopMetal1 vdd.$3275.Metal4 4.17696e-08f
Cred_100 \$I52.$2169.TopMetal1 vdd.$3277.Metal4 1.16861e-08f
Cred_101 \$I52.$2169.TopMetal1 vdd.$3448.Metal5 1.53757e-05f
Cred_102 \$I52.$2169.TopMetal1 vdd.$3450.Metal5 1.96391e-05f
Cred_103 \$I52.$2169.TopMetal1 vdd.$3452.Metal5 0.000142119f
Cred_104 \$I52.$2169.TopMetal1 vdd.$3455.Metal5 2.37501e-05f
Cred_105 \$I52.$2169.TopMetal1 vdd.$3456.Metal5 0.000138542f
Cred_106 \$I52.$2169.TopMetal1 vdd.$3462.Metal5 6.01688e-05f
Cred_107 \$I52.$2169.TopMetal1 vdd.$3468.Metal5 0.000138542f
Cred_108 \$I52.$2169.TopMetal1 vdd.$3469.Metal5 2.37501e-05f
Cred_109 \$I52.$2169.TopMetal1 vdd.$3472.Metal5 0.000142119f
Cred_110 \$I52.$2169.TopMetal1 vdd.$3474.Metal5 1.96391e-05f
Cred_111 \$I52.$2169.TopMetal1 vdd.$3476.Metal5 1.53757e-05f
Cred_112 \$I52.$2169.TopMetal1 vdd.$3480.Metal5 0.000443363f
Cred_113 \$I52.$2169.TopMetal1 vdd.$3496.Metal5 0.000443363f
Cred_114 \$I52.$2169.TopMetal1 vdd.$3615.TopMetal1 0.118115f
Cred_115 \$I52.$2169.TopMetal1 vdd.$3617.TopMetal1 0.15533f
Cred_116 \$I52.$2169.TopMetal1 vdd.$3619.TopMetal1 0.116576f
Cred_117 \$I52.$2169.TopMetal1 vdd.$3620.TopMetal1 0.0684716f
Cred_118 \$I52.$2169.TopMetal1 vdd.$3622.TopMetal1 0.0684716f
Cred_119 \$I52.$2169.TopMetal1 vdd.$3623.TopMetal1 0.116576f
Cred_120 \$I52.$2169.TopMetal1 vdd.$3625.TopMetal1 0.15533f
Cred_121 \$I52.$2169.TopMetal1 vdd.$3627.TopMetal1 0.118115f
Cred_122 \$I52.$2169.TopMetal1 vdd.$3700.TopMetal1 0.435145f
Cred_123 \$I52.$2169.TopMetal1 vdd.$3707.TopMetal1 0.435145f
Cred_124 \$I52.$2169.TopMetal1 vdd.$4071.TopMetal1 1.36717f
Cred_125 \$I52.$2169.TopMetal1 vdd.$4456.TopMetal1 7.33154e-05f
Cred_126 \$I52.$2169.TopMetal1 vdd.$4841.TopMetal1 3.9316e-09f
Cred_127 \$I52.$2169.TopMetal1 vdd.$5226.TopMetal1 2.10847e-13f
Cred_128 \$I52.$2169.TopMetal1 vdd.P0.GatPoly 0.0113365f
Cred_129 \$I52.$2169.TopMetal1 vdd.P0.nSD 0.00368838f
Cred_130 \$I52.$2169.TopMetal1 vdd.P0.pSD 0.000427585f
Cred_131 \$I52.$2169.TopMetal1 vdd.P1.GatPoly 1.93616e-06f
Cred_132 \$I52.$2169.TopMetal1 vdd.P1.pSD 0.000430736f
Cred_133 \$I52.$2169.TopMetal1 vdd.P10.pSD 0.000430308f
Cred_134 \$I52.$2169.TopMetal1 vdd.P11.pSD 0.000273112f
Cred_135 \$I52.$2169.TopMetal1 vdd.P13.pSD 0.000273112f
Cred_136 \$I52.$2169.TopMetal1 vdd.P15.pSD 0.000430308f
Cred_137 \$I52.$2169.TopMetal1 vdd.P17.pSD 0.000430284f
Cred_138 \$I52.$2169.TopMetal1 vdd.P19.pSD 0.000430535f
Cred_139 \$I52.$2169.TopMetal1 vdd.P2.GatPoly 1.93616e-06f
Cred_140 \$I52.$2169.TopMetal1 vdd.P21.pSD 0.000429876f
Cred_141 \$I52.$2169.TopMetal1 vdd.P23.pSD 0.000430736f
Cred_142 \$I52.$2169.TopMetal1 vdd.P25.pSD 0.000427585f
Cred_143 \$I52.$2169.TopMetal1 vdd.P3.pSD 0.000429876f
Cred_144 \$I52.$2169.TopMetal1 vdd.P5.pSD 0.000430535f
Cred_145 \$I52.$2169.TopMetal1 vdd.P7.pSD 0.000430284f
Cred_146 \$I52.$2169.TopMetal1 vout 0.0638753f
Cred_147 \$I52.$2169.TopMetal1 vout.$1238.Metal4 0.00879132f
Cred_148 \$I52.$2169.TopMetal1 vout.$1239.Metal4 0.00199983f
Cred_149 \$I52.$2169.TopMetal1 vout.$1299.Metal4 0.00205327f
Cred_150 \$I52.$2169.TopMetal1 vout.$1313.Metal4 1.07001e-06f
Cred_151 \$I52.$2169.TopMetal1 vout.$1372.Metal4 0.0407069f
Cred_152 \$I52.$2169.TopMetal1 vout.$1383.Metal4 0.00676401f
Cred_153 \$I52.$2169.TopMetal1 vout.P0.GatPoly 1.00199e-05f
Cred_154 \$I52.$2169.TopMetal1 vref 0.141547f
Cred_155 \$I52.$2169.TopMetal1 vref.P0.GatPoly 0.00402929f
Cred_156 \$I52.$2169.TopMetal1 vref.P0.nSD 0.0230319f
Cred_157 \$I52.$2169.TopMetal1 vref.P0.pSD 0.0421355f
Cred_158 \$I52.$2169.TopMetal1 vss 417.886f
Cred_159 \$I52.$2169.TopMetal1 vss.$1033.Metal4 0.00201301f
Cred_160 \$I52.$2169.TopMetal1 vss.$1037.Metal4 0.00201301f
Cred_161 \$I52.$2169.TopMetal1 vss.$1211.Metal5 937.001f
Cred_162 \$I52.$2169.TopMetal1 vss.$1229.Metal5 932.694f
Cred_163 \$I52.$2169.TopMetal1 vss.$1246.Metal5 13.2639f
Cred_164 \$I52.$2169.TopMetal1 vss.$1281.Metal5 1.14767p
Cred_165 \$I52.$2169.TopMetal1 vss.$1299.Metal5 1.14137p
Cred_166 \$I52.$2169.TopMetal1 vss.$825.Metal3 2.37351e-05f
Cred_167 \$I52.P0.GatPoly \$I66 1.18688e-05f
Cred_168 \$I52.P0.GatPoly \$I66.$689.Metal3 2.78728e-06f
Cred_169 \$I52.P0.GatPoly \$I66.$692.Metal3 3.56554e-06f
Cred_170 \$I52.P0.GatPoly \$I66.$748.Metal3 5.49023e-06f
Cred_171 \$I52.P0.GatPoly \$I66.P21.GatPoly 2.10939e-09f
Cred_172 \$I52.P0.GatPoly \$I66.P22.GatPoly 1.05449e-09f
Cred_173 \$I52.P0.GatPoly \$I67 0.00296416f
Cred_174 \$I52.P0.GatPoly \$I67.$82.Metal2 0.000291007f
Cred_175 \$I52.P0.GatPoly \$I78 6.00916e-05f
Cred_176 \$I52.P0.GatPoly rfin 0.00658384f
Cred_177 \$I52.P0.GatPoly vss 0.832949f
Cred_178 \$I52.P0.GatPoly vdd 0.00265312f
Cred_179 \$I52.P0.GatPoly vdd.$2365.Metal1 1.60501e-06f
Cred_180 \$I52.P0.GatPoly vdd.$2370.Metal1 1.50446e-09f
Cred_181 \$I52.P0.GatPoly vdd.$2375.Metal1 1.69213e-09f
Cred_182 \$I52.P0.GatPoly vdd.$2389.Metal1 1.69213e-09f
Cred_183 \$I52.P0.GatPoly vdd.$2394.Metal1 1.50446e-09f
Cred_184 \$I52.P0.GatPoly vdd.$2399.Metal1 1.60501e-06f
Cred_185 \$I52.P0.GatPoly vdd.$2747.Metal2 1.22803e-06f
Cred_186 \$I52.P0.GatPoly vdd.$2749.Metal2 1.00021e-06f
Cred_187 \$I52.P0.GatPoly vdd.$2751.Metal2 5.46968e-07f
Cred_188 \$I52.P0.GatPoly vdd.$2755.Metal2 1.19267e-06f
Cred_189 \$I52.P0.GatPoly vdd.$2759.Metal2 9.35629e-07f
Cred_190 \$I52.P0.GatPoly vdd.$2761.Metal2 5.30669e-07f
Cred_191 \$I52.P0.GatPoly vdd.$2765.Metal2 1.17608e-06f
Cred_192 \$I52.P0.GatPoly vdd.$2769.Metal2 9.68016e-07f
Cred_193 \$I52.P0.GatPoly vdd.$2771.Metal2 3.54939e-07f
Cred_194 \$I52.P0.GatPoly vdd.$2773.Metal2 2.04945e-07f
Cred_195 \$I52.P0.GatPoly vdd.$2775.Metal2 6.3533e-07f
Cred_196 \$I52.P0.GatPoly vdd.$2779.Metal2 6.3533e-07f
Cred_197 \$I52.P0.GatPoly vdd.$2781.Metal2 2.04945e-07f
Cred_198 \$I52.P0.GatPoly vdd.$2783.Metal2 3.54939e-07f
Cred_199 \$I52.P0.GatPoly vdd.$2785.Metal2 9.68016e-07f
Cred_200 \$I52.P0.GatPoly vdd.$2789.Metal2 1.17608e-06f
Cred_201 \$I52.P0.GatPoly vdd.$2793.Metal2 5.30669e-07f
Cred_202 \$I52.P0.GatPoly vdd.$2795.Metal2 9.35629e-07f
Cred_203 \$I52.P0.GatPoly vdd.$2799.Metal2 1.19267e-06f
Cred_204 \$I52.P0.GatPoly vdd.$2803.Metal2 5.46968e-07f
Cred_205 \$I52.P0.GatPoly vdd.$2805.Metal2 1.00021e-06f
Cred_206 \$I52.P0.GatPoly vdd.$2807.Metal2 1.22803e-06f
Cred_207 \$I52.P0.GatPoly vdd.$2987.Metal3 1.50446e-09f
Cred_208 \$I52.P0.GatPoly vdd.$2997.Metal3 1.69213e-09f
Cred_209 \$I52.P0.GatPoly vdd.$3025.Metal3 1.69213e-09f
Cred_210 \$I52.P0.GatPoly vdd.$3035.Metal3 1.50446e-09f
Cred_211 \$I52.P0.GatPoly vdd.$3213.Metal4 8.70192e-12f
Cred_212 \$I52.P0.GatPoly vdd.$3215.Metal4 3.11032e-11f
Cred_213 \$I52.P0.GatPoly vdd.$3223.Metal4 1.72429e-10f
Cred_214 \$I52.P0.GatPoly vdd.$3267.Metal4 1.72429e-10f
Cred_215 \$I52.P0.GatPoly vdd.$3275.Metal4 3.11032e-11f
Cred_216 \$I52.P0.GatPoly vdd.$3277.Metal4 8.70192e-12f
Cred_217 \$I52.P0.GatPoly vdd.$3448.Metal5 1.14494e-08f
Cred_218 \$I52.P0.GatPoly vdd.$3450.Metal5 1.4624e-08f
Cred_219 \$I52.P0.GatPoly vdd.$3452.Metal5 1.05827e-07f
Cred_220 \$I52.P0.GatPoly vdd.$3455.Metal5 1.76852e-08f
Cred_221 \$I52.P0.GatPoly vdd.$3456.Metal5 1.03164e-07f
Cred_222 \$I52.P0.GatPoly vdd.$3462.Metal5 4.4804e-08f
Cred_223 \$I52.P0.GatPoly vdd.$3468.Metal5 1.03164e-07f
Cred_224 \$I52.P0.GatPoly vdd.$3469.Metal5 1.76852e-08f
Cred_225 \$I52.P0.GatPoly vdd.$3472.Metal5 1.05827e-07f
Cred_226 \$I52.P0.GatPoly vdd.$3474.Metal5 1.4624e-08f
Cred_227 \$I52.P0.GatPoly vdd.$3476.Metal5 1.14494e-08f
Cred_228 \$I52.P0.GatPoly vdd.$3480.Metal5 3.30145e-07f
Cred_229 \$I52.P0.GatPoly vdd.$3496.Metal5 3.30145e-07f
Cred_230 \$I52.P0.GatPoly vdd.$3615.TopMetal1 8.79526e-05f
Cred_231 \$I52.P0.GatPoly vdd.$3617.TopMetal1 0.000115664f
Cred_232 \$I52.P0.GatPoly vdd.$3619.TopMetal1 8.68072e-05f
Cred_233 \$I52.P0.GatPoly vdd.$3620.TopMetal1 5.09865e-05f
Cred_234 \$I52.P0.GatPoly vdd.$3622.TopMetal1 5.09865e-05f
Cred_235 \$I52.P0.GatPoly vdd.$3623.TopMetal1 8.68072e-05f
Cred_236 \$I52.P0.GatPoly vdd.$3625.TopMetal1 0.000115664f
Cred_237 \$I52.P0.GatPoly vdd.$3627.TopMetal1 8.79526e-05f
Cred_238 \$I52.P0.GatPoly vdd.$3700.TopMetal1 0.000324025f
Cred_239 \$I52.P0.GatPoly vdd.$3707.TopMetal1 0.000324025f
Cred_240 \$I52.P0.GatPoly vdd.$4071.TopMetal1 0.0220684f
Cred_241 \$I52.P0.GatPoly vdd.$4456.TopMetal1 1.18344e-06f
Cred_242 \$I52.P0.GatPoly vdd.$4841.TopMetal1 6.34627e-11f
Cred_243 \$I52.P0.GatPoly vdd.$5226.TopMetal1 3.40343e-15f
Cred_244 \$I52.P0.GatPoly vdd.P0.GatPoly 0.00806023f
Cred_245 \$I52.P0.GatPoly vdd.P0.nSD 2.74651e-06f
Cred_246 \$I52.P0.GatPoly vdd.P0.pSD 3.18396e-07f
Cred_247 \$I52.P0.GatPoly vdd.P1.GatPoly 1.44174e-09f
Cred_248 \$I52.P0.GatPoly vdd.P1.pSD 3.20743e-07f
Cred_249 \$I52.P0.GatPoly vdd.P10.pSD 3.20424e-07f
Cred_250 \$I52.P0.GatPoly vdd.P11.pSD 2.0337e-07f
Cred_251 \$I52.P0.GatPoly vdd.P13.pSD 2.0337e-07f
Cred_252 \$I52.P0.GatPoly vdd.P15.pSD 3.20424e-07f
Cred_253 \$I52.P0.GatPoly vdd.P17.pSD 3.20405e-07f
Cred_254 \$I52.P0.GatPoly vdd.P19.pSD 3.20593e-07f
Cred_255 \$I52.P0.GatPoly vdd.P2.GatPoly 1.44174e-09f
Cred_256 \$I52.P0.GatPoly vdd.P21.pSD 3.20102e-07f
Cred_257 \$I52.P0.GatPoly vdd.P23.pSD 3.20743e-07f
Cred_258 \$I52.P0.GatPoly vdd.P25.pSD 3.18396e-07f
Cred_259 \$I52.P0.GatPoly vdd.P3.pSD 3.20102e-07f
Cred_260 \$I52.P0.GatPoly vdd.P5.pSD 3.20593e-07f
Cred_261 \$I52.P0.GatPoly vdd.P7.pSD 3.20405e-07f
Cred_262 \$I52.P0.GatPoly vout 4.16111e-05f
Cred_263 \$I52.P0.GatPoly vout.$1238.Metal4 4.60103e-06f
Cred_264 \$I52.P0.GatPoly vout.$1239.Metal4 1.04663e-06f
Cred_265 \$I52.P0.GatPoly vout.$1299.Metal4 1.33759e-06f
Cred_266 \$I52.P0.GatPoly vout.$1313.Metal4 6.97053e-10f
Cred_267 \$I52.P0.GatPoly vout.$1372.Metal4 3.03119e-05f
Cred_268 \$I52.P0.GatPoly vout.$1383.Metal4 5.03674e-06f
Cred_269 \$I52.P0.GatPoly vout.P0.GatPoly 6.52738e-09f
Cred_270 \$I52.P0.GatPoly vref 9.25225e-05f
Cred_271 \$I52.P0.GatPoly vref.P0.GatPoly 2.63763e-06f
Cred_272 \$I52.P0.GatPoly vref.P0.nSD 1.50351e-05f
Cred_273 \$I52.P0.GatPoly vref.P0.pSD 2.77867e-05f
Cred_274 \$I52.P0.GatPoly vss 0.218622f
Cred_275 \$I52.P0.GatPoly vss.$1033.Metal4 1.07215e-06f
Cred_276 \$I52.P0.GatPoly vss.$1037.Metal4 1.07215e-06f
Cred_277 \$I52.P0.GatPoly vss.$1211.Metal5 0.258568f
Cred_278 \$I52.P0.GatPoly vss.$1229.Metal5 0.256625f
Cred_279 \$I52.P0.GatPoly vss.$1246.Metal5 0.0065661f
Cred_280 \$I52.P0.GatPoly vss.$1281.Metal5 0.48888f
Cred_281 \$I52.P0.GatPoly vss.$1299.Metal5 0.485554f
Cred_282 \$I52.P0.GatPoly vss.$825.Metal3 1.26415e-08f
Cred_283 \$I52.P1.GatPoly \$I66 5.93367e-06f
Cred_284 \$I52.P1.GatPoly \$I66.$689.Metal3 1.39347e-06f
Cred_285 \$I52.P1.GatPoly \$I66.$692.Metal3 1.78255e-06f
Cred_286 \$I52.P1.GatPoly \$I66.$748.Metal3 2.74478e-06f
Cred_287 \$I52.P1.GatPoly \$I66.P21.GatPoly 1.05456e-09f
Cred_288 \$I52.P1.GatPoly \$I66.P22.GatPoly 5.27182e-10f
Cred_289 \$I52.P1.GatPoly \$I67 0.0014868f
Cred_290 \$I52.P1.GatPoly \$I67.$82.Metal2 0.000145948f
Cred_291 \$I52.P1.GatPoly \$I78 3.00421e-05f
Cred_292 \$I52.P1.GatPoly rfin 0.0197173f
Cred_293 \$I52.P1.GatPoly vss 0.93675f
Cred_294 \$I52.P1.GatPoly vdd 0.00132639f
Cred_295 \$I52.P1.GatPoly vdd.$2365.Metal1 8.02408e-07f
Cred_296 \$I52.P1.GatPoly vdd.$2370.Metal1 7.52139e-10f
Cred_297 \$I52.P1.GatPoly vdd.$2375.Metal1 8.45962e-10f
Cred_298 \$I52.P1.GatPoly vdd.$2389.Metal1 8.45962e-10f
Cred_299 \$I52.P1.GatPoly vdd.$2394.Metal1 7.52139e-10f
Cred_300 \$I52.P1.GatPoly vdd.$2399.Metal1 8.02408e-07f
Cred_301 \$I52.P1.GatPoly vdd.$2747.Metal2 6.13941e-07f
Cred_302 \$I52.P1.GatPoly vdd.$2749.Metal2 5.00045e-07f
Cred_303 \$I52.P1.GatPoly vdd.$2751.Metal2 2.7345e-07f
Cred_304 \$I52.P1.GatPoly vdd.$2755.Metal2 5.96263e-07f
Cred_305 \$I52.P1.GatPoly vdd.$2759.Metal2 4.67757e-07f
Cred_306 \$I52.P1.GatPoly vdd.$2761.Metal2 2.65302e-07f
Cred_307 \$I52.P1.GatPoly vdd.$2765.Metal2 5.87966e-07f
Cred_308 \$I52.P1.GatPoly vdd.$2769.Metal2 4.83948e-07f
Cred_309 \$I52.P1.GatPoly vdd.$2771.Metal2 1.77448e-07f
Cred_310 \$I52.P1.GatPoly vdd.$2773.Metal2 1.0246e-07f
Cred_311 \$I52.P1.GatPoly vdd.$2775.Metal2 3.17626e-07f
Cred_312 \$I52.P1.GatPoly vdd.$2779.Metal2 3.17626e-07f
Cred_313 \$I52.P1.GatPoly vdd.$2781.Metal2 1.0246e-07f
Cred_314 \$I52.P1.GatPoly vdd.$2783.Metal2 1.77448e-07f
Cred_315 \$I52.P1.GatPoly vdd.$2785.Metal2 4.83948e-07f
Cred_316 \$I52.P1.GatPoly vdd.$2789.Metal2 5.87966e-07f
Cred_317 \$I52.P1.GatPoly vdd.$2793.Metal2 2.65302e-07f
Cred_318 \$I52.P1.GatPoly vdd.$2795.Metal2 4.67757e-07f
Cred_319 \$I52.P1.GatPoly vdd.$2799.Metal2 5.96263e-07f
Cred_320 \$I52.P1.GatPoly vdd.$2803.Metal2 2.7345e-07f
Cred_321 \$I52.P1.GatPoly vdd.$2805.Metal2 5.00045e-07f
Cred_322 \$I52.P1.GatPoly vdd.$2807.Metal2 6.13941e-07f
Cred_323 \$I52.P1.GatPoly vdd.$2987.Metal3 7.52139e-10f
Cred_324 \$I52.P1.GatPoly vdd.$2997.Metal3 8.45962e-10f
Cred_325 \$I52.P1.GatPoly vdd.$3025.Metal3 8.45962e-10f
Cred_326 \$I52.P1.GatPoly vdd.$3035.Metal3 7.52139e-10f
Cred_327 \$I52.P1.GatPoly vdd.$3213.Metal4 4.35042e-12f
Cred_328 \$I52.P1.GatPoly vdd.$3215.Metal4 1.55497e-11f
Cred_329 \$I52.P1.GatPoly vdd.$3223.Metal4 8.62039e-11f
Cred_330 \$I52.P1.GatPoly vdd.$3267.Metal4 8.62039e-11f
Cred_331 \$I52.P1.GatPoly vdd.$3275.Metal4 1.55497e-11f
Cred_332 \$I52.P1.GatPoly vdd.$3277.Metal4 4.35042e-12f
Cred_333 \$I52.P1.GatPoly vdd.$3448.Metal5 5.72397e-09f
Cred_334 \$I52.P1.GatPoly vdd.$3450.Metal5 7.31109e-09f
Cred_335 \$I52.P1.GatPoly vdd.$3452.Metal5 5.29071e-08f
Cred_336 \$I52.P1.GatPoly vdd.$3455.Metal5 8.84153e-09f
Cred_337 \$I52.P1.GatPoly vdd.$3456.Metal5 5.15756e-08f
Cred_338 \$I52.P1.GatPoly vdd.$3462.Metal5 2.23993e-08f
Cred_339 \$I52.P1.GatPoly vdd.$3468.Metal5 5.15756e-08f
Cred_340 \$I52.P1.GatPoly vdd.$3469.Metal5 8.84153e-09f
Cred_341 \$I52.P1.GatPoly vdd.$3472.Metal5 5.29071e-08f
Cred_342 \$I52.P1.GatPoly vdd.$3474.Metal5 7.31109e-09f
Cred_343 \$I52.P1.GatPoly vdd.$3476.Metal5 5.72397e-09f
Cred_344 \$I52.P1.GatPoly vdd.$3480.Metal5 1.65052e-07f
Cred_345 \$I52.P1.GatPoly vdd.$3496.Metal5 1.65052e-07f
Cred_346 \$I52.P1.GatPoly vdd.$3615.TopMetal1 4.39709e-05f
Cred_347 \$I52.P1.GatPoly vdd.$3617.TopMetal1 5.7825e-05f
Cred_348 \$I52.P1.GatPoly vdd.$3619.TopMetal1 4.33983e-05f
Cred_349 \$I52.P1.GatPoly vdd.$3620.TopMetal1 2.54901e-05f
Cred_350 \$I52.P1.GatPoly vdd.$3622.TopMetal1 2.54901e-05f
Cred_351 \$I52.P1.GatPoly vdd.$3623.TopMetal1 4.33983e-05f
Cred_352 \$I52.P1.GatPoly vdd.$3625.TopMetal1 5.7825e-05f
Cred_353 \$I52.P1.GatPoly vdd.$3627.TopMetal1 4.39709e-05f
Cred_354 \$I52.P1.GatPoly vdd.$3700.TopMetal1 0.000161992f
Cred_355 \$I52.P1.GatPoly vdd.$3707.TopMetal1 0.000161992f
Cred_356 \$I52.P1.GatPoly vdd.$4071.TopMetal1 0.0068563f
Cred_357 \$I52.P1.GatPoly vdd.$4456.TopMetal1 3.67675e-07f
Cred_358 \$I52.P1.GatPoly vdd.$4841.TopMetal1 1.97169e-11f
Cred_359 \$I52.P1.GatPoly vdd.$5226.TopMetal1 1.05739e-15f
Cred_360 \$I52.P1.GatPoly vdd.P0.GatPoly 0.00152302f
Cred_361 \$I52.P1.GatPoly vdd.P0.nSD 1.37308e-06f
Cred_362 \$I52.P1.GatPoly vdd.P0.pSD 1.59178e-07f
Cred_363 \$I52.P1.GatPoly vdd.P1.GatPoly 7.20781e-10f
Cred_364 \$I52.P1.GatPoly vdd.P1.pSD 1.60352e-07f
Cred_365 \$I52.P1.GatPoly vdd.P10.pSD 1.60192e-07f
Cred_366 \$I52.P1.GatPoly vdd.P11.pSD 1.01672e-07f
Cred_367 \$I52.P1.GatPoly vdd.P13.pSD 1.01672e-07f
Cred_368 \$I52.P1.GatPoly vdd.P15.pSD 1.60192e-07f
Cred_369 \$I52.P1.GatPoly vdd.P17.pSD 1.60183e-07f
Cred_370 \$I52.P1.GatPoly vdd.P19.pSD 1.60277e-07f
Cred_371 \$I52.P1.GatPoly vdd.P2.GatPoly 7.20781e-10f
Cred_372 \$I52.P1.GatPoly vdd.P21.pSD 1.60031e-07f
Cred_373 \$I52.P1.GatPoly vdd.P23.pSD 1.60352e-07f
Cred_374 \$I52.P1.GatPoly vdd.P25.pSD 1.59178e-07f
Cred_375 \$I52.P1.GatPoly vdd.P3.pSD 1.60031e-07f
Cred_376 \$I52.P1.GatPoly vdd.P5.pSD 1.60277e-07f
Cred_377 \$I52.P1.GatPoly vdd.P7.pSD 1.60183e-07f
Cred_378 \$I52.P1.GatPoly vout 2.0803e-05f
Cred_379 \$I52.P1.GatPoly vout.$1238.Metal4 2.30023e-06f
Cred_380 \$I52.P1.GatPoly vout.$1239.Metal4 5.23252e-07f
Cred_381 \$I52.P1.GatPoly vout.$1299.Metal4 6.68711e-07f
Cred_382 \$I52.P1.GatPoly vout.$1313.Metal4 3.48484e-10f
Cred_383 \$I52.P1.GatPoly vout.$1372.Metal4 1.51541e-05f
Cred_384 \$I52.P1.GatPoly vout.$1383.Metal4 2.51806e-06f
Cred_385 \$I52.P1.GatPoly vout.P0.GatPoly 3.26329e-09f
Cred_386 \$I52.P1.GatPoly vref 4.62556e-05f
Cred_387 \$I52.P1.GatPoly vref.P0.GatPoly 1.31865e-06f
Cred_388 \$I52.P1.GatPoly vref.P0.nSD 7.51664e-06f
Cred_389 \$I52.P1.GatPoly vref.P0.pSD 1.38917e-05f
Cred_390 \$I52.P1.GatPoly vss 0.109133f
Cred_391 \$I52.P1.GatPoly vss.$1033.Metal4 5.36007e-07f
Cred_392 \$I52.P1.GatPoly vss.$1037.Metal4 5.36007e-07f
Cred_393 \$I52.P1.GatPoly vss.$1211.Metal5 0.129219f
Cred_394 \$I52.P1.GatPoly vss.$1229.Metal5 0.128247f
Cred_395 \$I52.P1.GatPoly vss.$1246.Metal5 0.00328265f
Cred_396 \$I52.P1.GatPoly vss.$1281.Metal5 0.24422f
Cred_397 \$I52.P1.GatPoly vss.$1299.Metal5 0.242557f
Cred_398 \$I52.P1.GatPoly vss.$825.Metal3 6.31997e-09f
Cred_399 \$I52.P2.GatPoly \$I66 5.09015e-06f
Cred_400 \$I52.P2.GatPoly \$I66.$689.Metal3 1.19537e-06f
Cred_401 \$I52.P2.GatPoly \$I66.$692.Metal3 1.52915e-06f
Cred_402 \$I52.P2.GatPoly \$I66.$748.Metal3 2.35458e-06f
Cred_403 \$I52.P2.GatPoly \$I66.P21.GatPoly 9.04648e-10f
Cred_404 \$I52.P2.GatPoly \$I66.P22.GatPoly 4.52238e-10f
Cred_405 \$I52.P2.GatPoly \$I67 0.00127544f
Cred_406 \$I52.P2.GatPoly \$I67.$82.Metal2 0.0001252f
Cred_407 \$I52.P2.GatPoly \$I78 2.57713e-05f
Cred_408 \$I52.P2.GatPoly rfin 0.0206129f
Cred_409 \$I52.P2.GatPoly vss 0.851131f
Cred_410 \$I52.P2.GatPoly vdd 0.00113784f
Cred_411 \$I52.P2.GatPoly vdd.$2365.Metal1 6.88338e-07f
Cred_412 \$I52.P2.GatPoly vdd.$2370.Metal1 6.45215e-10f
Cred_413 \$I52.P2.GatPoly vdd.$2375.Metal1 7.257e-10f
Cred_414 \$I52.P2.GatPoly vdd.$2389.Metal1 7.257e-10f
Cred_415 \$I52.P2.GatPoly vdd.$2394.Metal1 6.45215e-10f
Cred_416 \$I52.P2.GatPoly vdd.$2399.Metal1 6.88338e-07f
Cred_417 \$I52.P2.GatPoly vdd.$2747.Metal2 5.26664e-07f
Cred_418 \$I52.P2.GatPoly vdd.$2749.Metal2 4.28959e-07f
Cred_419 \$I52.P2.GatPoly vdd.$2751.Metal2 2.34577e-07f
Cred_420 \$I52.P2.GatPoly vdd.$2755.Metal2 5.11499e-07f
Cred_421 \$I52.P2.GatPoly vdd.$2759.Metal2 4.01261e-07f
Cred_422 \$I52.P2.GatPoly vdd.$2761.Metal2 2.27587e-07f
Cred_423 \$I52.P2.GatPoly vdd.$2765.Metal2 5.04381e-07f
Cred_424 \$I52.P2.GatPoly vdd.$2769.Metal2 4.15151e-07f
Cred_425 \$I52.P2.GatPoly vdd.$2771.Metal2 1.52222e-07f
Cred_426 \$I52.P2.GatPoly vdd.$2773.Metal2 8.78944e-08f
Cred_427 \$I52.P2.GatPoly vdd.$2775.Metal2 2.72473e-07f
Cred_428 \$I52.P2.GatPoly vdd.$2779.Metal2 2.72473e-07f
Cred_429 \$I52.P2.GatPoly vdd.$2781.Metal2 8.78944e-08f
Cred_430 \$I52.P2.GatPoly vdd.$2783.Metal2 1.52222e-07f
Cred_431 \$I52.P2.GatPoly vdd.$2785.Metal2 4.15151e-07f
Cred_432 \$I52.P2.GatPoly vdd.$2789.Metal2 5.04381e-07f
Cred_433 \$I52.P2.GatPoly vdd.$2793.Metal2 2.27587e-07f
Cred_434 \$I52.P2.GatPoly vdd.$2795.Metal2 4.01261e-07f
Cred_435 \$I52.P2.GatPoly vdd.$2799.Metal2 5.11499e-07f
Cred_436 \$I52.P2.GatPoly vdd.$2803.Metal2 2.34577e-07f
Cred_437 \$I52.P2.GatPoly vdd.$2805.Metal2 4.28959e-07f
Cred_438 \$I52.P2.GatPoly vdd.$2807.Metal2 5.26664e-07f
Cred_439 \$I52.P2.GatPoly vdd.$2987.Metal3 6.45215e-10f
Cred_440 \$I52.P2.GatPoly vdd.$2997.Metal3 7.257e-10f
Cred_441 \$I52.P2.GatPoly vdd.$3025.Metal3 7.257e-10f
Cred_442 \$I52.P2.GatPoly vdd.$3035.Metal3 6.45215e-10f
Cred_443 \$I52.P2.GatPoly vdd.$3213.Metal4 3.73197e-12f
Cred_444 \$I52.P2.GatPoly vdd.$3215.Metal4 1.33392e-11f
Cred_445 \$I52.P2.GatPoly vdd.$3223.Metal4 7.39493e-11f
Cred_446 \$I52.P2.GatPoly vdd.$3267.Metal4 7.39493e-11f
Cred_447 \$I52.P2.GatPoly vdd.$3275.Metal4 1.33392e-11f
Cred_448 \$I52.P2.GatPoly vdd.$3277.Metal4 3.73197e-12f
Cred_449 \$I52.P2.GatPoly vdd.$3448.Metal5 4.91026e-09f
Cred_450 \$I52.P2.GatPoly vdd.$3450.Metal5 6.27175e-09f
Cred_451 \$I52.P2.GatPoly vdd.$3452.Metal5 4.53858e-08f
Cred_452 \$I52.P2.GatPoly vdd.$3455.Metal5 7.58463e-09f
Cred_453 \$I52.P2.GatPoly vdd.$3456.Metal5 4.42436e-08f
Cred_454 \$I52.P2.GatPoly vdd.$3462.Metal5 1.9215e-08f
Cred_455 \$I52.P2.GatPoly vdd.$3468.Metal5 4.42436e-08f
Cred_456 \$I52.P2.GatPoly vdd.$3469.Metal5 7.58463e-09f
Cred_457 \$I52.P2.GatPoly vdd.$3472.Metal5 4.53858e-08f
Cred_458 \$I52.P2.GatPoly vdd.$3474.Metal5 6.27175e-09f
Cred_459 \$I52.P2.GatPoly vdd.$3476.Metal5 4.91026e-09f
Cred_460 \$I52.P2.GatPoly vdd.$3480.Metal5 1.41588e-07f
Cred_461 \$I52.P2.GatPoly vdd.$3496.Metal5 1.41588e-07f
Cred_462 \$I52.P2.GatPoly vdd.$3615.TopMetal1 3.772e-05f
Cred_463 \$I52.P2.GatPoly vdd.$3617.TopMetal1 4.96047e-05f
Cred_464 \$I52.P2.GatPoly vdd.$3619.TopMetal1 3.72288e-05f
Cred_465 \$I52.P2.GatPoly vdd.$3620.TopMetal1 2.18665e-05f
Cred_466 \$I52.P2.GatPoly vdd.$3622.TopMetal1 2.18665e-05f
Cred_467 \$I52.P2.GatPoly vdd.$3623.TopMetal1 3.72288e-05f
Cred_468 \$I52.P2.GatPoly vdd.$3625.TopMetal1 4.96047e-05f
Cred_469 \$I52.P2.GatPoly vdd.$3627.TopMetal1 3.772e-05f
Cred_470 \$I52.P2.GatPoly vdd.$3700.TopMetal1 0.000138964f
Cred_471 \$I52.P2.GatPoly vdd.$3707.TopMetal1 0.000138964f
Cred_472 \$I52.P2.GatPoly vdd.$4071.TopMetal1 0.00588161f
Cred_473 \$I52.P2.GatPoly vdd.$4456.TopMetal1 3.15406e-07f
Cred_474 \$I52.P2.GatPoly vdd.$4841.TopMetal1 1.69139e-11f
Cred_475 \$I52.P2.GatPoly vdd.$5226.TopMetal1 9.07072e-16f
Cred_476 \$I52.P2.GatPoly vdd.P0.GatPoly 0.00130651f
Cred_477 \$I52.P2.GatPoly vdd.P0.nSD 1.17789e-06f
Cred_478 \$I52.P2.GatPoly vdd.P0.pSD 1.3655e-07f
Cred_479 \$I52.P2.GatPoly vdd.P1.GatPoly 6.18316e-10f
Cred_480 \$I52.P2.GatPoly vdd.P1.pSD 1.37556e-07f
Cred_481 \$I52.P2.GatPoly vdd.P10.pSD 1.37419e-07f
Cred_482 \$I52.P2.GatPoly vdd.P11.pSD 8.72186e-08f
Cred_483 \$I52.P2.GatPoly vdd.P13.pSD 8.72186e-08f
Cred_484 \$I52.P2.GatPoly vdd.P15.pSD 1.37419e-07f
Cred_485 \$I52.P2.GatPoly vdd.P17.pSD 1.37412e-07f
Cred_486 \$I52.P2.GatPoly vdd.P19.pSD 1.37492e-07f
Cred_487 \$I52.P2.GatPoly vdd.P2.GatPoly 6.18316e-10f
Cred_488 \$I52.P2.GatPoly vdd.P21.pSD 1.37281e-07f
Cred_489 \$I52.P2.GatPoly vdd.P23.pSD 1.37556e-07f
Cred_490 \$I52.P2.GatPoly vdd.P25.pSD 1.3655e-07f
Cred_491 \$I52.P2.GatPoly vdd.P3.pSD 1.37281e-07f
Cred_492 \$I52.P2.GatPoly vdd.P5.pSD 1.37492e-07f
Cred_493 \$I52.P2.GatPoly vdd.P7.pSD 1.37412e-07f
Cred_494 \$I52.P2.GatPoly vout 1.78457e-05f
Cred_495 \$I52.P2.GatPoly vout.$1238.Metal4 1.97323e-06f
Cred_496 \$I52.P2.GatPoly vout.$1239.Metal4 4.48867e-07f
Cred_497 \$I52.P2.GatPoly vout.$1299.Metal4 5.73648e-07f
Cred_498 \$I52.P2.GatPoly vout.$1313.Metal4 2.98943e-10f
Cred_499 \$I52.P2.GatPoly vout.$1372.Metal4 1.29998e-05f
Cred_500 \$I52.P2.GatPoly vout.$1383.Metal4 2.16009e-06f
Cred_501 \$I52.P2.GatPoly vout.P0.GatPoly 2.79938e-09f
Cred_502 \$I52.P2.GatPoly vref 3.96799e-05f
Cred_503 \$I52.P2.GatPoly vref.P0.GatPoly 1.1312e-06f
Cred_504 \$I52.P2.GatPoly vref.P0.nSD 6.44808e-06f
Cred_505 \$I52.P2.GatPoly vref.P0.pSD 1.19168e-05f
Cred_506 \$I52.P2.GatPoly vss 0.0936186f
Cred_507 \$I52.P2.GatPoly vss.$1033.Metal4 4.59808e-07f
Cred_508 \$I52.P2.GatPoly vss.$1037.Metal4 4.59808e-07f
Cred_509 \$I52.P2.GatPoly vss.$1211.Metal5 0.110849f
Cred_510 \$I52.P2.GatPoly vss.$1229.Metal5 0.110015f
Cred_511 \$I52.P2.GatPoly vss.$1246.Metal5 0.00281599f
Cred_512 \$I52.P2.GatPoly vss.$1281.Metal5 0.209502f
Cred_513 \$I52.P2.GatPoly vss.$1299.Metal5 0.208075f
Cred_514 \$I52.P2.GatPoly vss.$825.Metal3 5.42153e-09f
Cred_515 \$I66 \$I66.$692.Metal3 0.000994642f
Cred_516 \$I66 \$I66.$748.Metal3 0.00153155f
Cred_517 \$I66 \$I67 0.0169179f
Cred_518 \$I66 \$I67.$82.Metal2 0.00739643f
Cred_519 \$I66 \$I67.P0.GatPoly 4.81964e-05f
Cred_520 \$I66 \$I67.P3.GatPoly 4.38908e-06f
Cred_521 \$I66 \$I67.P4.GatPoly 4.38908e-06f
Cred_522 \$I66 \$I78 0.000284921f
Cred_523 \$I66 rfin 0.0328272f
Cred_524 \$I66 vss 1.92452f
Cred_525 \$I66 vdd.$2365.Metal1 7.0241e-06f
Cred_526 \$I66 vdd.$2399.Metal1 5.64731e-08f
Cred_527 \$I66 vdd.P0.nSD 7.04811e-05f
Cred_528 \$I66 vdd.P1.GatPoly 1.67545e-06f
Cred_529 \$I66 vdd.P2.GatPoly 2.51184e-09f
Cred_530 \$I66 vout 3.72724e-05f
Cred_531 \$I66 vout.$121.Metal1 2.05926e-08f
Cred_532 \$I66 vout.$122.Metal1 2.87819e-08f
Cred_533 \$I66 vout.$123.Metal1 1.67398e-08f
Cred_534 \$I66 vout.$1235.Metal4 2.67528e-06f
Cred_535 \$I66 vout.$1236.Metal4 0.000304428f
Cred_536 \$I66 vout.$1264.Metal4 1.43927e-06f
Cred_537 \$I66 vout.$1299.Metal4 1.19812e-06f
Cred_538 \$I66 vout.$1313.Metal4 6.24373e-10f
Cred_539 \$I66 vout.$498.Metal2 4.77148e-07f
Cred_540 \$I66 vout.$500.Metal2 3.71193e-07f
Cred_541 \$I66 vout.$516.Metal2 1.56335e-06f
Cred_542 \$I66 vout.$518.Metal2 2.41912e-06f
Cred_543 \$I66 vout.$520.Metal2 1.52513e-06f
Cred_544 \$I66 vout.$886.Metal3 2.38045e-05f
Cred_545 \$I66 vout.$888.Metal3 1.85185e-05f
Cred_546 \$I66 vout.$904.Metal3 2.63816e-05f
Cred_547 \$I66 vout.P0.GatPoly 5.84679e-09f
Cred_548 \$I66 vref 0.00105243f
Cred_549 \$I66 vref.P0.GatPoly 0.000126257f
Cred_550 \$I66 vref.P0.nSD 6.191e-05f
Cred_551 \$I66 vref.P0.pSD 0.00010803f
Cred_552 \$I66 vss 0.0196294f
Cred_553 \$I66 vss.$1211.Metal5 0.020625f
Cred_554 \$I66 vss.$1229.Metal5 0.020625f
Cred_555 \$I66 vss.$127.Metal1 1.48672e-05f
Cred_556 \$I66 vss.$1281.Metal5 0.0746411f
Cred_557 \$I66 vss.$1299.Metal5 0.0746411f
Cred_558 \$I66 vss.$406.Metal1 1.17621e-05f
Cred_559 \$I66 vss.$457.Metal2 2.17134e-07f
Cred_560 \$I66 vss.P0.GatPoly 1.69852e-06f
Cred_561 \$I66 vss.P0.pSD 0.000222236f
Cred_562 \$I66.$689.Metal3 \$I67.$82.Metal2 0.103013f
Cred_563 \$I66.$689.Metal3 \$I78 0.0121868f
Cred_564 \$I66.$689.Metal3 vss 1.63546f
Cred_565 \$I66.$689.Metal3 vdd.$2365.Metal1 0.000452822f
Cred_566 \$I66.$689.Metal3 vdd.$2399.Metal1 3.64064e-06f
Cred_567 \$I66.$689.Metal3 vdd.P0.nSD 0.0045437f
Cred_568 \$I66.$689.Metal3 vdd.P1.GatPoly 0.000102223f
Cred_569 \$I66.$689.Metal3 vdd.P2.GatPoly 1.6193e-07f
Cred_570 \$I66.$689.Metal3 vout.$11.Metal1 6.15744e-08f
Cred_571 \$I66.$689.Metal3 vout.$121.Metal1 0.010927f
Cred_572 \$I66.$689.Metal3 vout.$122.Metal1 0.00934767f
Cred_573 \$I66.$689.Metal3 vout.$123.Metal1 0.00169771f
Cred_574 \$I66.$689.Metal3 vout.$1235.Metal4 0.0229409f
Cred_575 \$I66.$689.Metal3 vout.$1236.Metal4 0.00359117f
Cred_576 \$I66.$689.Metal3 vout.$1264.Metal4 0.0107992f
Cred_577 \$I66.$689.Metal3 vout.$436.Metal2 5.26644e-06f
Cred_578 \$I66.$689.Metal3 vout.$498.Metal2 0.00040586f
Cred_579 \$I66.$689.Metal3 vout.$500.Metal2 8.53978e-05f
Cred_580 \$I66.$689.Metal3 vout.$516.Metal2 0.00585645f
Cred_581 \$I66.$689.Metal3 vout.$518.Metal2 0.00524849f
Cred_582 \$I66.$689.Metal3 vout.$520.Metal2 0.00120525f
Cred_583 \$I66.$689.Metal3 vout.$864.Metal3 0.000119196f
Cred_584 \$I66.$689.Metal3 vout.$886.Metal3 0.020248f
Cred_585 \$I66.$689.Metal3 vout.$888.Metal3 0.00426042f
Cred_586 \$I66.$689.Metal3 vout.$904.Metal3 0.041675f
Cred_587 \$I66.$689.Metal3 vout.P0.nSD 0.00667229f
Cred_588 \$I66.$689.Metal3 vout.P2.nSD 0.00555817f
Cred_589 \$I66.$689.Metal3 vout.P4.nSD 0.001312f
Cred_590 \$I66.$689.Metal3 vss 0.124024f
Cred_591 \$I66.$689.Metal3 vss.$10.Metal1 0.00204244f
Cred_592 \$I66.$689.Metal3 vss.$1013.Metal4 2.463e-05f
Cred_593 \$I66.$689.Metal3 vss.$1017.Metal4 1.30147e-05f
Cred_594 \$I66.$689.Metal3 vss.$1211.Metal5 0.126518f
Cred_595 \$I66.$689.Metal3 vss.$1229.Metal5 0.119324f
Cred_596 \$I66.$689.Metal3 vss.$127.Metal1 0.0668149f
Cred_597 \$I66.$689.Metal3 vss.$1281.Metal5 0.538112f
Cred_598 \$I66.$689.Metal3 vss.$1299.Metal5 0.452356f
Cred_599 \$I66.$689.Metal3 vss.$13.Metal1 0.000978778f
Cred_600 \$I66.$689.Metal3 vss.$136.Metal1 0.000489779f
Cred_601 \$I66.$689.Metal3 vss.$406.Metal1 0.00621342f
Cred_602 \$I66.$689.Metal3 vss.$457.Metal2 0.000975822f
Cred_603 \$I66.$689.Metal3 vss.$461.Metal2 0.0127458f
Cred_604 \$I66.$689.Metal3 vss.$463.Metal2 0.00364833f
Cred_605 \$I66.$689.Metal3 vss.$467.Metal2 0.00659041f
Cred_606 \$I66.$689.Metal3 vss.$469.Metal2 0.0133614f
Cred_607 \$I66.$689.Metal3 vss.$473.Metal2 0.00701468f
Cred_608 \$I66.$689.Metal3 vss.$475.Metal2 0.00304133f
Cred_609 \$I66.$689.Metal3 vss.$799.Metal3 0.00264047f
Cred_610 \$I66.$689.Metal3 vss.$801.Metal3 0.0050257f
Cred_611 \$I66.$689.Metal3 vss.$805.Metal3 0.00448175f
Cred_612 \$I66.$689.Metal3 vss.$809.Metal3 0.0022204f
Cred_613 \$I66.$689.Metal3 vss.P0.GatPoly 0.0229351f
Cred_614 \$I66.$689.Metal3 vss.P0.nSD 0.00362645f
Cred_615 \$I66.$689.Metal3 vss.P0.pSD 0.33537f
Cred_616 \$I66.$689.Metal3 vss.P1.nSD 0.00415869f
Cred_617 \$I66.$689.Metal3 vss.P3.nSD 0.0124871f
Cred_618 \$I66.$689.Metal3 vss.P5.nSD 0.00576652f
Cred_619 \$I66.$692.Metal3 \$I66.$748.Metal3 1.18669e-05f
Cred_620 \$I66.$692.Metal3 \$I67 0.000895054f
Cred_621 \$I66.$692.Metal3 \$I67.$82.Metal2 0.114288f
Cred_622 \$I66.$692.Metal3 \$I67.P0.GatPoly 0.00146984f
Cred_623 \$I66.$692.Metal3 \$I67.P3.GatPoly 0.00014332f
Cred_624 \$I66.$692.Metal3 \$I67.P4.GatPoly 0.000141995f
Cred_625 \$I66.$692.Metal3 \$I78 0.00404362f
Cred_626 \$I66.$692.Metal3 rfin 0.00238037f
Cred_627 \$I66.$692.Metal3 vss 0.583969f
Cred_628 \$I66.$692.Metal3 vdd.$2365.Metal1 9.96863e-05f
Cred_629 \$I66.$692.Metal3 vdd.$2399.Metal1 8.01468e-07f
Cred_630 \$I66.$692.Metal3 vdd.P0.nSD 0.00100027f
Cred_631 \$I66.$692.Metal3 vdd.P1.GatPoly 2.37781e-05f
Cred_632 \$I66.$692.Metal3 vdd.P2.GatPoly 3.56481e-08f
Cred_633 \$I66.$692.Metal3 vout 0.000528972f
Cred_634 \$I66.$692.Metal3 vout.$121.Metal1 2.92251e-07f
Cred_635 \$I66.$692.Metal3 vout.$122.Metal1 0.00189809f
Cred_636 \$I66.$692.Metal3 vout.$123.Metal1 0.00859806f
Cred_637 \$I66.$692.Metal3 vout.$1235.Metal4 0.00325126f
Cred_638 \$I66.$692.Metal3 vout.$1236.Metal4 0.0166415f
Cred_639 \$I66.$692.Metal3 vout.$1237.Metal4 0.0134958f
Cred_640 \$I66.$692.Metal3 vout.$1238.Metal4 0.00257108f
Cred_641 \$I66.$692.Metal3 vout.$124.Metal1 0.00709002f
Cred_642 \$I66.$692.Metal3 vout.$125.Metal1 0.00141394f
Cred_643 \$I66.$692.Metal3 vout.$1264.Metal4 2.04262e-05f
Cred_644 \$I66.$692.Metal3 vout.$1299.Metal4 0.00369302f
Cred_645 \$I66.$692.Metal3 vout.$1313.Metal4 8.86113e-09f
Cred_646 \$I66.$692.Metal3 vout.$498.Metal2 8.29533e-05f
Cred_647 \$I66.$692.Metal3 vout.$500.Metal2 0.000403722f
Cred_648 \$I66.$692.Metal3 vout.$502.Metal2 0.000313265f
Cred_649 \$I66.$692.Metal3 vout.$504.Metal2 6.48273e-05f
Cred_650 \$I66.$692.Metal3 vout.$516.Metal2 2.21871e-05f
Cred_651 \$I66.$692.Metal3 vout.$518.Metal2 0.00106125f
Cred_652 \$I66.$692.Metal3 vout.$520.Metal2 0.00764391f
Cred_653 \$I66.$692.Metal3 vout.$522.Metal2 0.00398028f
Cred_654 \$I66.$692.Metal3 vout.$524.Metal2 0.000805597f
Cred_655 \$I66.$692.Metal3 vout.$886.Metal3 0.00413847f
Cred_656 \$I66.$692.Metal3 vout.$888.Metal3 0.0201413f
Cred_657 \$I66.$692.Metal3 vout.$890.Metal3 0.0156285f
Cred_658 \$I66.$692.Metal3 vout.$892.Metal3 0.00323418f
Cred_659 \$I66.$692.Metal3 vout.$904.Metal3 0.000374409f
Cred_660 \$I66.$692.Metal3 vout.P0.GatPoly 8.29779e-08f
Cred_661 \$I66.$692.Metal3 vout.P2.nSD 0.000809942f
Cred_662 \$I66.$692.Metal3 vout.P4.nSD 0.00505555f
Cred_663 \$I66.$692.Metal3 vout.P6.nSD 0.00416679f
Cred_664 \$I66.$692.Metal3 vout.P8.nSD 0.000983565f
Cred_665 \$I66.$692.Metal3 vref 0.0494222f
Cred_666 \$I66.$692.Metal3 vref.P0.GatPoly 0.0031366f
Cred_667 \$I66.$692.Metal3 vref.P0.nSD 0.0117526f
Cred_668 \$I66.$692.Metal3 vref.P0.pSD 0.0150452f
Cred_669 \$I66.$692.Metal3 vss 0.0271041f
Cred_670 \$I66.$692.Metal3 vss.$1017.Metal4 6.50614e-06f
Cred_671 \$I66.$692.Metal3 vss.$1023.Metal4 2.01984e-05f
Cred_672 \$I66.$692.Metal3 vss.$1027.Metal4 9.45655e-06f
Cred_673 \$I66.$692.Metal3 vss.$1211.Metal5 0.0279803f
Cred_674 \$I66.$692.Metal3 vss.$1229.Metal5 0.0279803f
Cred_675 \$I66.$692.Metal3 vss.$127.Metal1 0.00333792f
Cred_676 \$I66.$692.Metal3 vss.$1281.Metal5 0.113909f
Cred_677 \$I66.$692.Metal3 vss.$1299.Metal5 0.106791f
Cred_678 \$I66.$692.Metal3 vss.$13.Metal1 0.000489428f
Cred_679 \$I66.$692.Metal3 vss.$136.Metal1 0.00190587f
Cred_680 \$I66.$692.Metal3 vss.$138.Metal1 0.000238399f
Cred_681 \$I66.$692.Metal3 vss.$140.Metal1 0.000556904f
Cred_682 \$I66.$692.Metal3 vss.$406.Metal1 0.00536984f
Cred_683 \$I66.$692.Metal3 vss.$457.Metal2 4.87498e-05f
Cred_684 \$I66.$692.Metal3 vss.$473.Metal2 0.00619807f
Cred_685 \$I66.$692.Metal3 vss.$475.Metal2 0.00667129f
Cred_686 \$I66.$692.Metal3 vss.$479.Metal2 0.0161746f
Cred_687 \$I66.$692.Metal3 vss.$483.Metal2 0.00644819f
Cred_688 \$I66.$692.Metal3 vss.$487.Metal2 0.00105533f
Cred_689 \$I66.$692.Metal3 vss.$805.Metal3 0.000551796f
Cred_690 \$I66.$692.Metal3 vss.$809.Metal3 0.00278542f
Cred_691 \$I66.$692.Metal3 vss.$811.Metal3 0.00478831f
Cred_692 \$I66.$692.Metal3 vss.$815.Metal3 0.00340413f
Cred_693 \$I66.$692.Metal3 vss.$819.Metal3 0.0016258f
Cred_694 \$I66.$692.Metal3 vss.P0.GatPoly 0.000135896f
Cred_695 \$I66.$692.Metal3 vss.P0.pSD 0.0795712f
Cred_696 \$I66.$692.Metal3 vss.P10.nSD 0.00435389f
Cred_697 \$I66.$692.Metal3 vss.P5.nSD 0.00570524f
Cred_698 \$I66.$692.Metal3 vss.P7.nSD 0.0108598f
Cred_699 \$I66.$696.Metal3 \$I67.$82.Metal2 0.472055f
Cred_700 \$I66.$696.Metal3 \$I67.P0.GatPoly 0.0379336f
Cred_701 \$I66.$696.Metal3 \$I67.P3.GatPoly 0.0177918f
Cred_702 \$I66.$696.Metal3 \$I67.P4.GatPoly 0.0114711f
Cred_703 \$I66.$696.Metal3 vss 0.386479f
Cred_704 \$I66.$696.Metal3 vout.$1237.Metal4 0.00838147f
Cred_705 \$I66.$696.Metal3 vout.$1238.Metal4 0.022497f
Cred_706 \$I66.$696.Metal3 vout.$1239.Metal4 0.00345348f
Cred_707 \$I66.$696.Metal3 vout.$124.Metal1 0.00425983f
Cred_708 \$I66.$696.Metal3 vout.$125.Metal1 0.00975042f
Cred_709 \$I66.$696.Metal3 vout.$126.Metal1 0.00463101f
Cred_710 \$I66.$696.Metal3 vout.$1269.Metal4 0.0150036f
Cred_711 \$I66.$696.Metal3 vout.$127.Metal1 0.000945876f
Cred_712 \$I66.$696.Metal3 vout.$1299.Metal4 0.0500565f
Cred_713 \$I66.$696.Metal3 vout.$502.Metal2 0.000180551f
Cred_714 \$I66.$696.Metal3 vout.$504.Metal2 0.00042324f
Cred_715 \$I66.$696.Metal3 vout.$522.Metal2 0.00235301f
Cred_716 \$I66.$696.Metal3 vout.$524.Metal2 0.00549893f
Cred_717 \$I66.$696.Metal3 vout.$526.Metal2 0.00181135f
Cred_718 \$I66.$696.Metal3 vout.$528.Metal2 0.000365522f
Cred_719 \$I66.$696.Metal3 vout.$890.Metal3 0.00900752f
Cred_720 \$I66.$696.Metal3 vout.$892.Metal3 0.0211151f
Cred_721 \$I66.$696.Metal3 vout.$934.Metal3 0.0109739f
Cred_722 \$I66.$696.Metal3 vout.$936.Metal3 0.00231992f
Cred_723 \$I66.$696.Metal3 vout.P10.nSD 0.00240024f
Cred_724 \$I66.$696.Metal3 vout.P12.nSD 0.000404614f
Cred_725 \$I66.$696.Metal3 vout.P6.nSD 0.00219817f
Cred_726 \$I66.$696.Metal3 vout.P8.nSD 0.00538323f
Cred_727 \$I66.$696.Metal3 vref 0.0685411f
Cred_728 \$I66.$696.Metal3 vref.P0.GatPoly 0.00266381f
Cred_729 \$I66.$696.Metal3 vref.P0.nSD 0.0227329f
Cred_730 \$I66.$696.Metal3 vref.P0.pSD 0.0205258f
Cred_731 \$I66.$696.Metal3 vss 0.00615328f
Cred_732 \$I66.$696.Metal3 vss.$1023.Metal4 4.42722e-06f
Cred_733 \$I66.$696.Metal3 vss.$1027.Metal4 9.45655e-06f
Cred_734 \$I66.$696.Metal3 vss.$1033.Metal4 2.46357e-05f
Cred_735 \$I66.$696.Metal3 vss.$1037.Metal4 1.2307e-05f
Cred_736 \$I66.$696.Metal3 vss.$1043.Metal4 3.1502e-06f
Cred_737 \$I66.$696.Metal3 vss.$1211.Metal5 0.00634592f
Cred_738 \$I66.$696.Metal3 vss.$1229.Metal5 0.00634592f
Cred_739 \$I66.$696.Metal3 vss.$127.Metal1 0.00156905f
Cred_740 \$I66.$696.Metal3 vss.$1281.Metal5 0.0646783f
Cred_741 \$I66.$696.Metal3 vss.$1299.Metal5 0.0415933f
Cred_742 \$I66.$696.Metal3 vss.$136.Metal1 2.44248e-06f
Cred_743 \$I66.$696.Metal3 vss.$138.Metal1 0.000238399f
Cred_744 \$I66.$696.Metal3 vss.$140.Metal1 0.00198773f
Cred_745 \$I66.$696.Metal3 vss.$143.Metal1 0.000598441f
Cred_746 \$I66.$696.Metal3 vss.$146.Metal1 0.000901604f
Cred_747 \$I66.$696.Metal3 vss.$148.Metal1 7.94163e-05f
Cred_748 \$I66.$696.Metal3 vss.$406.Metal1 0.00732352f
Cred_749 \$I66.$696.Metal3 vss.$457.Metal2 2.29157e-05f
Cred_750 \$I66.$696.Metal3 vss.$475.Metal2 0.000207151f
Cred_751 \$I66.$696.Metal3 vss.$479.Metal2 0.00231325f
Cred_752 \$I66.$696.Metal3 vss.$483.Metal2 0.0103361f
Cred_753 \$I66.$696.Metal3 vss.$487.Metal2 0.00729882f
Cred_754 \$I66.$696.Metal3 vss.$489.Metal2 0.0105971f
Cred_755 \$I66.$696.Metal3 vss.$493.Metal2 0.00529385f
Cred_756 \$I66.$696.Metal3 vss.$495.Metal2 0.00358113f
Cred_757 \$I66.$696.Metal3 vss.$499.Metal2 0.00481113f
Cred_758 \$I66.$696.Metal3 vss.$811.Metal3 0.000377922f
Cred_759 \$I66.$696.Metal3 vss.$815.Metal3 0.0014737f
Cred_760 \$I66.$696.Metal3 vss.$819.Metal3 0.00326274f
Cred_761 \$I66.$696.Metal3 vss.$821.Metal3 0.00523464f
Cred_762 \$I66.$696.Metal3 vss.$825.Metal3 0.00475687f
Cred_763 \$I66.$696.Metal3 vss.$829.Metal3 0.00261501f
Cred_764 \$I66.$696.Metal3 vss.$831.Metal3 0.00136065f
Cred_765 \$I66.$696.Metal3 vss.$835.Metal3 0.000267173f
Cred_766 \$I66.$696.Metal3 vss.P0.GatPoly 5.60949e-05f
Cred_767 \$I66.$696.Metal3 vss.P0.pSD 0.0642601f
Cred_768 \$I66.$696.Metal3 vss.P10.nSD 0.00717843f
Cred_769 \$I66.$696.Metal3 vss.P11.nSD 0.00911666f
Cred_770 \$I66.$696.Metal3 vss.P13.nSD 0.00455431f
Cred_771 \$I66.$696.Metal3 vss.P15.nSD 0.00300081f
Cred_772 \$I66.$696.Metal3 vss.P7.nSD 0.00167599f
Cred_773 \$I66.$700.Metal3 \$I67.$82.Metal2 0.165601f
Cred_774 \$I66.$700.Metal3 \$I67.P0.GatPoly 0.0141568f
Cred_775 \$I66.$700.Metal3 \$I67.P3.GatPoly 0.00177935f
Cred_776 \$I66.$700.Metal3 \$I67.P4.GatPoly 0.00808553f
Cred_777 \$I66.$700.Metal3 vss 0.466415f
Cred_778 \$I66.$700.Metal3 vout.$1239.Metal4 0.00345174f
Cred_779 \$I66.$700.Metal3 vout.$126.Metal1 0.0065097f
Cred_780 \$I66.$700.Metal3 vout.$1269.Metal4 0.0920906f
Cred_781 \$I66.$700.Metal3 vout.$127.Metal1 0.0103789f
Cred_782 \$I66.$700.Metal3 vout.$128.Metal1 0.0070813f
Cred_783 \$I66.$700.Metal3 vout.$129.Metal1 0.00141944f
Cred_784 \$I66.$700.Metal3 vout.$1299.Metal4 0.267506f
Cred_785 \$I66.$700.Metal3 vout.$526.Metal2 0.002529f
Cred_786 \$I66.$700.Metal3 vout.$528.Metal2 0.00398578f
Cred_787 \$I66.$700.Metal3 vout.$530.Metal2 0.00272398f
Cred_788 \$I66.$700.Metal3 vout.$532.Metal2 0.000548525f
Cred_789 \$I66.$700.Metal3 vout.$934.Metal3 0.0151479f
Cred_790 \$I66.$700.Metal3 vout.$936.Metal3 0.0241532f
Cred_791 \$I66.$700.Metal3 vout.$938.Metal3 0.0167172f
Cred_792 \$I66.$700.Metal3 vout.$940.Metal3 0.00348141f
Cred_793 \$I66.$700.Metal3 vout.P10.nSD 0.00320897f
Cred_794 \$I66.$700.Metal3 vout.P12.nSD 0.00445565f
Cred_795 \$I66.$700.Metal3 vout.P14.nSD 0.00303709f
Cred_796 \$I66.$700.Metal3 vout.P16.nSD 0.000607188f
Cred_797 \$I66.$700.Metal3 vref 0.0672117f
Cred_798 \$I66.$700.Metal3 vref.P0.GatPoly 0.00257767f
Cred_799 \$I66.$700.Metal3 vref.P0.nSD 0.00988745f
Cred_800 \$I66.$700.Metal3 vref.P0.pSD 0.0102149f
Cred_801 \$I66.$700.Metal3 vss 0.000498825f
Cred_802 \$I66.$700.Metal3 vss.$1037.Metal4 1.23008e-05f
Cred_803 \$I66.$700.Metal3 vss.$1043.Metal4 1.57629e-05f
Cred_804 \$I66.$700.Metal3 vss.$1047.Metal4 2.29059e-05f
Cred_805 \$I66.$700.Metal3 vss.$1053.Metal4 4.87745e-06f
Cred_806 \$I66.$700.Metal3 vss.$1211.Metal5 0.000514442f
Cred_807 \$I66.$700.Metal3 vss.$1229.Metal5 0.000514442f
Cred_808 \$I66.$700.Metal3 vss.$127.Metal1 0.000922874f
Cred_809 \$I66.$700.Metal3 vss.$1281.Metal5 0.00196918f
Cred_810 \$I66.$700.Metal3 vss.$1299.Metal5 0.0192629f
Cred_811 \$I66.$700.Metal3 vss.$143.Metal1 0.000199262f
Cred_812 \$I66.$700.Metal3 vss.$146.Metal1 0.00164663f
Cred_813 \$I66.$700.Metal3 vss.$148.Metal1 0.000397382f
Cred_814 \$I66.$700.Metal3 vss.$150.Metal1 0.00143348f
Cred_815 \$I66.$700.Metal3 vss.$153.Metal1 0.000366909f
Cred_816 \$I66.$700.Metal3 vss.$406.Metal1 0.0166669f
Cred_817 \$I66.$700.Metal3 vss.$457.Metal2 1.34784e-05f
Cred_818 \$I66.$700.Metal3 vss.$493.Metal2 0.00529119f
Cred_819 \$I66.$700.Metal3 vss.$495.Metal2 0.0052084f
Cred_820 \$I66.$700.Metal3 vss.$499.Metal2 0.014853f
Cred_821 \$I66.$700.Metal3 vss.$503.Metal2 0.0164758f
Cred_822 \$I66.$700.Metal3 vss.$507.Metal2 0.00574736f
Cred_823 \$I66.$700.Metal3 vss.$509.Metal2 0.00548509f
Cred_824 \$I66.$700.Metal3 vss.$825.Metal3 0.00158389f
Cred_825 \$I66.$700.Metal3 vss.$829.Metal3 0.00261369f
Cred_826 \$I66.$700.Metal3 vss.$831.Metal3 0.00353125f
Cred_827 \$I66.$700.Metal3 vss.$835.Metal3 0.00446548f
Cred_828 \$I66.$700.Metal3 vss.$839.Metal3 0.00425281f
Cred_829 \$I66.$700.Metal3 vss.$841.Metal3 0.00208815f
Cred_830 \$I66.$700.Metal3 vss.$845.Metal3 0.000413664f
Cred_831 \$I66.$700.Metal3 vss.P0.GatPoly 3.29936e-05f
Cred_832 \$I66.$700.Metal3 vss.P0.pSD 0.0702166f
Cred_833 \$I66.$700.Metal3 vss.P13.nSD 0.00455201f
Cred_834 \$I66.$700.Metal3 vss.P15.nSD 0.00908608f
Cred_835 \$I66.$700.Metal3 vss.P17.nSD 0.0113319f
Cred_836 \$I66.$700.Metal3 vss.P19.nSD 0.00447493f
Cred_837 \$I66.$704.Metal3 vss 0.492494f
Cred_838 \$I66.$704.Metal3 vout.$1269.Metal4 0.0742397f
Cred_839 \$I66.$704.Metal3 vout.$128.Metal1 0.00424027f
Cred_840 \$I66.$704.Metal3 vout.$129.Metal1 0.00990639f
Cred_841 \$I66.$704.Metal3 vout.$1299.Metal4 0.237788f
Cred_842 \$I66.$704.Metal3 vout.$130.Metal1 0.0111226f
Cred_843 \$I66.$704.Metal3 vout.$530.Metal2 0.0016261f
Cred_844 \$I66.$704.Metal3 vout.$532.Metal2 0.00380319f
Cred_845 \$I66.$704.Metal3 vout.$534.Metal2 0.004342f
Cred_846 \$I66.$704.Metal3 vout.$938.Metal3 0.00974908f
Cred_847 \$I66.$704.Metal3 vout.$940.Metal3 0.0229943f
Cred_848 \$I66.$704.Metal3 vout.$942.Metal3 0.0261069f
Cred_849 \$I66.$704.Metal3 vout.P14.nSD 0.0018218f
Cred_850 \$I66.$704.Metal3 vout.P16.nSD 0.00425354f
Cred_851 \$I66.$704.Metal3 vout.P18.nSD 0.00561041f
Cred_852 \$I66.$704.Metal3 vref 0.041401f
Cred_853 \$I66.$704.Metal3 vref.P0.GatPoly 0.0012219f
Cred_854 \$I66.$704.Metal3 vref.P0.nSD 0.000738993f
Cred_855 \$I66.$704.Metal3 vref.P0.pSD 0.00129526f
Cred_856 \$I66.$704.Metal3 vss 0.00480648f
Cred_857 \$I66.$704.Metal3 vss.$1047.Metal4 1.72587e-06f
Cred_858 \$I66.$704.Metal3 vss.$1053.Metal4 1.46397e-05f
Cred_859 \$I66.$704.Metal3 vss.$1057.Metal4 2.463e-05f
Cred_860 \$I66.$704.Metal3 vss.$1211.Metal5 0.00495695f
Cred_861 \$I66.$704.Metal3 vss.$1229.Metal5 0.00495695f
Cred_862 \$I66.$704.Metal3 vss.$127.Metal1 0.000467197f
Cred_863 \$I66.$704.Metal3 vss.$1281.Metal5 0.0189742f
Cred_864 \$I66.$704.Metal3 vss.$1299.Metal5 0.0189742f
Cred_865 \$I66.$704.Metal3 vss.$150.Metal1 0.000963769f
Cred_866 \$I66.$704.Metal3 vss.$153.Metal1 0.00110102f
Cred_867 \$I66.$704.Metal3 vss.$156.Metal1 0.00204244f
Cred_868 \$I66.$704.Metal3 vss.$159.Metal1 0.0108858f
Cred_869 \$I66.$704.Metal3 vss.$406.Metal1 0.282032f
Cred_870 \$I66.$704.Metal3 vss.$457.Metal2 6.82334e-06f
Cred_871 \$I66.$704.Metal3 vss.$503.Metal2 0.0021697f
Cred_872 \$I66.$704.Metal3 vss.$507.Metal2 0.00511418f
Cred_873 \$I66.$704.Metal3 vss.$509.Metal2 0.00996074f
Cred_874 \$I66.$704.Metal3 vss.$513.Metal2 0.0152993f
Cred_875 \$I66.$704.Metal3 vss.$515.Metal2 0.00691468f
Cred_876 \$I66.$704.Metal3 vss.$519.Metal2 0.00329958f
Cred_877 \$I66.$704.Metal3 vss.$521.Metal2 0.00832826f
Cred_878 \$I66.$704.Metal3 vss.$525.Metal2 0.000158986f
Cred_879 \$I66.$704.Metal3 vss.$835.Metal3 0.000146374f
Cred_880 \$I66.$704.Metal3 vss.$839.Metal3 0.000912434f
Cred_881 \$I66.$704.Metal3 vss.$841.Metal3 0.0029161f
Cred_882 \$I66.$704.Metal3 vss.$845.Metal3 0.00461957f
Cred_883 \$I66.$704.Metal3 vss.$849.Metal3 0.0050257f
Cred_884 \$I66.$704.Metal3 vss.$851.Metal3 0.00264047f
Cred_885 \$I66.$704.Metal3 vss.P0.GatPoly 1.67027e-05f
Cred_886 \$I66.$704.Metal3 vss.P0.pSD 0.0756571f
Cred_887 \$I66.$704.Metal3 vss.P1.GatPoly 0.0187314f
Cred_888 \$I66.$704.Metal3 vss.P17.nSD 0.00144008f
Cred_889 \$I66.$704.Metal3 vss.P19.nSD 0.00752139f
Cred_890 \$I66.$704.Metal3 vss.P21.nSD 0.0135172f
Cred_891 \$I66.$704.Metal3 vss.P23.nSD 0.00290557f
Cred_892 \$I66.$704.Metal3 vss.P25.nSD 0.00238883f
Cred_893 \$I66.$748.Metal3 \$I67 0.00137821f
Cred_894 \$I66.$748.Metal3 \$I67.$82.Metal2 0.388768f
Cred_895 \$I66.$748.Metal3 \$I67.P0.GatPoly 0.00115604f
Cred_896 \$I66.$748.Metal3 \$I67.P1.GatPoly 0.000491053f
Cred_897 \$I66.$748.Metal3 \$I67.P2.GatPoly 0.000480176f
Cred_898 \$I66.$748.Metal3 \$I67.P3.GatPoly 0.000105277f
Cred_899 \$I66.$748.Metal3 \$I67.P4.GatPoly 0.000105277f
Cred_900 \$I66.$748.Metal3 \$I78 0.0159241f
Cred_901 \$I66.$748.Metal3 rfin 0.00366529f
Cred_902 \$I66.$748.Metal3 vss 0.533329f
Cred_903 \$I66.$748.Metal3 vdd.$2365.Metal1 0.000337958f
Cred_904 \$I66.$748.Metal3 vdd.$2375.Metal1 6.06001e-07f
Cred_905 \$I66.$748.Metal3 vdd.$2399.Metal1 7.64752e-05f
Cred_906 \$I66.$748.Metal3 vdd.$2761.Metal2 5.13958e-05f
Cred_907 \$I66.$748.Metal3 vdd.$2765.Metal2 0.000421187f
Cred_908 \$I66.$748.Metal3 vdd.$2997.Metal3 8.10359e-05f
Cred_909 \$I66.$748.Metal3 vdd.P0.nSD 0.0150024f
Cred_910 \$I66.$748.Metal3 vdd.P1.GatPoly 4.48181e-05f
Cred_911 \$I66.$748.Metal3 vdd.P2.GatPoly 3.4015e-06f
Cred_912 \$I66.$748.Metal3 vdd.P7.pSD 0.000673578f
Cred_913 \$I66.$748.Metal3 vout 0.0457433f
Cred_914 \$I66.$748.Metal3 vout.$1036.Metal3 0.000604928f
Cred_915 \$I66.$748.Metal3 vout.$1038.Metal3 0.000845216f
Cred_916 \$I66.$748.Metal3 vout.$1040.Metal3 0.000821547f
Cred_917 \$I66.$748.Metal3 vout.$121.Metal1 4.50008e-07f
Cred_918 \$I66.$748.Metal3 vout.$122.Metal1 6.28969e-07f
Cred_919 \$I66.$748.Metal3 vout.$123.Metal1 3.65814e-07f
Cred_920 \$I66.$748.Metal3 vout.$1235.Metal4 5.84626e-05f
Cred_921 \$I66.$748.Metal3 vout.$1236.Metal4 0.00665263f
Cred_922 \$I66.$748.Metal3 vout.$1264.Metal4 3.14524e-05f
Cred_923 \$I66.$748.Metal3 vout.$1299.Metal4 0.000717211f
Cred_924 \$I66.$748.Metal3 vout.$1313.Metal4 0.00106191f
Cred_925 \$I66.$748.Metal3 vout.$1330.Metal4 0.00549245f
Cred_926 \$I66.$748.Metal3 vout.$1331.Metal4 0.000100665f
Cred_927 \$I66.$748.Metal3 vout.$1332.Metal4 9.78464e-05f
Cred_928 \$I66.$748.Metal3 vout.$1370.Metal4 0.000133523f
Cred_929 \$I66.$748.Metal3 vout.$158.Metal1 0.000485792f
Cred_930 \$I66.$748.Metal3 vout.$159.Metal1 1.0253e-06f
Cred_931 \$I66.$748.Metal3 vout.$160.Metal1 9.96588e-07f
Cred_932 \$I66.$748.Metal3 vout.$208.Metal1 0.000100904f
Cred_933 \$I66.$748.Metal3 vout.$498.Metal2 1.04271e-05f
Cred_934 \$I66.$748.Metal3 vout.$500.Metal2 8.11165e-06f
Cred_935 \$I66.$748.Metal3 vout.$516.Metal2 3.41637e-05f
Cred_936 \$I66.$748.Metal3 vout.$518.Metal2 5.28648e-05f
Cred_937 \$I66.$748.Metal3 vout.$520.Metal2 3.33285e-05f
Cred_938 \$I66.$748.Metal3 vout.$588.Metal2 0.000215069f
Cred_939 \$I66.$748.Metal3 vout.$590.Metal2 8.60417e-05f
Cred_940 \$I66.$748.Metal3 vout.$592.Metal2 8.36322e-05f
Cred_941 \$I66.$748.Metal3 vout.$608.Metal2 1.43287e-05f
Cred_942 \$I66.$748.Metal3 vout.$610.Metal2 1.69419e-05f
Cred_943 \$I66.$748.Metal3 vout.$612.Metal2 1.64674e-05f
Cred_944 \$I66.$748.Metal3 vout.$886.Metal3 0.000520197f
Cred_945 \$I66.$748.Metal3 vout.$888.Metal3 0.000404683f
Cred_946 \$I66.$748.Metal3 vout.$904.Metal3 0.000576515f
Cred_947 \$I66.$748.Metal3 vout.P0.GatPoly 0.012164f
Cred_948 \$I66.$748.Metal3 vout.P4.pSD 0.000136457f
Cred_949 \$I66.$748.Metal3 vref 0.141339f
Cred_950 \$I66.$748.Metal3 vref.P0.GatPoly 0.0134553f
Cred_951 \$I66.$748.Metal3 vref.P0.nSD 0.0164154f
Cred_952 \$I66.$748.Metal3 vref.P0.pSD 0.0326833f
Cred_953 \$I66.$748.Metal3 vss 0.0543923f
Cred_954 \$I66.$748.Metal3 vss.$1211.Metal5 0.042549f
Cred_955 \$I66.$748.Metal3 vss.$1229.Metal5 0.042549f
Cred_956 \$I66.$748.Metal3 vss.$127.Metal1 0.000361356f
Cred_957 \$I66.$748.Metal3 vss.$1281.Metal5 0.162388f
Cred_958 \$I66.$748.Metal3 vss.$1299.Metal5 0.162388f
Cred_959 \$I66.$748.Metal3 vss.$406.Metal1 0.000315608f
Cred_960 \$I66.$748.Metal3 vss.$457.Metal2 5.27756e-06f
Cred_961 \$I66.$748.Metal3 vss.P0.GatPoly 3.84213e-05f
Cred_962 \$I66.$748.Metal3 vss.P0.pSD 0.00580595f
Cred_963 \$I66.$758.Metal3 \$I67.$82.Metal2 0.0192859f
Cred_964 \$I66.$758.Metal3 \$I67.P1.GatPoly 8.03551e-06f
Cred_965 \$I66.$758.Metal3 \$I67.P2.GatPoly 7.65404e-06f
Cred_966 \$I66.$758.Metal3 \$I78 0.597385f
Cred_967 \$I66.$758.Metal3 vss 0.105376f
Cred_968 \$I66.$758.Metal3 vdd.$2365.Metal1 0.0326959f
Cred_969 \$I66.$758.Metal3 vdd.$2370.Metal1 2.13031e-05f
Cred_970 \$I66.$758.Metal3 vdd.$2375.Metal1 6.78156e-06f
Cred_971 \$I66.$758.Metal3 vdd.$2399.Metal1 0.000597605f
Cred_972 \$I66.$758.Metal3 vdd.$2747.Metal2 0.00382632f
Cred_973 \$I66.$758.Metal3 vdd.$2749.Metal2 0.0029379f
Cred_974 \$I66.$758.Metal3 vdd.$2751.Metal2 0.00409061f
Cred_975 \$I66.$758.Metal3 vdd.$2755.Metal2 0.0168987f
Cred_976 \$I66.$758.Metal3 vdd.$2759.Metal2 0.0123748f
Cred_977 \$I66.$758.Metal3 vdd.$2761.Metal2 0.00677607f
Cred_978 \$I66.$758.Metal3 vdd.$2765.Metal2 0.00471337f
Cred_979 \$I66.$758.Metal3 vdd.$2983.Metal3 0.000801618f
Cred_980 \$I66.$758.Metal3 vdd.$2987.Metal3 0.00353282f
Cred_981 \$I66.$758.Metal3 vdd.$2991.Metal3 0.000896521f
Cred_982 \$I66.$758.Metal3 vdd.$2993.Metal3 0.00309412f
Cred_983 \$I66.$758.Metal3 vdd.$2997.Metal3 0.00193078f
Cred_984 \$I66.$758.Metal3 vdd.$3219.Metal4 9.45176e-06f
Cred_985 \$I66.$758.Metal3 vdd.$3223.Metal4 1.05707e-05f
Cred_986 \$I66.$758.Metal3 vdd.$3229.Metal4 1.20731e-05f
Cred_987 \$I66.$758.Metal3 vdd.P0.nSD 0.420368f
Cred_988 \$I66.$758.Metal3 vdd.P0.pSD 0.00334101f
Cred_989 \$I66.$758.Metal3 vdd.P1.GatPoly 0.0144791f
Cred_990 \$I66.$758.Metal3 vdd.P1.pSD 0.00740362f
Cred_991 \$I66.$758.Metal3 vdd.P2.GatPoly 2.65805e-05f
Cred_992 \$I66.$758.Metal3 vdd.P3.pSD 0.0284106f
Cred_993 \$I66.$758.Metal3 vdd.P5.pSD 0.0271896f
Cred_994 \$I66.$758.Metal3 vdd.P7.pSD 0.0075378f
Cred_995 \$I66.$758.Metal3 vout.$1032.Metal3 0.0173107f
Cred_996 \$I66.$758.Metal3 vout.$1034.Metal3 0.0172213f
Cred_997 \$I66.$758.Metal3 vout.$1036.Metal3 0.012794f
Cred_998 \$I66.$758.Metal3 vout.$1112.Metal3 9.05368e-06f
Cred_999 \$I66.$758.Metal3 vout.$1152.Metal3 2.14336e-05f
Cred_1000 \$I66.$758.Metal3 vout.$1328.Metal4 0.00601852f
Cred_1001 \$I66.$758.Metal3 vout.$1329.Metal4 0.00601138f
Cred_1002 \$I66.$758.Metal3 vout.$1330.Metal4 0.00261418f
Cred_1003 \$I66.$758.Metal3 vout.$1368.Metal4 0.000197776f
Cred_1004 \$I66.$758.Metal3 vout.$1369.Metal4 0.00321709f
Cred_1005 \$I66.$758.Metal3 vout.$1370.Metal4 0.00313709f
Cred_1006 \$I66.$758.Metal3 vout.$1408.Metal4 0.00250504f
Cred_1007 \$I66.$758.Metal3 vout.$156.Metal1 0.0199759f
Cred_1008 \$I66.$758.Metal3 vout.$157.Metal1 0.020703f
Cred_1009 \$I66.$758.Metal3 vout.$158.Metal1 0.0153193f
Cred_1010 \$I66.$758.Metal3 vout.$206.Metal1 0.00726387f
Cred_1011 \$I66.$758.Metal3 vout.$207.Metal1 0.0076254f
Cred_1012 \$I66.$758.Metal3 vout.$208.Metal1 0.00472524f
Cred_1013 \$I66.$758.Metal3 vout.$584.Metal2 0.0050681f
Cred_1014 \$I66.$758.Metal3 vout.$586.Metal2 0.00507432f
Cred_1015 \$I66.$758.Metal3 vout.$588.Metal2 0.00505528f
Cred_1016 \$I66.$758.Metal3 vout.$604.Metal2 0.00050559f
Cred_1017 \$I66.$758.Metal3 vout.$606.Metal2 0.000511692f
Cred_1018 \$I66.$758.Metal3 vout.$608.Metal2 0.000359624f
Cred_1019 \$I66.$758.Metal3 vout.$724.Metal2 9.48498e-08f
Cred_1020 \$I66.$758.Metal3 vout.P0.pSD 0.00837349f
Cred_1021 \$I66.$758.Metal3 vout.P2.pSD 0.00839244f
Cred_1022 \$I66.$758.Metal3 vout.P4.pSD 0.00668299f
Cred_1023 \$I66.$758.Metal3 vref 0.0140777f
Cred_1024 \$I66.$758.Metal3 vref.P0.GatPoly 0.000548951f
Cred_1025 \$I66.$758.Metal3 vref.P0.nSD 0.00314695f
Cred_1026 \$I66.$758.Metal3 vref.P0.pSD 0.00918887f
Cred_1027 \$I66.$758.Metal3 vss 0.0522961f
Cred_1028 \$I66.$758.Metal3 vss.$1211.Metal5 0.023335f
Cred_1029 \$I66.$758.Metal3 vss.$1229.Metal5 0.023335f
Cred_1030 \$I66.$758.Metal3 vss.$1281.Metal5 0.0893218f
Cred_1031 \$I66.$758.Metal3 vss.$1299.Metal5 0.0893218f
Cred_1032 \$I66.$760.Metal3 \$I67.$82.Metal2 0.211273f
Cred_1033 \$I66.$760.Metal3 \$I67.P1.GatPoly 0.0068966f
Cred_1034 \$I66.$760.Metal3 \$I67.P2.GatPoly 0.00134964f
Cred_1035 \$I66.$760.Metal3 \$I78 0.389725f
Cred_1036 \$I66.$760.Metal3 vss 0.0394969f
Cred_1037 \$I66.$760.Metal3 vdd.$2365.Metal1 0.00109877f
Cred_1038 \$I66.$760.Metal3 vdd.$2375.Metal1 1.66446e-05f
Cred_1039 \$I66.$760.Metal3 vdd.$2399.Metal1 0.000510995f
Cred_1040 \$I66.$760.Metal3 vdd.$2761.Metal2 0.00141165f
Cred_1041 \$I66.$760.Metal3 vdd.$2765.Metal2 0.0115794f
Cred_1042 \$I66.$760.Metal3 vdd.$2769.Metal2 0.0102218f
Cred_1043 \$I66.$760.Metal3 vdd.$2771.Metal2 0.00446746f
Cred_1044 \$I66.$760.Metal3 vdd.$2773.Metal2 0.00155053f
Cred_1045 \$I66.$760.Metal3 vdd.$2775.Metal2 0.00481425f
Cred_1046 \$I66.$760.Metal3 vdd.$2997.Metal3 0.00184613f
Cred_1047 \$I66.$760.Metal3 vdd.$3001.Metal3 0.000929421f
Cred_1048 \$I66.$760.Metal3 vdd.$3003.Metal3 0.00233413f
Cred_1049 \$I66.$760.Metal3 vdd.$3007.Metal3 0.002278f
Cred_1050 \$I66.$760.Metal3 vdd.$3011.Metal3 0.000645342f
Cred_1051 \$I66.$760.Metal3 vdd.$3233.Metal4 1.09587e-05f
Cred_1052 \$I66.$760.Metal3 vdd.$3239.Metal4 7.79604e-06f
Cred_1053 \$I66.$760.Metal3 vdd.$3243.Metal4 7.60913e-06f
Cred_1054 \$I66.$760.Metal3 vdd.P0.nSD 0.087012f
Cred_1055 \$I66.$760.Metal3 vdd.P1.GatPoly 4.88715e-05f
Cred_1056 \$I66.$760.Metal3 vdd.P10.pSD 0.0210107f
Cred_1057 \$I66.$760.Metal3 vdd.P11.pSD 0.0089868f
Cred_1058 \$I66.$760.Metal3 vdd.P2.GatPoly 2.27283e-05f
Cred_1059 \$I66.$760.Metal3 vdd.P7.pSD 0.019668f
Cred_1060 \$I66.$760.Metal3 vout 0.00229579f
Cred_1061 \$I66.$760.Metal3 vout.$1036.Metal3 0.0037746f
Cred_1062 \$I66.$760.Metal3 vout.$1038.Metal3 0.0153559f
Cred_1063 \$I66.$760.Metal3 vout.$1040.Metal3 0.00966422f
Cred_1064 \$I66.$760.Metal3 vout.$1299.Metal4 2.76452e-08f
Cred_1065 \$I66.$760.Metal3 vout.$1313.Metal4 0.00231586f
Cred_1066 \$I66.$760.Metal3 vout.$1330.Metal4 0.000449555f
Cred_1067 \$I66.$760.Metal3 vout.$1331.Metal4 0.00546301f
Cred_1068 \$I66.$760.Metal3 vout.$1332.Metal4 0.00354978f
Cred_1069 \$I66.$760.Metal3 vout.$1370.Metal4 0.00149422f
Cred_1070 \$I66.$760.Metal3 vout.$1371.Metal4 0.00304527f
Cred_1071 \$I66.$760.Metal3 vout.$1372.Metal4 0.00250118f
Cred_1072 \$I66.$760.Metal3 vout.$158.Metal1 0.00543318f
Cred_1073 \$I66.$760.Metal3 vout.$159.Metal1 0.0218917f
Cred_1074 \$I66.$760.Metal3 vout.$160.Metal1 0.0133973f
Cred_1075 \$I66.$760.Metal3 vout.$208.Metal1 0.00112919f
Cred_1076 \$I66.$760.Metal3 vout.$209.Metal1 0.00432507f
Cred_1077 \$I66.$760.Metal3 vout.$210.Metal1 0.0027508f
Cred_1078 \$I66.$760.Metal3 vout.$588.Metal2 0.00212532f
Cred_1079 \$I66.$760.Metal3 vout.$590.Metal2 0.0045176f
Cred_1080 \$I66.$760.Metal3 vout.$592.Metal2 0.00286278f
Cred_1081 \$I66.$760.Metal3 vout.$608.Metal2 0.000100316f
Cred_1082 \$I66.$760.Metal3 vout.$610.Metal2 0.000402239f
Cred_1083 \$I66.$760.Metal3 vout.$612.Metal2 0.000253778f
Cred_1084 \$I66.$760.Metal3 vout.P0.GatPoly 3.60133e-07f
Cred_1085 \$I66.$760.Metal3 vout.P4.pSD 0.00152705f
Cred_1086 \$I66.$760.Metal3 vout.P6.pSD 0.00777245f
Cred_1087 \$I66.$760.Metal3 vout.P8.pSD 0.00500152f
Cred_1088 \$I66.$760.Metal3 vref 0.029024f
Cred_1089 \$I66.$760.Metal3 vref.P0.GatPoly 0.00113241f
Cred_1090 \$I66.$760.Metal3 vref.P0.nSD 0.00635451f
Cred_1091 \$I66.$760.Metal3 vref.P0.pSD 0.0207886f
Cred_1092 \$I66.$760.Metal3 vss 0.0352517f
Cred_1093 \$I66.$760.Metal3 vss.$1211.Metal5 0.0128632f
Cred_1094 \$I66.$760.Metal3 vss.$1229.Metal5 0.0128632f
Cred_1095 \$I66.$760.Metal3 vss.$1281.Metal5 0.0492375f
Cred_1096 \$I66.$760.Metal3 vss.$1299.Metal5 0.0492375f
Cred_1097 \$I66.$764.Metal3 \$I67.$82.Metal2 0.542966f
Cred_1098 \$I66.$764.Metal3 \$I67.P0.GatPoly 0.000202451f
Cred_1099 \$I66.$764.Metal3 \$I67.P1.GatPoly 0.00925244f
Cred_1100 \$I66.$764.Metal3 \$I67.P2.GatPoly 0.0148375f
Cred_1101 \$I66.$764.Metal3 \$I67.P3.GatPoly 1.37392e-05f
Cred_1102 \$I66.$764.Metal3 \$I67.P4.GatPoly 1.37392e-05f
Cred_1103 \$I66.$764.Metal3 \$I78 0.320725f
Cred_1104 \$I66.$764.Metal3 vss 0.0409301f
Cred_1105 \$I66.$764.Metal3 vdd.$2365.Metal1 0.00050921f
Cred_1106 \$I66.$764.Metal3 vdd.$2399.Metal1 0.000598908f
Cred_1107 \$I66.$764.Metal3 vdd.$2769.Metal2 0.00331459f
Cred_1108 \$I66.$764.Metal3 vdd.$2771.Metal2 0.00157507f
Cred_1109 \$I66.$764.Metal3 vdd.$2773.Metal2 0.00155099f
Cred_1110 \$I66.$764.Metal3 vdd.$2775.Metal2 0.00481568f
Cred_1111 \$I66.$764.Metal3 vdd.$2779.Metal2 0.00963611f
Cred_1112 \$I66.$764.Metal3 vdd.$2781.Metal2 0.00310351f
Cred_1113 \$I66.$764.Metal3 vdd.$2783.Metal2 0.00325462f
Cred_1114 \$I66.$764.Metal3 vdd.$2785.Metal2 0.00691312f
Cred_1115 \$I66.$764.Metal3 vdd.$3003.Metal3 0.000665018f
Cred_1116 \$I66.$764.Metal3 vdd.$3007.Metal3 0.00194786f
Cred_1117 \$I66.$764.Metal3 vdd.$3011.Metal3 0.00193727f
Cred_1118 \$I66.$764.Metal3 vdd.$3015.Metal3 0.00389774f
Cred_1119 \$I66.$764.Metal3 vdd.$3019.Metal3 0.00133073f
Cred_1120 \$I66.$764.Metal3 vdd.$3239.Metal4 3.89781e-06f
Cred_1121 \$I66.$764.Metal3 vdd.$3243.Metal4 7.61138e-06f
Cred_1122 \$I66.$764.Metal3 vdd.$3247.Metal4 1.52306e-05f
Cred_1123 \$I66.$764.Metal3 vdd.$3251.Metal4 7.79965e-06f
Cred_1124 \$I66.$764.Metal3 vdd.P0.nSD 0.0643262f
Cred_1125 \$I66.$764.Metal3 vdd.P1.GatPoly 2.26489e-05f
Cred_1126 \$I66.$764.Metal3 vdd.P10.pSD 0.00671015f
Cred_1127 \$I66.$764.Metal3 vdd.P11.pSD 0.00898946f
Cred_1128 \$I66.$764.Metal3 vdd.P13.pSD 0.0179885f
Cred_1129 \$I66.$764.Metal3 vdd.P15.pSD 0.0142583f
Cred_1130 \$I66.$764.Metal3 vdd.P2.GatPoly 2.66385e-05f
Cred_1131 \$I66.$764.Metal3 vout 0.0345575f
Cred_1132 \$I66.$764.Metal3 vout.$1002.Metal3 0.0151437f
Cred_1133 \$I66.$764.Metal3 vout.$1004.Metal3 0.00323993f
Cred_1134 \$I66.$764.Metal3 vout.$1038.Metal3 0.00130235f
Cred_1135 \$I66.$764.Metal3 vout.$1040.Metal3 0.00678663f
Cred_1136 \$I66.$764.Metal3 vout.$1299.Metal4 2.62915e-05f
Cred_1137 \$I66.$764.Metal3 vout.$1313.Metal4 0.0813499f
Cred_1138 \$I66.$764.Metal3 vout.$1331.Metal4 0.000485271f
Cred_1139 \$I66.$764.Metal3 vout.$1332.Metal4 0.00250317f
Cred_1140 \$I66.$764.Metal3 vout.$1371.Metal4 0.000262813f
Cred_1141 \$I66.$764.Metal3 vout.$1372.Metal4 0.0019543f
Cred_1142 \$I66.$764.Metal3 vout.$1373.Metal4 0.029819f
Cred_1143 \$I66.$764.Metal3 vout.$1383.Metal4 0.00212539f
Cred_1144 \$I66.$764.Metal3 vout.$159.Metal1 0.00200959f
Cred_1145 \$I66.$764.Metal3 vout.$160.Metal1 0.00939581f
Cred_1146 \$I66.$764.Metal3 vout.$161.Metal1 0.0184097f
Cred_1147 \$I66.$764.Metal3 vout.$162.Metal1 0.00389166f
Cred_1148 \$I66.$764.Metal3 vout.$209.Metal1 0.000392935f
Cred_1149 \$I66.$764.Metal3 vout.$210.Metal1 0.00196511f
Cred_1150 \$I66.$764.Metal3 vout.$211.Metal1 0.00393225f
Cred_1151 \$I66.$764.Metal3 vout.$212.Metal1 0.000786276f
Cred_1152 \$I66.$764.Metal3 vout.$590.Metal2 0.000401033f
Cred_1153 \$I66.$764.Metal3 vout.$592.Metal2 0.00203325f
Cred_1154 \$I66.$764.Metal3 vout.$594.Metal2 0.00297935f
Cred_1155 \$I66.$764.Metal3 vout.$596.Metal2 0.000599892f
Cred_1156 \$I66.$764.Metal3 vout.$610.Metal2 3.46846e-05f
Cred_1157 \$I66.$764.Metal3 vout.$612.Metal2 0.000178942f
Cred_1158 \$I66.$764.Metal3 vout.$614.Metal2 8.58611e-05f
Cred_1159 \$I66.$764.Metal3 vout.$616.Metal2 1.71684e-05f
Cred_1160 \$I66.$764.Metal3 vout.P0.GatPoly 0.000461189f
Cred_1161 \$I66.$764.Metal3 vout.P10.pSD 0.0062795f
Cred_1162 \$I66.$764.Metal3 vout.P12.pSD 0.00106332f
Cred_1163 \$I66.$764.Metal3 vout.P6.pSD 0.000531384f
Cred_1164 \$I66.$764.Metal3 vout.P8.pSD 0.00329821f
Cred_1165 \$I66.$764.Metal3 vref 0.072637f
Cred_1166 \$I66.$764.Metal3 vref.P0.GatPoly 0.00282071f
Cred_1167 \$I66.$764.Metal3 vref.P0.nSD 0.0134741f
Cred_1168 \$I66.$764.Metal3 vref.P0.pSD 0.0455828f
Cred_1169 \$I66.$764.Metal3 vss 0.0193358f
Cred_1170 \$I66.$764.Metal3 vss.$1211.Metal5 0.00705552f
Cred_1171 \$I66.$764.Metal3 vss.$1229.Metal5 0.00705552f
Cred_1172 \$I66.$764.Metal3 vss.$1281.Metal5 0.0270071f
Cred_1173 \$I66.$764.Metal3 vss.$1299.Metal5 0.0270071f
Cred_1174 \$I66.$767.Metal3 \$I67.$82.Metal2 0.000360419f
Cred_1175 \$I66.$767.Metal3 \$I67.P0.GatPoly 5.48173e-05f
Cred_1176 \$I66.$767.Metal3 \$I67.P3.GatPoly 2.64359e-06f
Cred_1177 \$I66.$767.Metal3 \$I67.P4.GatPoly 2.64359e-06f
Cred_1178 \$I66.$767.Metal3 \$I78 0.366046f
Cred_1179 \$I66.$767.Metal3 vss 0.0473103f
Cred_1180 \$I66.$767.Metal3 vdd.$2365.Metal1 0.000314772f
Cred_1181 \$I66.$767.Metal3 vdd.$2389.Metal1 2.10915e-05f
Cred_1182 \$I66.$767.Metal3 vdd.$2399.Metal1 0.00107816f
Cred_1183 \$I66.$767.Metal3 vdd.$2783.Metal2 0.00279f
Cred_1184 \$I66.$767.Metal3 vdd.$2785.Metal2 0.00662764f
Cred_1185 \$I66.$767.Metal3 vdd.$2789.Metal2 0.0146701f
Cred_1186 \$I66.$767.Metal3 vdd.$2793.Metal2 0.00439249f
Cred_1187 \$I66.$767.Metal3 vdd.$2795.Metal2 0.00498747f
Cred_1188 \$I66.$767.Metal3 vdd.$3015.Metal3 0.000330713f
Cred_1189 \$I66.$767.Metal3 vdd.$3019.Metal3 0.00166931f
Cred_1190 \$I66.$767.Metal3 vdd.$3021.Metal3 0.000929421f
Cred_1191 \$I66.$767.Metal3 vdd.$3025.Metal3 0.00287246f
Cred_1192 \$I66.$767.Metal3 vdd.$3029.Metal3 0.00102946f
Cred_1193 \$I66.$767.Metal3 vdd.$3251.Metal4 3.89939e-06f
Cred_1194 \$I66.$767.Metal3 vdd.$3257.Metal4 1.09587e-05f
Cred_1195 \$I66.$767.Metal3 vdd.$3261.Metal4 6.03387e-06f
Cred_1196 \$I66.$767.Metal3 vdd.P0.nSD 0.0693713f
Cred_1197 \$I66.$767.Metal3 vdd.P1.GatPoly 1.40006e-05f
Cred_1198 \$I66.$767.Metal3 vdd.P15.pSD 0.0134714f
Cred_1199 \$I66.$767.Metal3 vdd.P17.pSD 0.0247497f
Cred_1200 \$I66.$767.Metal3 vdd.P19.pSD 0.0106669f
Cred_1201 \$I66.$767.Metal3 vdd.P2.GatPoly 4.79551e-05f
Cred_1202 \$I66.$767.Metal3 vout 0.0877401f
Cred_1203 \$I66.$767.Metal3 vout.$1002.Metal3 0.00283351f
Cred_1204 \$I66.$767.Metal3 vout.$1004.Metal3 0.0149836f
Cred_1205 \$I66.$767.Metal3 vout.$1006.Metal3 0.0115397f
Cred_1206 \$I66.$767.Metal3 vout.$1008.Metal3 0.00242932f
Cred_1207 \$I66.$767.Metal3 vout.$1299.Metal4 0.000144442f
Cred_1208 \$I66.$767.Metal3 vout.$1313.Metal4 0.150769f
Cred_1209 \$I66.$767.Metal3 vout.$1373.Metal4 0.0850625f
Cred_1210 \$I66.$767.Metal3 vout.$161.Metal1 0.00387418f
Cred_1211 \$I66.$767.Metal3 vout.$162.Metal1 0.0194101f
Cred_1212 \$I66.$767.Metal3 vout.$163.Metal1 0.014567f
Cred_1213 \$I66.$767.Metal3 vout.$164.Metal1 0.00291799f
Cred_1214 \$I66.$767.Metal3 vout.$211.Metal1 0.000786276f
Cred_1215 \$I66.$767.Metal3 vout.$212.Metal1 0.00393225f
Cred_1216 \$I66.$767.Metal3 vout.$213.Metal1 0.00294843f
Cred_1217 \$I66.$767.Metal3 vout.$214.Metal1 0.000589555f
Cred_1218 \$I66.$767.Metal3 vout.$594.Metal2 0.000591881f
Cred_1219 \$I66.$767.Metal3 vout.$596.Metal2 0.00297608f
Cred_1220 \$I66.$767.Metal3 vout.$598.Metal2 0.0022375f
Cred_1221 \$I66.$767.Metal3 vout.$600.Metal2 0.000449802f
Cred_1222 \$I66.$767.Metal3 vout.$614.Metal2 1.71684e-05f
Cred_1223 \$I66.$767.Metal3 vout.$616.Metal2 8.58611e-05f
Cred_1224 \$I66.$767.Metal3 vout.$618.Metal2 6.43791e-05f
Cred_1225 \$I66.$767.Metal3 vout.$620.Metal2 1.2873e-05f
Cred_1226 \$I66.$767.Metal3 vout.P0.GatPoly 0.00258483f
Cred_1227 \$I66.$767.Metal3 vout.P10.pSD 0.00106332f
Cred_1228 \$I66.$767.Metal3 vout.P12.pSD 0.00531777f
Cred_1229 \$I66.$767.Metal3 vout.P14.pSD 0.00398729f
Cred_1230 \$I66.$767.Metal3 vout.P16.pSD 0.000797282f
Cred_1231 \$I66.$767.Metal3 vref 0.0129834f
Cred_1232 \$I66.$767.Metal3 vref.P0.GatPoly 0.000494048f
Cred_1233 \$I66.$767.Metal3 vref.P0.nSD 0.000298796f
Cred_1234 \$I66.$767.Metal3 vref.P0.pSD 0.000523711f
Cred_1235 \$I66.$771.Metal3 \$I78 0.471995f
Cred_1236 \$I66.$771.Metal3 vss 0.0801191f
Cred_1237 \$I66.$771.Metal3 vdd.$2365.Metal1 0.000485969f
Cred_1238 \$I66.$771.Metal3 vdd.$2389.Metal1 2.79794e-06f
Cred_1239 \$I66.$771.Metal3 vdd.$2394.Metal1 2.13358e-05f
Cred_1240 \$I66.$771.Metal3 vdd.$2399.Metal1 0.0317955f
Cred_1241 \$I66.$771.Metal3 vdd.$2789.Metal2 0.00194464f
Cred_1242 \$I66.$771.Metal3 vdd.$2793.Metal2 0.00410317f
Cred_1243 \$I66.$771.Metal3 vdd.$2795.Metal2 0.00803775f
Cred_1244 \$I66.$771.Metal3 vdd.$2799.Metal2 0.0169246f
Cred_1245 \$I66.$771.Metal3 vdd.$2803.Metal2 0.00409692f
Cred_1246 \$I66.$771.Metal3 vdd.$2805.Metal2 0.00294246f
Cred_1247 \$I66.$771.Metal3 vdd.$2807.Metal2 0.00383226f
Cred_1248 \$I66.$771.Metal3 vdd.$3025.Metal3 0.000984469f
Cred_1249 \$I66.$771.Metal3 vdd.$3029.Metal3 0.00206535f
Cred_1250 \$I66.$771.Metal3 vdd.$3031.Metal3 0.000897913f
Cred_1251 \$I66.$771.Metal3 vdd.$3035.Metal3 0.00353831f
Cred_1252 \$I66.$771.Metal3 vdd.$3039.Metal3 0.000802863f
Cred_1253 \$I66.$771.Metal3 vdd.$3261.Metal4 6.03387e-06f
Cred_1254 \$I66.$771.Metal3 vdd.$3267.Metal4 1.05872e-05f
Cred_1255 \$I66.$771.Metal3 vdd.$3271.Metal4 9.46644e-06f
Cred_1256 \$I66.$771.Metal3 vdd.P0.nSD 0.384013f
Cred_1257 \$I66.$771.Metal3 vdd.P1.GatPoly 2.16152e-05f
Cred_1258 \$I66.$771.Metal3 vdd.P17.pSD 0.00313949f
Cred_1259 \$I66.$771.Metal3 vdd.P19.pSD 0.0169816f
Cred_1260 \$I66.$771.Metal3 vdd.P2.GatPoly 0.0144196f
Cred_1261 \$I66.$771.Metal3 vdd.P21.pSD 0.0284567f
Cred_1262 \$I66.$771.Metal3 vdd.P23.pSD 0.00719403f
Cred_1263 \$I66.$771.Metal3 vdd.P25.pSD 0.00334619f
Cred_1264 \$I66.$771.Metal3 vout 0.080547f
Cred_1265 \$I66.$771.Metal3 vout.$1006.Metal3 0.00667896f
Cred_1266 \$I66.$771.Metal3 vout.$1008.Metal3 0.0157932f
Cred_1267 \$I66.$771.Metal3 vout.$1010.Metal3 0.0178636f
Cred_1268 \$I66.$771.Metal3 vout.$1299.Metal4 9.69922e-07f
Cred_1269 \$I66.$771.Metal3 vout.$1313.Metal4 0.171013f
Cred_1270 \$I66.$771.Metal3 vout.$1373.Metal4 0.0818404f
Cred_1271 \$I66.$771.Metal3 vout.$163.Metal1 0.00872839f
Cred_1272 \$I66.$771.Metal3 vout.$164.Metal1 0.0203825f
Cred_1273 \$I66.$771.Metal3 vout.$165.Metal1 0.0221646f
Cred_1274 \$I66.$771.Metal3 vout.$213.Metal1 0.00176879f
Cred_1275 \$I66.$771.Metal3 vout.$214.Metal1 0.00412871f
Cred_1276 \$I66.$771.Metal3 vout.$215.Metal1 0.00471644f
Cred_1277 \$I66.$771.Metal3 vout.$598.Metal2 0.00133749f
Cred_1278 \$I66.$771.Metal3 vout.$600.Metal2 0.00312597f
Cred_1279 \$I66.$771.Metal3 vout.$602.Metal2 0.00356761f
Cred_1280 \$I66.$771.Metal3 vout.$618.Metal2 3.86218e-05f
Cred_1281 \$I66.$771.Metal3 vout.$620.Metal2 9.01508e-05f
Cred_1282 \$I66.$771.Metal3 vout.$622.Metal2 0.000102984f
Cred_1283 \$I66.$771.Metal3 vout.P0.GatPoly 1.26351e-05f
Cred_1284 \$I66.$771.Metal3 vout.P14.pSD 0.00239202f
Cred_1285 \$I66.$771.Metal3 vout.P16.pSD 0.00558345f
Cred_1286 \$I66.$771.Metal3 vout.P18.pSD 0.00733956f
Cred_1287 \$I66.$771.Metal3 vref 0.0219524f
Cred_1288 \$I66.$771.Metal3 vref.P0.GatPoly 0.000683295f
Cred_1289 \$I66.$771.Metal3 vref.P0.nSD 0.000413251f
Cred_1290 \$I66.$771.Metal3 vref.P0.pSD 0.000724321f
Cred_1291 \$I66.$771.Metal3 vss 0.0122664f
Cred_1292 \$I66.$771.Metal3 vss.$1211.Metal5 0.00447594f
Cred_1293 \$I66.$771.Metal3 vss.$1229.Metal5 0.00447594f
Cred_1294 \$I66.$771.Metal3 vss.$1281.Metal5 0.017133f
Cred_1295 \$I66.$771.Metal3 vss.$1299.Metal5 0.017133f
Cred_1296 \$I66.P0.GatPoly \$I67.$82.Metal2 0.0153908f
Cred_1297 \$I66.P0.GatPoly \$I67.P0.GatPoly 2.96197e-06f
Cred_1298 \$I66.P0.GatPoly \$I67.P1.GatPoly 7.55266e-05f
Cred_1299 \$I66.P0.GatPoly \$I67.P2.GatPoly 7.51279e-05f
Cred_1300 \$I66.P0.GatPoly \$I67.P3.GatPoly 2.69737e-07f
Cred_1301 \$I66.P0.GatPoly \$I67.P4.GatPoly 2.69737e-07f
Cred_1302 \$I66.P0.GatPoly \$I78 0.000552192f
Cred_1303 \$I66.P0.GatPoly vss 0.13074f
Cred_1304 \$I66.P0.GatPoly vdd.$2365.Metal1 2.84531e-05f
Cred_1305 \$I66.P0.GatPoly vdd.$2399.Metal1 2.84e-05f
Cred_1306 \$I66.P0.GatPoly vdd.P0.nSD 0.00341921f
Cred_1307 \$I66.P0.GatPoly vdd.P1.GatPoly 1.26555e-06f
Cred_1308 \$I66.P0.GatPoly vdd.P2.GatPoly 1.26319e-06f
Cred_1309 \$I66.P0.GatPoly vout 0.00691428f
Cred_1310 \$I66.P0.GatPoly vout.$1040.Metal3 2.36691e-05f
Cred_1311 \$I66.P0.GatPoly vout.$1299.Metal4 0.000111874f
Cred_1312 \$I66.P0.GatPoly vout.$1313.Metal4 0.000155632f
Cred_1313 \$I66.P0.GatPoly vout.$1332.Metal4 2.819e-06f
Cred_1314 \$I66.P0.GatPoly vout.$160.Metal1 2.87121e-08f
Cred_1315 \$I66.P0.GatPoly vout.$592.Metal2 2.40948e-06f
Cred_1316 \$I66.P0.GatPoly vout.$612.Metal2 4.74435e-07f
Cred_1317 \$I66.P0.GatPoly vout.P0.GatPoly 0.00938758f
Cred_1318 \$I66.P0.GatPoly vref 0.00997919f
Cred_1319 \$I66.P0.GatPoly vref.P0.GatPoly 0.00732224f
Cred_1320 \$I66.P0.GatPoly vref.P0.nSD 0.000666598f
Cred_1321 \$I66.P0.GatPoly vref.P0.pSD 0.00127918f
Cred_1322 \$I66.P0.GatPoly vss 0.000651593f
Cred_1323 \$I66.P0.GatPoly vss.$1211.Metal5 0.000421566f
Cred_1324 \$I66.P0.GatPoly vss.$1229.Metal5 0.000421566f
Cred_1325 \$I66.P0.GatPoly vss.$1281.Metal5 0.00161367f
Cred_1326 \$I66.P0.GatPoly vss.$1299.Metal5 0.00161367f
Cred_1327 \$I66.P1.GatPoly \$I67.$82.Metal2 3.70414e-05f
Cred_1328 \$I66.P1.GatPoly \$I78 0.0196404f
Cred_1329 \$I66.P1.GatPoly vss 0.000259168f
Cred_1330 \$I66.P1.GatPoly vdd.$2365.Metal1 0.00115632f
Cred_1331 \$I66.P1.GatPoly vdd.$2367.Metal1 0.000498601f
Cred_1332 \$I66.P1.GatPoly vdd.$2370.Metal1 0.00100606f
Cred_1333 \$I66.P1.GatPoly vdd.$2399.Metal1 1.05309e-05f
Cred_1334 \$I66.P1.GatPoly vdd.$2747.Metal2 3.39725e-06f
Cred_1335 \$I66.P1.GatPoly vdd.$2749.Metal2 0.013492f
Cred_1336 \$I66.P1.GatPoly vdd.$2751.Metal2 0.00875954f
Cred_1337 \$I66.P1.GatPoly vdd.$2755.Metal2 9.48183e-06f
Cred_1338 \$I66.P1.GatPoly vdd.$2759.Metal2 1.53064e-06f
Cred_1339 \$I66.P1.GatPoly vdd.$2761.Metal2 6.33369e-07f
Cred_1340 \$I66.P1.GatPoly vdd.$2983.Metal3 0.00130443f
Cred_1341 \$I66.P1.GatPoly vdd.$2987.Metal3 0.00130605f
Cred_1342 \$I66.P1.GatPoly vdd.$2991.Metal3 3.97553e-07f
Cred_1343 \$I66.P1.GatPoly vdd.$2993.Metal3 4.58645e-07f
Cred_1344 \$I66.P1.GatPoly vdd.$3219.Metal4 0.00262811f
Cred_1345 \$I66.P1.GatPoly vdd.$3223.Metal4 4.68749e-09f
Cred_1346 \$I66.P1.GatPoly vdd.P0.nSD 0.0120373f
Cred_1347 \$I66.P1.GatPoly vdd.P0.pSD 2.96636e-06f
Cred_1348 \$I66.P1.GatPoly vdd.P1.GatPoly 0.155943f
Cred_1349 \$I66.P1.GatPoly vdd.P1.pSD 0.0279733f
Cred_1350 \$I66.P1.GatPoly vdd.P2.GatPoly 4.68399e-07f
Cred_1351 \$I66.P1.GatPoly vdd.P3.pSD 1.59408e-05f
Cred_1352 \$I66.P1.GatPoly vdd.P5.pSD 3.34773e-06f
Cred_1353 \$I66.P1.GatPoly vout.$1032.Metal3 1.35989e-05f
Cred_1354 \$I66.P1.GatPoly vout.$1034.Metal3 5.90284e-06f
Cred_1355 \$I66.P1.GatPoly vout.$1112.Metal3 6.02593e-09f
Cred_1356 \$I66.P1.GatPoly vout.$1152.Metal3 2.74394e-07f
Cred_1357 \$I66.P1.GatPoly vout.$1328.Metal4 4.68855e-06f
Cred_1358 \$I66.P1.GatPoly vout.$1329.Metal4 2.01967e-06f
Cred_1359 \$I66.P1.GatPoly vout.$1368.Metal4 1.31635e-07f
Cred_1360 \$I66.P1.GatPoly vout.$1369.Metal4 1.07671e-06f
Cred_1361 \$I66.P1.GatPoly vout.$1408.Metal4 1.69451e-06f
Cred_1362 \$I66.P1.GatPoly vout.$156.Metal1 0.00137411f
Cred_1363 \$I66.P1.GatPoly vout.$157.Metal1 6.88866e-06f
Cred_1364 \$I66.P1.GatPoly vout.$206.Metal1 0.00548449f
Cred_1365 \$I66.P1.GatPoly vout.$207.Metal1 2.54272e-06f
Cred_1366 \$I66.P1.GatPoly vout.$226.Metal1 0.00600163f
Cred_1367 \$I66.P1.GatPoly vout.$266.Metal1 0.00598438f
Cred_1368 \$I66.P1.GatPoly vout.$286.Metal1 0.0214618f
Cred_1369 \$I66.P1.GatPoly vout.$326.Metal1 0.00600124f
Cred_1370 \$I66.P1.GatPoly vout.$346.Metal1 0.00792118f
Cred_1371 \$I66.P1.GatPoly vout.$396.Metal1 0.00871131f
Cred_1372 \$I66.P1.GatPoly vout.$584.Metal2 2.27738e-05f
Cred_1373 \$I66.P1.GatPoly vout.$586.Metal2 1.70527e-06f
Cred_1374 \$I66.P1.GatPoly vout.$604.Metal2 3.22636e-05f
Cred_1375 \$I66.P1.GatPoly vout.$606.Metal2 1.7384e-07f
Cred_1376 \$I66.P1.GatPoly vout.$644.Metal2 1.8244e-05f
Cred_1377 \$I66.P1.GatPoly vout.$664.Metal2 3.60091e-05f
Cred_1378 \$I66.P1.GatPoly vout.$684.Metal2 1.06054e-05f
Cred_1379 \$I66.P1.GatPoly vout.$704.Metal2 3.55883e-05f
Cred_1380 \$I66.P1.GatPoly vout.$724.Metal2 1.93602e-05f
Cred_1381 \$I66.P1.GatPoly vout.$764.Metal2 8.46505e-05f
Cred_1382 \$I66.P1.GatPoly vout.$784.Metal2 8.72673e-05f
Cred_1383 \$I66.P1.GatPoly vout.P0.pSD 0.000200904f
Cred_1384 \$I66.P1.GatPoly vout.P2.pSD 3.00352e-06f
Cred_1385 \$I66.P1.GatPoly vss 0.00261926f
Cred_1386 \$I66.P1.GatPoly vss.$1211.Metal5 0.000281742f
Cred_1387 \$I66.P1.GatPoly vss.$1229.Metal5 0.000281742f
Cred_1388 \$I66.P1.GatPoly vss.$1281.Metal5 0.00107845f
Cred_1389 \$I66.P1.GatPoly vss.$1299.Metal5 0.00107845f
Cred_1390 \$I66.P10.GatPoly \$I67.$82.Metal2 0.0125251f
Cred_1391 \$I66.P10.GatPoly \$I67.P1.GatPoly 0.144146f
Cred_1392 \$I66.P10.GatPoly \$I67.P2.GatPoly 8.57938e-05f
Cred_1393 \$I66.P10.GatPoly \$I78 0.0191987f
Cred_1394 \$I66.P10.GatPoly vss 0.000166182f
Cred_1395 \$I66.P10.GatPoly vdd.$2365.Metal1 6.51611e-06f
Cred_1396 \$I66.P10.GatPoly vdd.$2379.Metal1 0.00161941f
Cred_1397 \$I66.P10.GatPoly vdd.$2382.Metal1 0.000802589f
Cred_1398 \$I66.P10.GatPoly vdd.$2399.Metal1 4.43946e-06f
Cred_1399 \$I66.P10.GatPoly vdd.$2769.Metal2 2.20595e-06f
Cred_1400 \$I66.P10.GatPoly vdd.$2771.Metal2 1.04825e-06f
Cred_1401 \$I66.P10.GatPoly vdd.$2773.Metal2 0.00829738f
Cred_1402 \$I66.P10.GatPoly vdd.$2775.Metal2 0.0149722f
Cred_1403 \$I66.P10.GatPoly vdd.$3003.Metal3 4.42589e-07f
Cred_1404 \$I66.P10.GatPoly vdd.$3007.Metal3 0.0103993f
Cred_1405 \$I66.P10.GatPoly vdd.$3011.Metal3 4.29621e-07f
Cred_1406 \$I66.P10.GatPoly vdd.$3239.Metal4 2.5941e-09f
Cred_1407 \$I66.P10.GatPoly vdd.$3243.Metal4 5.06559e-09f
Cred_1408 \$I66.P10.GatPoly vdd.P0.nSD 0.000656404f
Cred_1409 \$I66.P10.GatPoly vdd.P1.GatPoly 2.89827e-07f
Cred_1410 \$I66.P10.GatPoly vdd.P10.pSD 4.46579e-06f
Cred_1411 \$I66.P10.GatPoly vdd.P11.pSD 0.0280112f
Cred_1412 \$I66.P10.GatPoly vdd.P2.GatPoly 1.9746e-07f
Cred_1413 \$I66.P10.GatPoly vout.$1038.Metal3 8.6675e-07f
Cred_1414 \$I66.P10.GatPoly vout.$1040.Metal3 4.57025e-06f
Cred_1415 \$I66.P10.GatPoly vout.$1100.Metal3 1.02546e-07f
Cred_1416 \$I66.P10.GatPoly vout.$1160.Metal3 2.60128e-07f
Cred_1417 \$I66.P10.GatPoly vout.$1331.Metal4 3.22962e-07f
Cred_1418 \$I66.P10.GatPoly vout.$1332.Metal4 1.66794e-06f
Cred_1419 \$I66.P10.GatPoly vout.$1371.Metal4 1.74909e-07f
Cred_1420 \$I66.P10.GatPoly vout.$1372.Metal4 0.0258608f
Cred_1421 \$I66.P10.GatPoly vout.$159.Metal1 1.33744e-06f
Cred_1422 \$I66.P10.GatPoly vout.$160.Metal1 0.00146709f
Cred_1423 \$I66.P10.GatPoly vout.$209.Metal1 2.61509e-07f
Cred_1424 \$I66.P10.GatPoly vout.$210.Metal1 0.00539049f
Cred_1425 \$I66.P10.GatPoly vout.$230.Metal1 0.00600163f
Cred_1426 \$I66.P10.GatPoly vout.$270.Metal1 0.0059683f
Cred_1427 \$I66.P10.GatPoly vout.$290.Metal1 0.00596902f
Cred_1428 \$I66.P10.GatPoly vout.$330.Metal1 0.00600124f
Cred_1429 \$I66.P10.GatPoly vout.$350.Metal1 0.00792118f
Cred_1430 \$I66.P10.GatPoly vout.$400.Metal1 0.00871131f
Cred_1431 \$I66.P10.GatPoly vout.$590.Metal2 2.66899e-07f
Cred_1432 \$I66.P10.GatPoly vout.$592.Metal2 1.70968e-05f
Cred_1433 \$I66.P10.GatPoly vout.$610.Metal2 2.30836e-08f
Cred_1434 \$I66.P10.GatPoly vout.$612.Metal2 3.00301e-05f
Cred_1435 \$I66.P10.GatPoly vout.$652.Metal2 1.8244e-05f
Cred_1436 \$I66.P10.GatPoly vout.$672.Metal2 4.1125e-05f
Cred_1437 \$I66.P10.GatPoly vout.$712.Metal2 4.07043e-05f
Cred_1438 \$I66.P10.GatPoly vout.$732.Metal2 1.93601e-05f
Cred_1439 \$I66.P10.GatPoly vout.$772.Metal2 8.46505e-05f
Cred_1440 \$I66.P10.GatPoly vout.$792.Metal2 8.72673e-05f
Cred_1441 \$I66.P10.GatPoly vout.P6.pSD 3.53651e-07f
Cred_1442 \$I66.P10.GatPoly vout.P8.pSD 0.000193366f
Cred_1443 \$I66.P10.GatPoly vref 9.03332e-06f
Cred_1444 \$I66.P10.GatPoly vref.P0.GatPoly 3.52671e-07f
Cred_1445 \$I66.P10.GatPoly vref.P0.nSD 1.9304e-06f
Cred_1446 \$I66.P10.GatPoly vref.P0.pSD 7.12381e-06f
Cred_1447 \$I66.P10.GatPoly vss 0.000480689f
Cred_1448 \$I66.P10.GatPoly vss.$1211.Metal5 0.000175401f
Cred_1449 \$I66.P10.GatPoly vss.$1229.Metal5 0.000175401f
Cred_1450 \$I66.P10.GatPoly vss.$1281.Metal5 0.000671399f
Cred_1451 \$I66.P10.GatPoly vss.$1299.Metal5 0.000671399f
Cred_1452 \$I66.P11.GatPoly \$I67.$82.Metal2 0.0123432f
Cred_1453 \$I66.P11.GatPoly \$I67.P0.GatPoly 1.55284e-06f
Cred_1454 \$I66.P11.GatPoly \$I67.P1.GatPoly 8.44169e-05f
Cred_1455 \$I66.P11.GatPoly \$I67.P2.GatPoly 0.144143f
Cred_1456 \$I66.P11.GatPoly \$I67.P3.GatPoly 1.41412e-07f
Cred_1457 \$I66.P11.GatPoly \$I67.P4.GatPoly 1.41412e-07f
Cred_1458 \$I66.P11.GatPoly \$I78 0.0191274f
Cred_1459 \$I66.P11.GatPoly vss 0.000232828f
Cred_1460 \$I66.P11.GatPoly vdd.$2365.Metal1 3.93814e-06f
Cred_1461 \$I66.P11.GatPoly vdd.$2382.Metal1 0.000802589f
Cred_1462 \$I66.P11.GatPoly vdd.$2385.Metal1 0.00161941f
Cred_1463 \$I66.P11.GatPoly vdd.$2399.Metal1 5.76096e-06f
Cred_1464 \$I66.P11.GatPoly vdd.$2779.Metal2 0.014969f
Cred_1465 \$I66.P11.GatPoly vdd.$2781.Metal2 0.00829634f
Cred_1466 \$I66.P11.GatPoly vdd.$3015.Metal3 0.010398f
Cred_1467 \$I66.P11.GatPoly vdd.P0.nSD 0.000582229f
Cred_1468 \$I66.P11.GatPoly vdd.P1.GatPoly 1.75163e-07f
Cred_1469 \$I66.P11.GatPoly vdd.P13.pSD 0.0280052f
Cred_1470 \$I66.P11.GatPoly vdd.P2.GatPoly 2.56239e-07f
Cred_1471 \$I66.P11.GatPoly vout.$1002.Metal3 2.01506e-08f
Cred_1472 \$I66.P11.GatPoly vout.$1162.Metal3 2.60128e-07f
Cred_1473 \$I66.P11.GatPoly vout.$1313.Metal4 4.03907e-10f
Cred_1474 \$I66.P11.GatPoly vout.$1373.Metal4 0.00266173f
Cred_1475 \$I66.P11.GatPoly vout.$1383.Metal4 0.0214399f
Cred_1476 \$I66.P11.GatPoly vout.$161.Metal1 0.00145039f
Cred_1477 \$I66.P11.GatPoly vout.$211.Metal1 0.00736249f
Cred_1478 \$I66.P11.GatPoly vout.$251.Metal1 0.00798104f
Cred_1479 \$I66.P11.GatPoly vout.$291.Metal1 0.00792499f
Cred_1480 \$I66.P11.GatPoly vout.$331.Metal1 0.00600124f
Cred_1481 \$I66.P11.GatPoly vout.$351.Metal1 0.00792118f
Cred_1482 \$I66.P11.GatPoly vout.$401.Metal1 0.00871131f
Cred_1483 \$I66.P11.GatPoly vout.$594.Metal2 1.57423e-05f
Cred_1484 \$I66.P11.GatPoly vout.$614.Metal2 2.808e-05f
Cred_1485 \$I66.P11.GatPoly vout.$634.Metal2 7.75443e-06f
Cred_1486 \$I66.P11.GatPoly vout.$654.Metal2 3.9777e-05f
Cred_1487 \$I66.P11.GatPoly vout.$674.Metal2 2.46515e-05f
Cred_1488 \$I66.P11.GatPoly vout.$694.Metal2 3.14972e-05f
Cred_1489 \$I66.P11.GatPoly vout.$714.Metal2 3.55883e-05f
Cred_1490 \$I66.P11.GatPoly vout.$734.Metal2 1.93601e-05f
Cred_1491 \$I66.P11.GatPoly vout.$774.Metal2 8.46505e-05f
Cred_1492 \$I66.P11.GatPoly vout.$794.Metal2 8.72673e-05f
Cred_1493 \$I66.P11.GatPoly vout.P10.pSD 0.000213563f
Cred_1494 \$I66.P11.GatPoly vss 0.000479522f
Cred_1495 \$I66.P11.GatPoly vss.$1211.Metal5 0.000174975f
Cred_1496 \$I66.P11.GatPoly vss.$1229.Metal5 0.000174975f
Cred_1497 \$I66.P11.GatPoly vss.$1281.Metal5 0.000669769f
Cred_1498 \$I66.P11.GatPoly vss.$1299.Metal5 0.000669769f
Cred_1499 \$I66.P12.GatPoly \$I67.$82.Metal2 1.82573e-05f
Cred_1500 \$I66.P12.GatPoly \$I67.P0.GatPoly 2.77681e-06f
Cred_1501 \$I66.P12.GatPoly \$I67.P3.GatPoly 1.33913e-07f
Cred_1502 \$I66.P12.GatPoly \$I67.P4.GatPoly 1.33913e-07f
Cred_1503 \$I66.P12.GatPoly \$I78 0.0192966f
Cred_1504 \$I66.P12.GatPoly vss 0.00023874f
Cred_1505 \$I66.P12.GatPoly vdd.$2365.Metal1 3.55366e-06f
Cred_1506 \$I66.P12.GatPoly vdd.$2385.Metal1 0.00230161f
Cred_1507 \$I66.P12.GatPoly vdd.$2399.Metal1 6.72593e-06f
Cred_1508 \$I66.P12.GatPoly vdd.$2783.Metal2 0.00784434f
Cred_1509 \$I66.P12.GatPoly vdd.$2785.Metal2 0.0144969f
Cred_1510 \$I66.P12.GatPoly vdd.$3015.Metal3 0.00521911f
Cred_1511 \$I66.P12.GatPoly vdd.$3019.Metal3 0.00521926f
Cred_1512 \$I66.P12.GatPoly vdd.$3251.Metal4 6.15378e-05f
Cred_1513 \$I66.P12.GatPoly vdd.P0.nSD 0.000591489f
Cred_1514 \$I66.P12.GatPoly vdd.P1.GatPoly 1.58061e-07f
Cred_1515 \$I66.P12.GatPoly vdd.P15.pSD 0.0280589f
Cred_1516 \$I66.P12.GatPoly vdd.P2.GatPoly 2.99159e-07f
Cred_1517 \$I66.P12.GatPoly vout 6.50762e-05f
Cred_1518 \$I66.P12.GatPoly vout.$1002.Metal3 1.27662e-06f
Cred_1519 \$I66.P12.GatPoly vout.$1004.Metal3 7.18755e-07f
Cred_1520 \$I66.P12.GatPoly vout.$1162.Metal3 2.60128e-07f
Cred_1521 \$I66.P12.GatPoly vout.$1299.Metal4 6.52388e-09f
Cred_1522 \$I66.P12.GatPoly vout.$1313.Metal4 0.000114706f
Cred_1523 \$I66.P12.GatPoly vout.$1373.Metal4 0.000166879f
Cred_1524 \$I66.P12.GatPoly vout.$1383.Metal4 0.0227597f
Cred_1525 \$I66.P12.GatPoly vout.$161.Metal1 0.0015324f
Cred_1526 \$I66.P12.GatPoly vout.$162.Metal1 8.63337e-07f
Cred_1527 \$I66.P12.GatPoly vout.$211.Metal1 0.00736284f
Cred_1528 \$I66.P12.GatPoly vout.$212.Metal1 1.7443e-07f
Cred_1529 \$I66.P12.GatPoly vout.$251.Metal1 0.00798905f
Cred_1530 \$I66.P12.GatPoly vout.$291.Metal1 0.00794859f
Cred_1531 \$I66.P12.GatPoly vout.$331.Metal1 0.00600124f
Cred_1532 \$I66.P12.GatPoly vout.$351.Metal1 0.00792118f
Cred_1533 \$I66.P12.GatPoly vout.$401.Metal1 0.00871131f
Cred_1534 \$I66.P12.GatPoly vout.$594.Metal2 1.59605e-05f
Cred_1535 \$I66.P12.GatPoly vout.$596.Metal2 1.33082e-07f
Cred_1536 \$I66.P12.GatPoly vout.$614.Metal2 2.80876e-05f
Cred_1537 \$I66.P12.GatPoly vout.$616.Metal2 3.80869e-09f
Cred_1538 \$I66.P12.GatPoly vout.$634.Metal2 7.75443e-06f
Cred_1539 \$I66.P12.GatPoly vout.$654.Metal2 3.9777e-05f
Cred_1540 \$I66.P12.GatPoly vout.$674.Metal2 2.47121e-05f
Cred_1541 \$I66.P12.GatPoly vout.$694.Metal2 3.17513e-05f
Cred_1542 \$I66.P12.GatPoly vout.$714.Metal2 3.55883e-05f
Cred_1543 \$I66.P12.GatPoly vout.$734.Metal2 1.93601e-05f
Cred_1544 \$I66.P12.GatPoly vout.$774.Metal2 8.46505e-05f
Cred_1545 \$I66.P12.GatPoly vout.$794.Metal2 8.72673e-05f
Cred_1546 \$I66.P12.GatPoly vout.P0.GatPoly 1.11317e-07f
Cred_1547 \$I66.P12.GatPoly vout.P10.pSD 0.000214124f
Cred_1548 \$I66.P12.GatPoly vout.P12.pSD 2.35889e-07f
Cred_1549 \$I66.P12.GatPoly vref 9.41264e-07f
Cred_1550 \$I66.P12.GatPoly vref.P0.GatPoly 3.58173e-08f
Cred_1551 \$I66.P12.GatPoly vref.P0.nSD 2.1662e-08f
Cred_1552 \$I66.P12.GatPoly vref.P0.pSD 3.79678e-08f
Cred_1553 \$I66.P13.GatPoly \$I67.$82.Metal2 7.99564e-08f
Cred_1554 \$I66.P13.GatPoly \$I67.P0.GatPoly 1.21608e-08f
Cred_1555 \$I66.P13.GatPoly \$I67.P3.GatPoly 5.86462e-10f
Cred_1556 \$I66.P13.GatPoly \$I67.P4.GatPoly 5.86462e-10f
Cred_1557 \$I66.P13.GatPoly \$I78 0.0192905f
Cred_1558 \$I66.P13.GatPoly vss 0.000186762f
Cred_1559 \$I66.P13.GatPoly vdd.$2365.Metal1 3.2593e-06f
Cred_1560 \$I66.P13.GatPoly vdd.$2385.Metal1 0.0010733f
Cred_1561 \$I66.P13.GatPoly vdd.$2387.Metal1 0.00107328f
Cred_1562 \$I66.P13.GatPoly vdd.$2399.Metal1 7.87713e-06f
Cred_1563 \$I66.P13.GatPoly vdd.$2783.Metal2 0.00531603f
Cred_1564 \$I66.P13.GatPoly vdd.$2785.Metal2 0.0177376f
Cred_1565 \$I66.P13.GatPoly vdd.$3015.Metal3 7.33664e-08f
Cred_1566 \$I66.P13.GatPoly vdd.$3019.Metal3 0.0106304f
Cred_1567 \$I66.P13.GatPoly vdd.$3251.Metal4 8.65052e-10f
Cred_1568 \$I66.P13.GatPoly vdd.P0.nSD 0.000616497f
Cred_1569 \$I66.P13.GatPoly vdd.P1.GatPoly 1.44969e-07f
Cred_1570 \$I66.P13.GatPoly vdd.P15.pSD 0.0280667f
Cred_1571 \$I66.P13.GatPoly vdd.P2.GatPoly 3.50363e-07f
Cred_1572 \$I66.P13.GatPoly vout 7.60554e-05f
Cred_1573 \$I66.P13.GatPoly vout.$1002.Metal3 6.28595e-07f
Cred_1574 \$I66.P13.GatPoly vout.$1004.Metal3 1.45782e-06f
Cred_1575 \$I66.P13.GatPoly vout.$1044.Metal3 3.66949e-08f
Cred_1576 \$I66.P13.GatPoly vout.$1164.Metal3 2.60128e-07f
Cred_1577 \$I66.P13.GatPoly vout.$1299.Metal4 3.2062e-07f
Cred_1578 \$I66.P13.GatPoly vout.$1313.Metal4 0.000117452f
Cred_1579 \$I66.P13.GatPoly vout.$1373.Metal4 0.000166165f
Cred_1580 \$I66.P13.GatPoly vout.$1394.Metal4 0.0227236f
Cred_1581 \$I66.P13.GatPoly vout.$161.Metal1 8.59458e-07f
Cred_1582 \$I66.P13.GatPoly vout.$162.Metal1 0.00153673f
Cred_1583 \$I66.P13.GatPoly vout.$211.Metal1 1.7443e-07f
Cred_1584 \$I66.P13.GatPoly vout.$212.Metal1 0.00538953f
Cred_1585 \$I66.P13.GatPoly vout.$232.Metal1 0.00600163f
Cred_1586 \$I66.P13.GatPoly vout.$272.Metal1 0.00598017f
Cred_1587 \$I66.P13.GatPoly vout.$292.Metal1 0.00598058f
Cred_1588 \$I66.P13.GatPoly vout.$332.Metal1 0.00600124f
Cred_1589 \$I66.P13.GatPoly vout.$352.Metal1 0.00792118f
Cred_1590 \$I66.P13.GatPoly vout.$402.Metal1 0.00871131f
Cred_1591 \$I66.P13.GatPoly vout.$594.Metal2 1.31304e-07f
Cred_1592 \$I66.P13.GatPoly vout.$596.Metal2 1.60085e-05f
Cred_1593 \$I66.P13.GatPoly vout.$614.Metal2 3.80869e-09f
Cred_1594 \$I66.P13.GatPoly vout.$616.Metal2 2.99183e-05f
Cred_1595 \$I66.P13.GatPoly vout.$656.Metal2 1.8244e-05f
Cred_1596 \$I66.P13.GatPoly vout.$676.Metal2 3.60091e-05f
Cred_1597 \$I66.P13.GatPoly vout.$696.Metal2 1.05613e-05f
Cred_1598 \$I66.P13.GatPoly vout.$716.Metal2 3.55883e-05f
Cred_1599 \$I66.P13.GatPoly vout.$736.Metal2 1.93601e-05f
Cred_1600 \$I66.P13.GatPoly vout.$776.Metal2 8.46505e-05f
Cred_1601 \$I66.P13.GatPoly vout.$796.Metal2 8.72673e-05f
Cred_1602 \$I66.P13.GatPoly vout.P0.GatPoly 1.01891e-05f
Cred_1603 \$I66.P13.GatPoly vout.P10.pSD 2.35889e-07f
Cred_1604 \$I66.P13.GatPoly vout.P12.pSD 0.000191643f
Cred_1605 \$I66.P13.GatPoly vref 7.25766e-07f
Cred_1606 \$I66.P13.GatPoly vref.P0.GatPoly 2.76171e-08f
Cred_1607 \$I66.P13.GatPoly vref.P0.nSD 1.67026e-08f
Cred_1608 \$I66.P13.GatPoly vref.P0.pSD 2.92752e-08f
Cred_1609 \$I66.P14.GatPoly \$I78 0.0192636f
Cred_1610 \$I66.P14.GatPoly vss 0.00019338f
Cred_1611 \$I66.P14.GatPoly vdd.$2365.Metal1 2.62282e-06f
Cred_1612 \$I66.P14.GatPoly vdd.$2387.Metal1 0.000824985f
Cred_1613 \$I66.P14.GatPoly vdd.$2389.Metal1 0.000854965f
Cred_1614 \$I66.P14.GatPoly vdd.$2399.Metal1 8.24569e-06f
Cred_1615 \$I66.P14.GatPoly vdd.$2789.Metal2 0.0236248f
Cred_1616 \$I66.P14.GatPoly vdd.$2793.Metal2 0.00254569f
Cred_1617 \$I66.P14.GatPoly vdd.$3021.Metal3 0.00105301f
Cred_1618 \$I66.P14.GatPoly vdd.$3025.Metal3 0.00108303f
Cred_1619 \$I66.P14.GatPoly vdd.$3257.Metal4 1.24159e-05f
Cred_1620 \$I66.P14.GatPoly vdd.P0.nSD 0.000565498f
Cred_1621 \$I66.P14.GatPoly vdd.P1.GatPoly 1.16659e-07f
Cred_1622 \$I66.P14.GatPoly vdd.P17.pSD 0.0336988f
Cred_1623 \$I66.P14.GatPoly vdd.P2.GatPoly 3.66756e-07f
Cred_1624 \$I66.P14.GatPoly vout 7.37704e-05f
Cred_1625 \$I66.P14.GatPoly vout.$1004.Metal3 1.92944e-08f
Cred_1626 \$I66.P14.GatPoly vout.$1044.Metal3 3.66949e-08f
Cred_1627 \$I66.P14.GatPoly vout.$1164.Metal3 2.60128e-07f
Cred_1628 \$I66.P14.GatPoly vout.$1299.Metal4 4.03948e-07f
Cred_1629 \$I66.P14.GatPoly vout.$1313.Metal4 0.000107736f
Cred_1630 \$I66.P14.GatPoly vout.$1373.Metal4 0.000160264f
Cred_1631 \$I66.P14.GatPoly vout.$1394.Metal4 0.0227597f
Cred_1632 \$I66.P14.GatPoly vout.$162.Metal1 0.00153068f
Cred_1633 \$I66.P14.GatPoly vout.$212.Metal1 0.00538919f
Cred_1634 \$I66.P14.GatPoly vout.$232.Metal1 0.00600163f
Cred_1635 \$I66.P14.GatPoly vout.$272.Metal1 0.00598438f
Cred_1636 \$I66.P14.GatPoly vout.$292.Metal1 0.00598467f
Cred_1637 \$I66.P14.GatPoly vout.$332.Metal1 0.00600124f
Cred_1638 \$I66.P14.GatPoly vout.$352.Metal1 0.00792118f
Cred_1639 \$I66.P14.GatPoly vout.$402.Metal1 0.00871131f
Cred_1640 \$I66.P14.GatPoly vout.$596.Metal2 1.56979e-05f
Cred_1641 \$I66.P14.GatPoly vout.$616.Metal2 2.99107e-05f
Cred_1642 \$I66.P14.GatPoly vout.$656.Metal2 1.8244e-05f
Cred_1643 \$I66.P14.GatPoly vout.$676.Metal2 3.60091e-05f
Cred_1644 \$I66.P14.GatPoly vout.$696.Metal2 1.06054e-05f
Cred_1645 \$I66.P14.GatPoly vout.$716.Metal2 3.55883e-05f
Cred_1646 \$I66.P14.GatPoly vout.$736.Metal2 1.93601e-05f
Cred_1647 \$I66.P14.GatPoly vout.$776.Metal2 8.46505e-05f
Cred_1648 \$I66.P14.GatPoly vout.$796.Metal2 8.72673e-05f
Cred_1649 \$I66.P14.GatPoly vout.P0.GatPoly 1.30557e-05f
Cred_1650 \$I66.P14.GatPoly vout.P12.pSD 0.000191171f
Cred_1651 \$I66.P15.GatPoly \$I78 0.0193083f
Cred_1652 \$I66.P15.GatPoly vss 0.000247712f
Cred_1653 \$I66.P15.GatPoly vdd.$2365.Metal1 2.48154e-06f
Cred_1654 \$I66.P15.GatPoly vdd.$2389.Metal1 0.00249741f
Cred_1655 \$I66.P15.GatPoly vdd.$2399.Metal1 1.00184e-05f
Cred_1656 \$I66.P15.GatPoly vdd.$2789.Metal2 0.0193015f
Cred_1657 \$I66.P15.GatPoly vdd.$2793.Metal2 0.00384116f
Cred_1658 \$I66.P15.GatPoly vdd.$2795.Metal2 1.10644e-06f
Cred_1659 \$I66.P15.GatPoly vdd.$3025.Metal3 0.0104656f
Cred_1660 \$I66.P15.GatPoly vdd.$3029.Metal3 2.28378e-07f
Cred_1661 \$I66.P15.GatPoly vdd.$3261.Metal4 1.33857e-09f
Cred_1662 \$I66.P15.GatPoly vdd.P0.nSD 0.000602658f
Cred_1663 \$I66.P15.GatPoly vdd.P1.GatPoly 1.10375e-07f
Cred_1664 \$I66.P15.GatPoly vdd.P17.pSD 0.0280643f
Cred_1665 \$I66.P15.GatPoly vdd.P19.pSD 2.36637e-06f
Cred_1666 \$I66.P15.GatPoly vdd.P2.GatPoly 4.45604e-07f
Cred_1667 \$I66.P15.GatPoly vout 6.55275e-05f
Cred_1668 \$I66.P15.GatPoly vout.$1006.Metal3 2.58016e-06f
Cred_1669 \$I66.P15.GatPoly vout.$1008.Metal3 5.38926e-07f
Cred_1670 \$I66.P15.GatPoly vout.$1046.Metal3 3.66949e-08f
Cred_1671 \$I66.P15.GatPoly vout.$1106.Metal3 1.03773e-07f
Cred_1672 \$I66.P15.GatPoly vout.$1166.Metal3 2.60128e-07f
Cred_1673 \$I66.P15.GatPoly vout.$1299.Metal4 7.89061e-10f
Cred_1674 \$I66.P15.GatPoly vout.$1313.Metal4 0.000121762f
Cred_1675 \$I66.P15.GatPoly vout.$1373.Metal4 0.000168044f
Cred_1676 \$I66.P15.GatPoly vout.$1415.Metal4 0.00176585f
Cred_1677 \$I66.P15.GatPoly vout.$163.Metal1 0.00153823f
Cred_1678 \$I66.P15.GatPoly vout.$164.Metal1 6.47335e-07f
Cred_1679 \$I66.P15.GatPoly vout.$213.Metal1 0.00538984f
Cred_1680 \$I66.P15.GatPoly vout.$214.Metal1 1.30788e-07f
Cred_1681 \$I66.P15.GatPoly vout.$233.Metal1 0.0268862f
Cred_1682 \$I66.P15.GatPoly vout.$273.Metal1 0.00598023f
Cred_1683 \$I66.P15.GatPoly vout.$293.Metal1 0.00598063f
Cred_1684 \$I66.P15.GatPoly vout.$333.Metal1 0.00600124f
Cred_1685 \$I66.P15.GatPoly vout.$353.Metal1 0.00792118f
Cred_1686 \$I66.P15.GatPoly vout.$403.Metal1 0.00871131f
Cred_1687 \$I66.P15.GatPoly vout.$598.Metal2 1.62387e-05f
Cred_1688 \$I66.P15.GatPoly vout.$600.Metal2 9.97854e-08f
Cred_1689 \$I66.P15.GatPoly vout.$618.Metal2 2.9925e-05f
Cred_1690 \$I66.P15.GatPoly vout.$620.Metal2 2.85578e-09f
Cred_1691 \$I66.P15.GatPoly vout.$658.Metal2 1.8244e-05f
Cred_1692 \$I66.P15.GatPoly vout.$678.Metal2 4.11862e-05f
Cred_1693 \$I66.P15.GatPoly vout.$718.Metal2 4.07655e-05f
Cred_1694 \$I66.P15.GatPoly vout.$738.Metal2 1.93601e-05f
Cred_1695 \$I66.P15.GatPoly vout.$778.Metal2 8.46505e-05f
Cred_1696 \$I66.P15.GatPoly vout.$798.Metal2 8.72673e-05f
Cred_1697 \$I66.P15.GatPoly vout.P0.GatPoly 1.02791e-08f
Cred_1698 \$I66.P15.GatPoly vout.P14.pSD 0.000192055f
Cred_1699 \$I66.P15.GatPoly vout.P16.pSD 1.76871e-07f
Cred_1700 \$I66.P15.GatPoly vref 1.73482e-06f
Cred_1701 \$I66.P15.GatPoly vref.P0.GatPoly 6.60138e-08f
Cred_1702 \$I66.P15.GatPoly vref.P0.nSD 3.99246e-08f
Cred_1703 \$I66.P15.GatPoly vref.P0.pSD 6.99773e-08f
Cred_1704 \$I66.P16.GatPoly \$I78 0.0193199f
Cred_1705 \$I66.P16.GatPoly vss 0.000249432f
Cred_1706 \$I66.P16.GatPoly vdd.$2365.Metal1 2.14446e-06f
Cred_1707 \$I66.P16.GatPoly vdd.$2389.Metal1 0.00152022f
Cred_1708 \$I66.P16.GatPoly vdd.$2392.Metal1 0.000753442f
Cred_1709 \$I66.P16.GatPoly vdd.$2399.Metal1 1.12281e-05f
Cred_1710 \$I66.P16.GatPoly vdd.$2789.Metal2 8.62906e-07f
Cred_1711 \$I66.P16.GatPoly vdd.$2793.Metal2 0.00834945f
Cred_1712 \$I66.P16.GatPoly vdd.$2795.Metal2 0.0140236f
Cred_1713 \$I66.P16.GatPoly vdd.$3025.Metal3 0.00521322f
Cred_1714 \$I66.P16.GatPoly vdd.$3029.Metal3 0.00521324f
Cred_1715 \$I66.P16.GatPoly vdd.$3261.Metal4 6.14659e-05f
Cred_1716 \$I66.P16.GatPoly vdd.P0.nSD 0.000600213f
Cred_1717 \$I66.P16.GatPoly vdd.P1.GatPoly 9.53824e-08f
Cred_1718 \$I66.P16.GatPoly vdd.P17.pSD 1.3931e-06f
Cred_1719 \$I66.P16.GatPoly vdd.P19.pSD 0.028063f
Cred_1720 \$I66.P16.GatPoly vdd.P2.GatPoly 4.99409e-07f
Cred_1721 \$I66.P16.GatPoly vout 6.79649e-05f
Cred_1722 \$I66.P16.GatPoly vout.$1006.Metal3 2.98298e-06f
Cred_1723 \$I66.P16.GatPoly vout.$1008.Metal3 1.07797e-06f
Cred_1724 \$I66.P16.GatPoly vout.$1046.Metal3 3.66949e-08f
Cred_1725 \$I66.P16.GatPoly vout.$1106.Metal3 1.04207e-07f
Cred_1726 \$I66.P16.GatPoly vout.$1166.Metal3 2.60128e-07f
Cred_1727 \$I66.P16.GatPoly vout.$1299.Metal4 8.18411e-10f
Cred_1728 \$I66.P16.GatPoly vout.$1313.Metal4 0.00012648f
Cred_1729 \$I66.P16.GatPoly vout.$1373.Metal4 0.000170637f
Cred_1730 \$I66.P16.GatPoly vout.$1415.Metal4 0.00176585f
Cred_1731 \$I66.P16.GatPoly vout.$163.Metal1 0.00153455f
Cred_1732 \$I66.P16.GatPoly vout.$164.Metal1 1.29481e-06f
Cred_1733 \$I66.P16.GatPoly vout.$213.Metal1 0.00538997f
Cred_1734 \$I66.P16.GatPoly vout.$214.Metal1 2.61606e-07f
Cred_1735 \$I66.P16.GatPoly vout.$233.Metal1 0.0268791f
Cred_1736 \$I66.P16.GatPoly vout.$273.Metal1 0.00598444f
Cred_1737 \$I66.P16.GatPoly vout.$293.Metal1 0.00598472f
Cred_1738 \$I66.P16.GatPoly vout.$333.Metal1 0.00600124f
Cred_1739 \$I66.P16.GatPoly vout.$353.Metal1 0.00792118f
Cred_1740 \$I66.P16.GatPoly vout.$403.Metal1 0.00871131f
Cred_1741 \$I66.P16.GatPoly vout.$598.Metal2 1.62914e-05f
Cred_1742 \$I66.P16.GatPoly vout.$600.Metal2 1.99593e-07f
Cred_1743 \$I66.P16.GatPoly vout.$618.Metal2 2.99278e-05f
Cred_1744 \$I66.P16.GatPoly vout.$620.Metal2 5.71219e-09f
Cred_1745 \$I66.P16.GatPoly vout.$658.Metal2 1.8244e-05f
Cred_1746 \$I66.P16.GatPoly vout.$678.Metal2 4.12079e-05f
Cred_1747 \$I66.P16.GatPoly vout.$718.Metal2 4.07871e-05f
Cred_1748 \$I66.P16.GatPoly vout.$738.Metal2 1.93601e-05f
Cred_1749 \$I66.P16.GatPoly vout.$778.Metal2 8.46505e-05f
Cred_1750 \$I66.P16.GatPoly vout.$798.Metal2 8.72673e-05f
Cred_1751 \$I66.P16.GatPoly vout.P0.GatPoly 1.06614e-08f
Cred_1752 \$I66.P16.GatPoly vout.P14.pSD 0.000192232f
Cred_1753 \$I66.P16.GatPoly vout.P16.pSD 3.53782e-07f
Cred_1754 \$I66.P16.GatPoly vref 2.31304e-06f
Cred_1755 \$I66.P16.GatPoly vref.P0.GatPoly 8.80168e-08f
Cred_1756 \$I66.P16.GatPoly vref.P0.nSD 5.32318e-08f
Cred_1757 \$I66.P16.GatPoly vref.P0.pSD 9.33014e-08f
Cred_1758 \$I66.P17.GatPoly \$I78 0.0193083f
Cred_1759 \$I66.P17.GatPoly vss 0.000247712f
Cred_1760 \$I66.P17.GatPoly vdd.$2365.Metal1 1.92378e-06f
Cred_1761 \$I66.P17.GatPoly vdd.$2389.Metal1 0.000738812f
Cred_1762 \$I66.P17.GatPoly vdd.$2392.Metal1 0.00149077f
Cred_1763 \$I66.P17.GatPoly vdd.$2399.Metal1 1.28951e-05f
Cred_1764 \$I66.P17.GatPoly vdd.$2789.Metal2 4.31405e-07f
Cred_1765 \$I66.P17.GatPoly vdd.$2793.Metal2 0.00580959f
Cred_1766 \$I66.P17.GatPoly vdd.$2795.Metal2 0.0174075f
Cred_1767 \$I66.P17.GatPoly vdd.$3025.Metal3 2.18397e-07f
Cred_1768 \$I66.P17.GatPoly vdd.$3029.Metal3 0.0104706f
Cred_1769 \$I66.P17.GatPoly vdd.$3261.Metal4 1.33857e-09f
Cred_1770 \$I66.P17.GatPoly vdd.P0.nSD 0.000607522f
Cred_1771 \$I66.P17.GatPoly vdd.P1.GatPoly 8.55667e-08f
Cred_1772 \$I66.P17.GatPoly vdd.P17.pSD 6.96473e-07f
Cred_1773 \$I66.P17.GatPoly vdd.P19.pSD 0.0280687f
Cred_1774 \$I66.P17.GatPoly vdd.P2.GatPoly 5.73552e-07f
Cred_1775 \$I66.P17.GatPoly vout 6.55275e-05f
Cred_1776 \$I66.P17.GatPoly vout.$1006.Metal3 1.48168e-06f
Cred_1777 \$I66.P17.GatPoly vout.$1008.Metal3 1.63741e-06f
Cred_1778 \$I66.P17.GatPoly vout.$1048.Metal3 3.66949e-08f
Cred_1779 \$I66.P17.GatPoly vout.$1168.Metal3 4.12922e-08f
Cred_1780 \$I66.P17.GatPoly vout.$1208.Metal3 2.23813e-05f
Cred_1781 \$I66.P17.GatPoly vout.$1299.Metal4 7.89061e-10f
Cred_1782 \$I66.P17.GatPoly vout.$1313.Metal4 0.000121762f
Cred_1783 \$I66.P17.GatPoly vout.$1373.Metal4 0.000168044f
Cred_1784 \$I66.P17.GatPoly vout.$1415.Metal4 0.00108601f
Cred_1785 \$I66.P17.GatPoly vout.$163.Metal1 1.93633e-06f
Cred_1786 \$I66.P17.GatPoly vout.$164.Metal1 0.00153694f
Cred_1787 \$I66.P17.GatPoly vout.$213.Metal1 3.92394e-07f
Cred_1788 \$I66.P17.GatPoly vout.$214.Metal1 0.00538958f
Cred_1789 \$I66.P17.GatPoly vout.$234.Metal1 0.00600163f
Cred_1790 \$I66.P17.GatPoly vout.$274.Metal1 0.00598017f
Cred_1791 \$I66.P17.GatPoly vout.$294.Metal1 0.0275059f
Cred_1792 \$I66.P17.GatPoly vout.$334.Metal1 0.00600124f
Cred_1793 \$I66.P17.GatPoly vout.$354.Metal1 0.00792118f
Cred_1794 \$I66.P17.GatPoly vout.$404.Metal1 0.00871132f
Cred_1795 \$I66.P17.GatPoly vout.$598.Metal2 2.96713e-07f
Cred_1796 \$I66.P17.GatPoly vout.$600.Metal2 1.60418e-05f
Cred_1797 \$I66.P17.GatPoly vout.$618.Metal2 8.56796e-09f
Cred_1798 \$I66.P17.GatPoly vout.$620.Metal2 2.99193e-05f
Cred_1799 \$I66.P17.GatPoly vout.$660.Metal2 1.8244e-05f
Cred_1800 \$I66.P17.GatPoly vout.$680.Metal2 3.60091e-05f
Cred_1801 \$I66.P17.GatPoly vout.$700.Metal2 1.05613e-05f
Cred_1802 \$I66.P17.GatPoly vout.$720.Metal2 3.55883e-05f
Cred_1803 \$I66.P17.GatPoly vout.$740.Metal2 1.93601e-05f
Cred_1804 \$I66.P17.GatPoly vout.$780.Metal2 8.46461e-05f
Cred_1805 \$I66.P17.GatPoly vout.$800.Metal2 8.74591e-05f
Cred_1806 \$I66.P17.GatPoly vout.P0.GatPoly 1.02791e-08f
Cred_1807 \$I66.P17.GatPoly vout.P14.pSD 5.30653e-07f
Cred_1808 \$I66.P17.GatPoly vout.P16.pSD 0.000191702f
Cred_1809 \$I66.P17.GatPoly vref 1.73482e-06f
Cred_1810 \$I66.P17.GatPoly vref.P0.GatPoly 6.60138e-08f
Cred_1811 \$I66.P17.GatPoly vref.P0.nSD 3.99246e-08f
Cred_1812 \$I66.P17.GatPoly vref.P0.pSD 6.99773e-08f
Cred_1813 \$I66.P18.GatPoly \$I78 0.0192734f
Cred_1814 \$I66.P18.GatPoly vss 0.000242553f
Cred_1815 \$I66.P18.GatPoly vdd.$2365.Metal1 1.63453e-06f
Cred_1816 \$I66.P18.GatPoly vdd.$2392.Metal1 0.000500179f
Cred_1817 \$I66.P18.GatPoly vdd.$2394.Metal1 0.000527239f
Cred_1818 \$I66.P18.GatPoly vdd.$2399.Metal1 1.42709e-05f
Cred_1819 \$I66.P18.GatPoly vdd.$2799.Metal2 0.0239751f
Cred_1820 \$I66.P18.GatPoly vdd.$2803.Metal2 0.00229594f
Cred_1821 \$I66.P18.GatPoly vdd.$3031.Metal3 0.000952722f
Cred_1822 \$I66.P18.GatPoly vdd.$3035.Metal3 0.000979793f
Cred_1823 \$I66.P18.GatPoly vdd.$3267.Metal4 1.12334e-05f
Cred_1824 \$I66.P18.GatPoly vdd.P0.nSD 0.000582729f
Cred_1825 \$I66.P18.GatPoly vdd.P1.GatPoly 7.27014e-08f
Cred_1826 \$I66.P18.GatPoly vdd.P2.GatPoly 6.34746e-07f
Cred_1827 \$I66.P18.GatPoly vdd.P21.pSD 0.0338712f
Cred_1828 \$I66.P18.GatPoly vout 5.82148e-05f
Cred_1829 \$I66.P18.GatPoly vout.$1008.Metal3 1.92944e-08f
Cred_1830 \$I66.P18.GatPoly vout.$1048.Metal3 3.66949e-08f
Cred_1831 \$I66.P18.GatPoly vout.$1168.Metal3 4.12922e-08f
Cred_1832 \$I66.P18.GatPoly vout.$1208.Metal3 2.23813e-05f
Cred_1833 \$I66.P18.GatPoly vout.$1299.Metal4 7.01004e-10f
Cred_1834 \$I66.P18.GatPoly vout.$1313.Metal4 0.0001076f
Cred_1835 \$I66.P18.GatPoly vout.$1373.Metal4 0.000160264f
Cred_1836 \$I66.P18.GatPoly vout.$1415.Metal4 0.00108601f
Cred_1837 \$I66.P18.GatPoly vout.$164.Metal1 0.00153068f
Cred_1838 \$I66.P18.GatPoly vout.$214.Metal1 0.00538919f
Cred_1839 \$I66.P18.GatPoly vout.$234.Metal1 0.0275366f
Cred_1840 \$I66.P18.GatPoly vout.$274.Metal1 0.00598438f
Cred_1841 \$I66.P18.GatPoly vout.$294.Metal1 0.00598467f
Cred_1842 \$I66.P18.GatPoly vout.$334.Metal1 0.00600124f
Cred_1843 \$I66.P18.GatPoly vout.$354.Metal1 0.00792118f
Cred_1844 \$I66.P18.GatPoly vout.$404.Metal1 0.00871132f
Cred_1845 \$I66.P18.GatPoly vout.$600.Metal2 1.56979e-05f
Cred_1846 \$I66.P18.GatPoly vout.$620.Metal2 2.99107e-05f
Cred_1847 \$I66.P18.GatPoly vout.$660.Metal2 1.8244e-05f
Cred_1848 \$I66.P18.GatPoly vout.$680.Metal2 3.60091e-05f
Cred_1849 \$I66.P18.GatPoly vout.$700.Metal2 1.06054e-05f
Cred_1850 \$I66.P18.GatPoly vout.$720.Metal2 3.55883e-05f
Cred_1851 \$I66.P18.GatPoly vout.$740.Metal2 1.93601e-05f
Cred_1852 \$I66.P18.GatPoly vout.$780.Metal2 8.46461e-05f
Cred_1853 \$I66.P18.GatPoly vout.$800.Metal2 8.74591e-05f
Cred_1854 \$I66.P18.GatPoly vout.P0.GatPoly 9.13194e-09f
Cred_1855 \$I66.P18.GatPoly vout.P16.pSD 0.000191171f
Cred_1856 \$I66.P19.GatPoly \$I78 0.0191828f
Cred_1857 \$I66.P19.GatPoly vss 0.000251726f
Cred_1858 \$I66.P19.GatPoly vdd.$2365.Metal1 1.47193e-06f
Cred_1859 \$I66.P19.GatPoly vdd.$2394.Metal1 0.00248191f
Cred_1860 \$I66.P19.GatPoly vdd.$2399.Metal1 2.24152e-05f
Cred_1861 \$I66.P19.GatPoly vdd.$2799.Metal2 0.0195388f
Cred_1862 \$I66.P19.GatPoly vdd.$2803.Metal2 0.00359071f
Cred_1863 \$I66.P19.GatPoly vdd.$2805.Metal2 6.52764e-07f
Cred_1864 \$I66.P19.GatPoly vdd.$2807.Metal2 8.50159e-07f
Cred_1865 \$I66.P19.GatPoly vdd.$3035.Metal3 0.0104754f
Cred_1866 \$I66.P19.GatPoly vdd.$3039.Metal3 1.78109e-07f
Cred_1867 \$I66.P19.GatPoly vdd.$3271.Metal4 2.10006e-09f
Cred_1868 \$I66.P19.GatPoly vdd.P0.nSD 0.00063441f
Cred_1869 \$I66.P19.GatPoly vdd.P1.GatPoly 6.54691e-08f
Cred_1870 \$I66.P19.GatPoly vdd.P2.GatPoly 3.88214e-06f
Cred_1871 \$I66.P19.GatPoly vdd.P21.pSD 0.0280599f
Cred_1872 \$I66.P19.GatPoly vdd.P23.pSD 1.59594e-06f
Cred_1873 \$I66.P19.GatPoly vdd.P25.pSD 7.42329e-07f
Cred_1874 \$I66.P19.GatPoly vout 6.38939e-05f
Cred_1875 \$I66.P19.GatPoly vout.$1010.Metal3 3.98307e-06f
Cred_1876 \$I66.P19.GatPoly vout.$1050.Metal3 3.66949e-08f
Cred_1877 \$I66.P19.GatPoly vout.$1110.Metal3 1.03773e-07f
Cred_1878 \$I66.P19.GatPoly vout.$1190.Metal3 2.43653e-07f
Cred_1879 \$I66.P19.GatPoly vout.$1299.Metal4 7.6939e-10f
Cred_1880 \$I66.P19.GatPoly vout.$1313.Metal4 0.000117319f
Cred_1881 \$I66.P19.GatPoly vout.$1373.Metal4 0.00016545f
Cred_1882 \$I66.P19.GatPoly vout.$1416.Metal4 1.4671e-08f
Cred_1883 \$I66.P19.GatPoly vout.$165.Metal1 0.00153536f
Cred_1884 \$I66.P19.GatPoly vout.$215.Metal1 0.00539023f
Cred_1885 \$I66.P19.GatPoly vout.$235.Metal1 0.00600163f
Cred_1886 \$I66.P19.GatPoly vout.$275.Metal1 0.00598023f
Cred_1887 \$I66.P19.GatPoly vout.$295.Metal1 0.0283657f
Cred_1888 \$I66.P19.GatPoly vout.$335.Metal1 0.00600124f
Cred_1889 \$I66.P19.GatPoly vout.$355.Metal1 0.00792114f
Cred_1890 \$I66.P19.GatPoly vout.$405.Metal1 0.00871131f
Cred_1891 \$I66.P19.GatPoly vout.$602.Metal2 1.65338e-05f
Cred_1892 \$I66.P19.GatPoly vout.$622.Metal2 2.99335e-05f
Cred_1893 \$I66.P19.GatPoly vout.$662.Metal2 1.8244e-05f
Cred_1894 \$I66.P19.GatPoly vout.$682.Metal2 4.11862e-05f
Cred_1895 \$I66.P19.GatPoly vout.$722.Metal2 4.07655e-05f
Cred_1896 \$I66.P19.GatPoly vout.$742.Metal2 1.73001e-05f
Cred_1897 \$I66.P19.GatPoly vout.$762.Metal2 4.20256e-06f
Cred_1898 \$I66.P19.GatPoly vout.$782.Metal2 8.25861e-05f
Cred_1899 \$I66.P19.GatPoly vout.$802.Metal2 8.72595e-05f
Cred_1900 \$I66.P19.GatPoly vout.P0.GatPoly 1.00228e-08f
Cred_1901 \$I66.P19.GatPoly vout.P18.pSD 0.000192799f
Cred_1902 \$I66.P19.GatPoly vref 1.9782e-06f
Cred_1903 \$I66.P19.GatPoly vref.P0.GatPoly 4.15448e-08f
Cred_1904 \$I66.P19.GatPoly vref.P0.nSD 2.5126e-08f
Cred_1905 \$I66.P19.GatPoly vref.P0.pSD 4.40392e-08f
Cred_1906 \$I66.P19.GatPoly vss 2.72121e-06f
Cred_1907 \$I66.P19.GatPoly vss.$1211.Metal5 9.92955e-07f
Cred_1908 \$I66.P19.GatPoly vss.$1229.Metal5 9.92955e-07f
Cred_1909 \$I66.P19.GatPoly vss.$1281.Metal5 3.80083e-06f
Cred_1910 \$I66.P19.GatPoly vss.$1299.Metal5 3.80083e-06f
Cred_1911 \$I66.P2.GatPoly \$I67.$82.Metal2 3.66086e-05f
Cred_1912 \$I66.P2.GatPoly \$I78 0.0193465f
Cred_1913 \$I66.P2.GatPoly vss 0.000253694f
Cred_1914 \$I66.P2.GatPoly vdd.$2365.Metal1 3.71275e-05f
Cred_1915 \$I66.P2.GatPoly vdd.$2370.Metal1 0.00248191f
Cred_1916 \$I66.P2.GatPoly vdd.$2399.Metal1 1.72281e-06f
Cred_1917 \$I66.P2.GatPoly vdd.$2747.Metal2 2.54728e-06f
Cred_1918 \$I66.P2.GatPoly vdd.$2749.Metal2 1.95583e-06f
Cred_1919 \$I66.P2.GatPoly vdd.$2751.Metal2 0.0035913f
Cred_1920 \$I66.P2.GatPoly vdd.$2755.Metal2 0.0195348f
Cred_1921 \$I66.P2.GatPoly vdd.$2759.Metal2 1.53098e-06f
Cred_1922 \$I66.P2.GatPoly vdd.$2761.Metal2 6.3351e-07f
Cred_1923 \$I66.P2.GatPoly vdd.$2983.Metal3 5.33658e-07f
Cred_1924 \$I66.P2.GatPoly vdd.$2987.Metal3 0.0104675f
Cred_1925 \$I66.P2.GatPoly vdd.$2991.Metal3 3.97641e-07f
Cred_1926 \$I66.P2.GatPoly vdd.$2993.Metal3 4.58747e-07f
Cred_1927 \$I66.P2.GatPoly vdd.$3219.Metal4 6.29228e-09f
Cred_1928 \$I66.P2.GatPoly vdd.$3223.Metal4 4.68853e-09f
Cred_1929 \$I66.P2.GatPoly vdd.P0.nSD 0.000823212f
Cred_1930 \$I66.P2.GatPoly vdd.P0.pSD 2.22419e-06f
Cred_1931 \$I66.P2.GatPoly vdd.P1.GatPoly 1.03223e-05f
Cred_1932 \$I66.P2.GatPoly vdd.P1.pSD 4.92878e-06f
Cred_1933 \$I66.P2.GatPoly vdd.P2.GatPoly 7.66278e-08f
Cred_1934 \$I66.P2.GatPoly vdd.P3.pSD 0.0280541f
Cred_1935 \$I66.P2.GatPoly vdd.P5.pSD 3.34848e-06f
Cred_1936 \$I66.P2.GatPoly vout.$1032.Metal3 1.15777e-05f
Cred_1937 \$I66.P2.GatPoly vout.$1034.Metal3 5.90415e-06f
Cred_1938 \$I66.P2.GatPoly vout.$1112.Metal3 6.02726e-09f
Cred_1939 \$I66.P2.GatPoly vout.$1152.Metal3 2.74397e-07f
Cred_1940 \$I66.P2.GatPoly vout.$1328.Metal4 4.00869e-06f
Cred_1941 \$I66.P2.GatPoly vout.$1329.Metal4 2.02012e-06f
Cred_1942 \$I66.P2.GatPoly vout.$1368.Metal4 0.0237574f
Cred_1943 \$I66.P2.GatPoly vout.$1369.Metal4 1.07695e-06f
Cred_1944 \$I66.P2.GatPoly vout.$1408.Metal4 0.00170124f
Cred_1945 \$I66.P2.GatPoly vout.$156.Metal1 0.00144593f
Cred_1946 \$I66.P2.GatPoly vout.$157.Metal1 6.89018e-06f
Cred_1947 \$I66.P2.GatPoly vout.$206.Metal1 0.00551713f
Cred_1948 \$I66.P2.GatPoly vout.$207.Metal1 2.54329e-06f
Cred_1949 \$I66.P2.GatPoly vout.$226.Metal1 0.00600163f
Cred_1950 \$I66.P2.GatPoly vout.$266.Metal1 0.00596824f
Cred_1951 \$I66.P2.GatPoly vout.$286.Metal1 0.00596897f
Cred_1952 \$I66.P2.GatPoly vout.$326.Metal1 0.00600124f
Cred_1953 \$I66.P2.GatPoly vout.$346.Metal1 0.00792118f
Cred_1954 \$I66.P2.GatPoly vout.$396.Metal1 0.00871131f
Cred_1955 \$I66.P2.GatPoly vout.$584.Metal2 2.34121e-05f
Cred_1956 \$I66.P2.GatPoly vout.$586.Metal2 1.70565e-06f
Cred_1957 \$I66.P2.GatPoly vout.$604.Metal2 3.29356e-05f
Cred_1958 \$I66.P2.GatPoly vout.$606.Metal2 1.73878e-07f
Cred_1959 \$I66.P2.GatPoly vout.$644.Metal2 1.8244e-05f
Cred_1960 \$I66.P2.GatPoly vout.$664.Metal2 3.60091e-05f
Cred_1961 \$I66.P2.GatPoly vout.$684.Metal2 1.04364e-05f
Cred_1962 \$I66.P2.GatPoly vout.$704.Metal2 3.55883e-05f
Cred_1963 \$I66.P2.GatPoly vout.$724.Metal2 1.93602e-05f
Cred_1964 \$I66.P2.GatPoly vout.$764.Metal2 8.46505e-05f
Cred_1965 \$I66.P2.GatPoly vout.$784.Metal2 8.72673e-05f
Cred_1966 \$I66.P2.GatPoly vout.P0.pSD 0.000200886f
Cred_1967 \$I66.P2.GatPoly vout.P2.pSD 3.00419e-06f
Cred_1968 \$I66.P2.GatPoly vss 0.000459468f
Cred_1969 \$I66.P2.GatPoly vss.$1211.Metal5 0.000170299f
Cred_1970 \$I66.P2.GatPoly vss.$1229.Metal5 0.000170299f
Cred_1971 \$I66.P2.GatPoly vss.$1281.Metal5 0.000651871f
Cred_1972 \$I66.P2.GatPoly vss.$1299.Metal5 0.000651871f
Cred_1973 \$I66.P20.GatPoly \$I78 0.0193433f
Cred_1974 \$I66.P20.GatPoly vss 0.00025746f
Cred_1975 \$I66.P20.GatPoly vdd.$2365.Metal1 1.02958e-05f
Cred_1976 \$I66.P20.GatPoly vdd.$2394.Metal1 0.00100605f
Cred_1977 \$I66.P20.GatPoly vdd.$2397.Metal1 0.000498601f
Cred_1978 \$I66.P20.GatPoly vdd.$2399.Metal1 0.00113849f
Cred_1979 \$I66.P20.GatPoly vdd.$2799.Metal2 1.7583e-06f
Cred_1980 \$I66.P20.GatPoly vdd.$2803.Metal2 0.0087577f
Cred_1981 \$I66.P20.GatPoly vdd.$2805.Metal2 0.0134907f
Cred_1982 \$I66.P20.GatPoly vdd.$2807.Metal2 1.70051e-06f
Cred_1983 \$I66.P20.GatPoly vdd.$3035.Metal3 0.00130448f
Cred_1984 \$I66.P20.GatPoly vdd.$3039.Metal3 0.00130408f
Cred_1985 \$I66.P20.GatPoly vdd.$3271.Metal4 0.00262811f
Cred_1986 \$I66.P20.GatPoly vdd.P0.nSD 0.0118296f
Cred_1987 \$I66.P20.GatPoly vdd.P1.GatPoly 4.5794e-07f
Cred_1988 \$I66.P20.GatPoly vdd.P2.GatPoly 0.153088f
Cred_1989 \$I66.P20.GatPoly vdd.P21.pSD 2.78982e-06f
Cred_1990 \$I66.P20.GatPoly vdd.P23.pSD 0.0279623f
Cred_1991 \$I66.P20.GatPoly vdd.P25.pSD 1.48482e-06f
Cred_1992 \$I66.P20.GatPoly vout 6.48264e-06f
Cred_1993 \$I66.P20.GatPoly vout.$1010.Metal3 5.86726e-06f
Cred_1994 \$I66.P20.GatPoly vout.$1050.Metal3 3.66949e-08f
Cred_1995 \$I66.P20.GatPoly vout.$1110.Metal3 1.04207e-07f
Cred_1996 \$I66.P20.GatPoly vout.$1190.Metal3 2.43653e-07f
Cred_1997 \$I66.P20.GatPoly vout.$1299.Metal4 7.80618e-11f
Cred_1998 \$I66.P20.GatPoly vout.$1313.Metal4 1.92401e-05f
Cred_1999 \$I66.P20.GatPoly vout.$1373.Metal4 5.18537e-06f
Cred_2000 \$I66.P20.GatPoly vout.$1416.Metal4 1.4671e-08f
Cred_2001 \$I66.P20.GatPoly vout.$165.Metal1 0.00144877f
Cred_2002 \$I66.P20.GatPoly vout.$215.Metal1 0.00539076f
Cred_2003 \$I66.P20.GatPoly vout.$235.Metal1 0.0214788f
Cred_2004 \$I66.P20.GatPoly vout.$275.Metal1 0.00598444f
Cred_2005 \$I66.P20.GatPoly vout.$295.Metal1 0.00598472f
Cred_2006 \$I66.P20.GatPoly vout.$335.Metal1 0.00600124f
Cred_2007 \$I66.P20.GatPoly vout.$355.Metal1 0.00792114f
Cred_2008 \$I66.P20.GatPoly vout.$405.Metal1 0.00871131f
Cred_2009 \$I66.P20.GatPoly vout.$602.Metal2 1.68831e-05f
Cred_2010 \$I66.P20.GatPoly vout.$622.Metal2 2.9945e-05f
Cred_2011 \$I66.P20.GatPoly vout.$662.Metal2 1.8244e-05f
Cred_2012 \$I66.P20.GatPoly vout.$682.Metal2 4.12079e-05f
Cred_2013 \$I66.P20.GatPoly vout.$722.Metal2 4.07871e-05f
Cred_2014 \$I66.P20.GatPoly vout.$742.Metal2 1.73001e-05f
Cred_2015 \$I66.P20.GatPoly vout.$762.Metal2 4.20256e-06f
Cred_2016 \$I66.P20.GatPoly vout.$782.Metal2 8.25861e-05f
Cred_2017 \$I66.P20.GatPoly vout.$802.Metal2 8.72595e-05f
Cred_2018 \$I66.P20.GatPoly vout.P0.GatPoly 1.01691e-09f
Cred_2019 \$I66.P20.GatPoly vout.P18.pSD 0.000193506f
Cred_2020 \$I66.P20.GatPoly vref 2.86457e-06f
Cred_2021 \$I66.P20.GatPoly vref.P0.GatPoly 4.15356e-08f
Cred_2022 \$I66.P20.GatPoly vref.P0.nSD 2.51204e-08f
Cred_2023 \$I66.P20.GatPoly vref.P0.pSD 4.40295e-08f
Cred_2024 \$I66.P20.GatPoly vss 0.0011708f
Cred_2025 \$I66.P20.GatPoly vss.$1211.Metal5 0.000427221f
Cred_2026 \$I66.P20.GatPoly vss.$1229.Metal5 0.000427221f
Cred_2027 \$I66.P20.GatPoly vss.$1281.Metal5 0.00163531f
Cred_2028 \$I66.P20.GatPoly vss.$1299.Metal5 0.00163531f
Cred_2029 \$I66.P21.GatPoly \$I67.$82.Metal2 0.000130185f
Cred_2030 \$I66.P21.GatPoly \$I78 9.22284e-06f
Cred_2031 \$I66.P21.GatPoly vss 0.0244878f
Cred_2032 \$I66.P21.GatPoly vdd.$2365.Metal1 3.42692e-07f
Cred_2033 \$I66.P21.GatPoly vdd.$2399.Metal1 2.75521e-09f
Cred_2034 \$I66.P21.GatPoly vdd.P0.nSD 3.43863e-06f
Cred_2035 \$I66.P21.GatPoly vdd.P1.GatPoly 7.73615e-08f
Cred_2036 \$I66.P21.GatPoly vdd.P2.GatPoly 1.22547e-10f
Cred_2037 \$I66.P21.GatPoly vout.$11.Metal1 0.00903491f
Cred_2038 \$I66.P21.GatPoly vout.$121.Metal1 0.00479019f
Cred_2039 \$I66.P21.GatPoly vout.$1235.Metal4 1.55854e-06f
Cred_2040 \$I66.P21.GatPoly vout.$1264.Metal4 6.02315e-06f
Cred_2041 \$I66.P21.GatPoly vout.$436.Metal2 8.91319e-05f
Cred_2042 \$I66.P21.GatPoly vout.$456.Metal2 8.89175e-05f
Cred_2043 \$I66.P21.GatPoly vout.$496.Metal2 8.53418e-05f
Cred_2044 \$I66.P21.GatPoly vout.$516.Metal2 7.04896e-05f
Cred_2045 \$I66.P21.GatPoly vout.$61.Metal1 0.0197021f
Cred_2046 \$I66.P21.GatPoly vout.$864.Metal3 3.47689e-07f
Cred_2047 \$I66.P21.GatPoly vout.$904.Metal3 2.67944e-05f
Cred_2048 \$I66.P21.GatPoly vout.P0.nSD 0.000241065f
Cred_2049 \$I66.P21.GatPoly vss 0.000320047f
Cred_2050 \$I66.P21.GatPoly vss.$10.Metal1 0.00161708f
Cred_2051 \$I66.P21.GatPoly vss.$1009.Metal4 0.00178447f
Cred_2052 \$I66.P21.GatPoly vss.$1013.Metal4 2.83832e-09f
Cred_2053 \$I66.P21.GatPoly vss.$1211.Metal5 0.000329017f
Cred_2054 \$I66.P21.GatPoly vss.$1229.Metal5 0.000323572f
Cred_2055 \$I66.P21.GatPoly vss.$127.Metal1 0.00334025f
Cred_2056 \$I66.P21.GatPoly vss.$1281.Metal5 0.00130014f
Cred_2057 \$I66.P21.GatPoly vss.$1299.Metal5 0.00123524f
Cred_2058 \$I66.P21.GatPoly vss.$13.Metal1 1.50803e-07f
Cred_2059 \$I66.P21.GatPoly vss.$406.Metal1 0.000204752f
Cred_2060 \$I66.P21.GatPoly vss.$457.Metal2 4.87839e-05f
Cred_2061 \$I66.P21.GatPoly vss.$461.Metal2 9.64592e-06f
Cred_2062 \$I66.P21.GatPoly vss.$463.Metal2 0.0128189f
Cred_2063 \$I66.P21.GatPoly vss.$467.Metal2 0.00323345f
Cred_2064 \$I66.P21.GatPoly vss.$469.Metal2 2.30972e-06f
Cred_2065 \$I66.P21.GatPoly vss.$799.Metal3 0.00200245f
Cred_2066 \$I66.P21.GatPoly vss.$801.Metal3 1.35136e-06f
Cred_2067 \$I66.P21.GatPoly vss.$805.Metal3 2.40723e-07f
Cred_2068 \$I66.P21.GatPoly vss.P0.GatPoly 0.0855463f
Cred_2069 \$I66.P21.GatPoly vss.P0.nSD 2.74447e-06f
Cred_2070 \$I66.P21.GatPoly vss.P0.pSD 0.0148048f
Cred_2071 \$I66.P21.GatPoly vss.P1.nSD 0.012016f
Cred_2072 \$I66.P21.GatPoly vss.P3.nSD 2.12482e-06f
Cred_2073 \$I66.P22.GatPoly \$I67.$82.Metal2 9.36332e-05f
Cred_2074 \$I66.P22.GatPoly \$I78 4.61055e-06f
Cred_2075 \$I66.P22.GatPoly vss 0.0239941f
Cred_2076 \$I66.P22.GatPoly vdd.$2365.Metal1 1.71313e-07f
Cred_2077 \$I66.P22.GatPoly vdd.$2399.Metal1 1.37734e-09f
Cred_2078 \$I66.P22.GatPoly vdd.P0.nSD 1.71899e-06f
Cred_2079 \$I66.P22.GatPoly vdd.P1.GatPoly 3.86734e-08f
Cred_2080 \$I66.P22.GatPoly vdd.P2.GatPoly 6.12621e-11f
Cred_2081 \$I66.P22.GatPoly vout.$11.Metal1 0.00903491f
Cred_2082 \$I66.P22.GatPoly vout.$121.Metal1 0.00482255f
Cred_2083 \$I66.P22.GatPoly vout.$1235.Metal4 3.45781e-05f
Cred_2084 \$I66.P22.GatPoly vout.$1264.Metal4 0.0016981f
Cred_2085 \$I66.P22.GatPoly vout.$436.Metal2 8.91745e-05f
Cred_2086 \$I66.P22.GatPoly vout.$456.Metal2 8.89175e-05f
Cred_2087 \$I66.P22.GatPoly vout.$496.Metal2 8.53418e-05f
Cred_2088 \$I66.P22.GatPoly vout.$516.Metal2 7.10533e-05f
Cred_2089 \$I66.P22.GatPoly vout.$61.Metal1 0.0231179f
Cred_2090 \$I66.P22.GatPoly vout.$864.Metal3 1.31238e-06f
Cred_2091 \$I66.P22.GatPoly vout.$904.Metal3 1.58366e-05f
Cred_2092 \$I66.P22.GatPoly vout.P0.nSD 0.00023946f
Cred_2093 \$I66.P22.GatPoly vss 5.27674e-05f
Cred_2094 \$I66.P22.GatPoly vss.$10.Metal1 0.00106552f
Cred_2095 \$I66.P22.GatPoly vss.$1013.Metal4 2.8394e-09f
Cred_2096 \$I66.P22.GatPoly vss.$1211.Metal5 5.3894e-05f
Cred_2097 \$I66.P22.GatPoly vss.$1229.Metal5 5.11721e-05f
Cred_2098 \$I66.P22.GatPoly vss.$127.Metal1 7.83917e-05f
Cred_2099 \$I66.P22.GatPoly vss.$1281.Metal5 0.000226659f
Cred_2100 \$I66.P22.GatPoly vss.$1299.Metal5 0.000194215f
Cred_2101 \$I66.P22.GatPoly vss.$13.Metal1 0.000527865f
Cred_2102 \$I66.P22.GatPoly vss.$406.Metal1 3.11704e-05f
Cred_2103 \$I66.P22.GatPoly vss.$457.Metal2 1.1449e-06f
Cred_2104 \$I66.P22.GatPoly vss.$461.Metal2 4.82205e-06f
Cred_2105 \$I66.P22.GatPoly vss.$463.Metal2 1.38025e-06f
Cred_2106 \$I66.P22.GatPoly vss.$467.Metal2 0.00539072f
Cred_2107 \$I66.P22.GatPoly vss.$469.Metal2 0.0134709f
Cred_2108 \$I66.P22.GatPoly vss.$799.Metal3 9.98955e-07f
Cred_2109 \$I66.P22.GatPoly vss.$801.Metal3 0.0019637f
Cred_2110 \$I66.P22.GatPoly vss.$805.Metal3 2.40814e-07f
Cred_2111 \$I66.P22.GatPoly vss.P0.GatPoly 1.05758e-05f
Cred_2112 \$I66.P22.GatPoly vss.P0.nSD 1.37197e-06f
Cred_2113 \$I66.P22.GatPoly vss.P0.pSD 0.00093463f
Cred_2114 \$I66.P22.GatPoly vss.P1.nSD 1.57333e-06f
Cred_2115 \$I66.P22.GatPoly vss.P3.nSD 0.0142918f
Cred_2116 \$I66.P23.GatPoly \$I67.$82.Metal2 5.63573e-05f
Cred_2117 \$I66.P23.GatPoly vss 0.0234603f
Cred_2118 \$I66.P23.GatPoly vout.$12.Metal1 0.00903491f
Cred_2119 \$I66.P23.GatPoly vout.$122.Metal1 0.00481337f
Cred_2120 \$I66.P23.GatPoly vout.$1235.Metal4 0.00359882f
Cred_2121 \$I66.P23.GatPoly vout.$438.Metal2 8.91395e-05f
Cred_2122 \$I66.P23.GatPoly vout.$458.Metal2 8.89229e-05f
Cred_2123 \$I66.P23.GatPoly vout.$498.Metal2 8.53425e-05f
Cred_2124 \$I66.P23.GatPoly vout.$518.Metal2 6.70694e-05f
Cred_2125 \$I66.P23.GatPoly vout.$62.Metal1 0.0215488f
Cred_2126 \$I66.P23.GatPoly vout.$886.Metal3 3.05648e-07f
Cred_2127 \$I66.P23.GatPoly vout.P2.nSD 0.000236935f
Cred_2128 \$I66.P23.GatPoly vss 1.20254e-05f
Cred_2129 \$I66.P23.GatPoly vss.$1013.Metal4 8.35564e-06f
Cred_2130 \$I66.P23.GatPoly vss.$1211.Metal5 1.24019e-05f
Cred_2131 \$I66.P23.GatPoly vss.$1229.Metal5 1.24019e-05f
Cred_2132 \$I66.P23.GatPoly vss.$127.Metal1 4.90951e-05f
Cred_2133 \$I66.P23.GatPoly vss.$1281.Metal5 4.74719e-05f
Cred_2134 \$I66.P23.GatPoly vss.$1299.Metal5 4.74719e-05f
Cred_2135 \$I66.P23.GatPoly vss.$406.Metal1 3.35914e-05f
Cred_2136 \$I66.P23.GatPoly vss.$457.Metal2 7.17026e-07f
Cred_2137 \$I66.P23.GatPoly vss.$467.Metal2 0.00353994f
Cred_2138 \$I66.P23.GatPoly vss.$469.Metal2 0.0161331f
Cred_2139 \$I66.P23.GatPoly vss.$801.Metal3 0.000708654f
Cred_2140 \$I66.P23.GatPoly vss.$805.Metal3 0.000708654f
Cred_2141 \$I66.P23.GatPoly vss.P0.GatPoly 1.7552e-06f
Cred_2142 \$I66.P23.GatPoly vss.P0.pSD 0.000836047f
Cred_2143 \$I66.P23.GatPoly vss.P3.nSD 0.0155769f
Cred_2144 \$I66.P24.GatPoly \$I67.$82.Metal2 5.73152e-05f
Cred_2145 \$I66.P24.GatPoly vss 0.0235049f
Cred_2146 \$I66.P24.GatPoly vout.$12.Metal1 0.00903491f
Cred_2147 \$I66.P24.GatPoly vout.$122.Metal1 0.00483677f
Cred_2148 \$I66.P24.GatPoly vout.$123.Metal1 6.42284e-07f
Cred_2149 \$I66.P24.GatPoly vout.$1235.Metal4 0.00360125f
Cred_2150 \$I66.P24.GatPoly vout.$1236.Metal4 1.35863e-06f
Cred_2151 \$I66.P24.GatPoly vout.$438.Metal2 8.91395e-05f
Cred_2152 \$I66.P24.GatPoly vout.$458.Metal2 8.89229e-05f
Cred_2153 \$I66.P24.GatPoly vout.$498.Metal2 8.54008e-05f
Cred_2154 \$I66.P24.GatPoly vout.$500.Metal2 3.2308e-08f
Cred_2155 \$I66.P24.GatPoly vout.$518.Metal2 6.97404e-05f
Cred_2156 \$I66.P24.GatPoly vout.$520.Metal2 4.55974e-07f
Cred_2157 \$I66.P24.GatPoly vout.$62.Metal1 0.0221207f
Cred_2158 \$I66.P24.GatPoly vout.$886.Metal3 3.21262e-06f
Cred_2159 \$I66.P24.GatPoly vout.$888.Metal3 1.61182e-06f
Cred_2160 \$I66.P24.GatPoly vout.P2.nSD 0.000237548f
Cred_2161 \$I66.P24.GatPoly vout.P4.nSD 4.9636e-07f
Cred_2162 \$I66.P24.GatPoly vss 9.59421e-06f
Cred_2163 \$I66.P24.GatPoly vss.$1017.Metal4 1.1439e-05f
Cred_2164 \$I66.P24.GatPoly vss.$1211.Metal5 9.89459e-06f
Cred_2165 \$I66.P24.GatPoly vss.$1229.Metal5 9.89459e-06f
Cred_2166 \$I66.P24.GatPoly vss.$127.Metal1 4.35796e-05f
Cred_2167 \$I66.P24.GatPoly vss.$1281.Metal5 3.78744e-05f
Cred_2168 \$I66.P24.GatPoly vss.$1299.Metal5 3.78744e-05f
Cred_2169 \$I66.P24.GatPoly vss.$13.Metal1 0.000888102f
Cred_2170 \$I66.P24.GatPoly vss.$136.Metal1 0.000440198f
Cred_2171 \$I66.P24.GatPoly vss.$406.Metal1 3.95672e-05f
Cred_2172 \$I66.P24.GatPoly vss.$457.Metal2 6.36473e-07f
Cred_2173 \$I66.P24.GatPoly vss.$473.Metal2 0.0140269f
Cred_2174 \$I66.P24.GatPoly vss.$475.Metal2 0.0049275f
Cred_2175 \$I66.P24.GatPoly vss.$805.Metal3 0.000970159f
Cred_2176 \$I66.P24.GatPoly vss.$809.Metal3 0.000970581f
Cred_2177 \$I66.P24.GatPoly vss.P0.GatPoly 1.55801e-06f
Cred_2178 \$I66.P24.GatPoly vss.P0.pSD 0.00085953f
Cred_2179 \$I66.P24.GatPoly vss.P5.nSD 0.0143896f
Cred_2180 \$I66.P25.GatPoly \$I67.$82.Metal2 5.7535e-05f
Cred_2181 \$I66.P25.GatPoly vss 0.0235091f
Cred_2182 \$I66.P25.GatPoly vout.$122.Metal1 7.17938e-07f
Cred_2183 \$I66.P25.GatPoly vout.$123.Metal1 0.00474475f
Cred_2184 \$I66.P25.GatPoly vout.$1235.Metal4 1.21566e-06f
Cred_2185 \$I66.P25.GatPoly vout.$1236.Metal4 0.00360154f
Cred_2186 \$I66.P25.GatPoly vout.$13.Metal1 0.00903491f
Cred_2187 \$I66.P25.GatPoly vout.$440.Metal2 8.91395e-05f
Cred_2188 \$I66.P25.GatPoly vout.$460.Metal2 8.89229e-05f
Cred_2189 \$I66.P25.GatPoly vout.$498.Metal2 2.88213e-08f
Cred_2190 \$I66.P25.GatPoly vout.$500.Metal2 8.54071e-05f
Cred_2191 \$I66.P25.GatPoly vout.$518.Metal2 3.88506e-07f
Cred_2192 \$I66.P25.GatPoly vout.$520.Metal2 6.79815e-05f
Cred_2193 \$I66.P25.GatPoly vout.$63.Metal1 0.0221207f
Cred_2194 \$I66.P25.GatPoly vout.$886.Metal3 1.43787e-06f
Cred_2195 \$I66.P25.GatPoly vout.$888.Metal3 3.5299e-06f
Cred_2196 \$I66.P25.GatPoly vout.P2.nSD 3.0642e-07f
Cred_2197 \$I66.P25.GatPoly vout.P4.nSD 0.000237928f
Cred_2198 \$I66.P25.GatPoly vss 1.00147e-05f
Cred_2199 \$I66.P25.GatPoly vss.$1017.Metal4 2.46143e-09f
Cred_2200 \$I66.P25.GatPoly vss.$1211.Metal5 1.03283e-05f
Cred_2201 \$I66.P25.GatPoly vss.$1229.Metal5 1.03283e-05f
Cred_2202 \$I66.P25.GatPoly vss.$127.Metal1 3.85374e-05f
Cred_2203 \$I66.P25.GatPoly vss.$1281.Metal5 3.95345e-05f
Cred_2204 \$I66.P25.GatPoly vss.$1299.Metal5 3.95345e-05f
Cred_2205 \$I66.P25.GatPoly vss.$13.Metal1 0.000509276f
Cred_2206 \$I66.P25.GatPoly vss.$136.Metal1 0.00102738f
Cred_2207 \$I66.P25.GatPoly vss.$406.Metal1 4.3843e-05f
Cred_2208 \$I66.P25.GatPoly vss.$457.Metal2 5.62833e-07f
Cred_2209 \$I66.P25.GatPoly vss.$473.Metal2 0.0118592f
Cred_2210 \$I66.P25.GatPoly vss.$475.Metal2 0.00702968f
Cred_2211 \$I66.P25.GatPoly vss.$805.Metal3 2.08757e-07f
Cred_2212 \$I66.P25.GatPoly vss.$809.Metal3 0.0019634f
Cred_2213 \$I66.P25.GatPoly vss.P0.GatPoly 1.37775e-06f
Cred_2214 \$I66.P25.GatPoly vss.P0.pSD 0.000851512f
Cred_2215 \$I66.P25.GatPoly vss.P5.nSD 0.0143278f
Cred_2216 \$I66.P26.GatPoly \$I67.$82.Metal2 5.63573e-05f
Cred_2217 \$I66.P26.GatPoly vss 0.0234603f
Cred_2218 \$I66.P26.GatPoly vout.$123.Metal1 0.00475452f
Cred_2219 \$I66.P26.GatPoly vout.$1236.Metal4 0.00359882f
Cred_2220 \$I66.P26.GatPoly vout.$13.Metal1 0.00903491f
Cred_2221 \$I66.P26.GatPoly vout.$440.Metal2 8.91395e-05f
Cred_2222 \$I66.P26.GatPoly vout.$460.Metal2 8.89229e-05f
Cred_2223 \$I66.P26.GatPoly vout.$500.Metal2 8.53429e-05f
Cred_2224 \$I66.P26.GatPoly vout.$520.Metal2 6.83744e-05f
Cred_2225 \$I66.P26.GatPoly vout.$63.Metal1 0.0221207f
Cred_2226 \$I66.P26.GatPoly vout.$888.Metal3 3.26789e-07f
Cred_2227 \$I66.P26.GatPoly vout.P4.nSD 0.000236935f
Cred_2228 \$I66.P26.GatPoly vss 3.12599e-06f
Cred_2229 \$I66.P26.GatPoly vss.$1211.Metal5 3.22385e-06f
Cred_2230 \$I66.P26.GatPoly vss.$1229.Metal5 3.22385e-06f
Cred_2231 \$I66.P26.GatPoly vss.$127.Metal1 3.34518e-05f
Cred_2232 \$I66.P26.GatPoly vss.$1281.Metal5 1.23402e-05f
Cred_2233 \$I66.P26.GatPoly vss.$1299.Metal5 1.23402e-05f
Cred_2234 \$I66.P26.GatPoly vss.$136.Metal1 0.00166839f
Cred_2235 \$I66.P26.GatPoly vss.$406.Metal1 5.07077e-05f
Cred_2236 \$I66.P26.GatPoly vss.$457.Metal2 4.88558e-07f
Cred_2237 \$I66.P26.GatPoly vss.$475.Metal2 0.00285029f
Cred_2238 \$I66.P26.GatPoly vss.$479.Metal2 0.0158558f
Cred_2239 \$I66.P26.GatPoly vss.$811.Metal3 0.00199596f
Cred_2240 \$I66.P26.GatPoly vss.P0.GatPoly 1.19593e-06f
Cred_2241 \$I66.P26.GatPoly vss.P0.pSD 0.000846023f
Cred_2242 \$I66.P26.GatPoly vss.P7.nSD 0.0142499f
Cred_2243 \$I66.P27.GatPoly \$I67.$82.Metal2 7.74527e-05f
Cred_2244 \$I66.P27.GatPoly \$I67.P0.GatPoly 2.79044e-06f
Cred_2245 \$I66.P27.GatPoly \$I67.P3.GatPoly 2.55716e-07f
Cred_2246 \$I66.P27.GatPoly \$I67.P4.GatPoly 2.55492e-07f
Cred_2247 \$I66.P27.GatPoly vss 0.0235125f
Cred_2248 \$I66.P27.GatPoly vout.$1237.Metal4 0.00360392f
Cred_2249 \$I66.P27.GatPoly vout.$1238.Metal4 9.72699e-07f
Cred_2250 \$I66.P27.GatPoly vout.$124.Metal1 0.00483249f
Cred_2251 \$I66.P27.GatPoly vout.$125.Metal1 5.34927e-07f
Cred_2252 \$I66.P27.GatPoly vout.$1299.Metal4 1.39073e-06f
Cred_2253 \$I66.P27.GatPoly vout.$14.Metal1 0.00903491f
Cred_2254 \$I66.P27.GatPoly vout.$442.Metal2 8.91395e-05f
Cred_2255 \$I66.P27.GatPoly vout.$462.Metal2 8.89229e-05f
Cred_2256 \$I66.P27.GatPoly vout.$502.Metal2 8.5461e-05f
Cred_2257 \$I66.P27.GatPoly vout.$504.Metal2 2.45257e-08f
Cred_2258 \$I66.P27.GatPoly vout.$522.Metal2 6.85752e-05f
Cred_2259 \$I66.P27.GatPoly vout.$524.Metal2 3.04777e-07f
Cred_2260 \$I66.P27.GatPoly vout.$64.Metal1 0.0221207f
Cred_2261 \$I66.P27.GatPoly vout.$890.Metal3 6.21829e-06f
Cred_2262 \$I66.P27.GatPoly vout.$892.Metal3 1.22357e-06f
Cred_2263 \$I66.P27.GatPoly vout.P6.nSD 0.000238512f
Cred_2264 \$I66.P27.GatPoly vout.P8.nSD 3.72106e-07f
Cred_2265 \$I66.P27.GatPoly vref 4.67082e-07f
Cred_2266 \$I66.P27.GatPoly vref.P0.GatPoly 1.82136e-08f
Cred_2267 \$I66.P27.GatPoly vref.P0.nSD 1.27075e-07f
Cred_2268 \$I66.P27.GatPoly vref.P0.pSD 1.83008e-07f
Cred_2269 \$I66.P27.GatPoly vss 1.00987e-05f
Cred_2270 \$I66.P27.GatPoly vss.$1023.Metal4 9.24021e-06f
Cred_2271 \$I66.P27.GatPoly vss.$1027.Metal4 3.57764e-09f
Cred_2272 \$I66.P27.GatPoly vss.$1211.Metal5 1.04148e-05f
Cred_2273 \$I66.P27.GatPoly vss.$1229.Metal5 1.04148e-05f
Cred_2274 \$I66.P27.GatPoly vss.$127.Metal1 2.98742e-05f
Cred_2275 \$I66.P27.GatPoly vss.$1281.Metal5 4.25589e-05f
Cred_2276 \$I66.P27.GatPoly vss.$1299.Metal5 3.98658e-05f
Cred_2277 \$I66.P27.GatPoly vss.$136.Metal1 0.000538835f
Cred_2278 \$I66.P27.GatPoly vss.$138.Metal1 0.000516766f
Cred_2279 \$I66.P27.GatPoly vss.$140.Metal1 2.1069e-07f
Cred_2280 \$I66.P27.GatPoly vss.$406.Metal1 5.72864e-05f
Cred_2281 \$I66.P27.GatPoly vss.$457.Metal2 4.36309e-07f
Cred_2282 \$I66.P27.GatPoly vss.$475.Metal2 0.00188404f
Cred_2283 \$I66.P27.GatPoly vss.$479.Metal2 0.0171749f
Cred_2284 \$I66.P27.GatPoly vss.$483.Metal2 2.4395e-06f
Cred_2285 \$I66.P27.GatPoly vss.$487.Metal2 3.99257e-07f
Cred_2286 \$I66.P27.GatPoly vss.$811.Metal3 0.000805891f
Cred_2287 \$I66.P27.GatPoly vss.$815.Metal3 0.000784316f
Cred_2288 \$I66.P27.GatPoly vss.$819.Metal3 6.15077e-07f
Cred_2289 \$I66.P27.GatPoly vss.P0.GatPoly 1.06803e-06f
Cred_2290 \$I66.P27.GatPoly vss.P0.pSD 0.000847842f
Cred_2291 \$I66.P27.GatPoly vss.P10.nSD 1.64718e-06f
Cred_2292 \$I66.P27.GatPoly vss.P7.nSD 0.0149235f
Cred_2293 \$I66.P28.GatPoly \$I67.$82.Metal2 0.000121681f
Cred_2294 \$I66.P28.GatPoly \$I67.P0.GatPoly 9.64288e-06f
Cred_2295 \$I66.P28.GatPoly \$I67.P3.GatPoly 8.7921e-07f
Cred_2296 \$I66.P28.GatPoly \$I67.P4.GatPoly 8.79061e-07f
Cred_2297 \$I66.P28.GatPoly vss 0.0234824f
Cred_2298 \$I66.P28.GatPoly vout.$1237.Metal4 0.00360516f
Cred_2299 \$I66.P28.GatPoly vout.$1238.Metal4 1.94577e-06f
Cred_2300 \$I66.P28.GatPoly vout.$124.Metal1 0.00483855f
Cred_2301 \$I66.P28.GatPoly vout.$125.Metal1 1.07006e-06f
Cred_2302 \$I66.P28.GatPoly vout.$1299.Metal4 9.26858e-07f
Cred_2303 \$I66.P28.GatPoly vout.$14.Metal1 0.00903491f
Cred_2304 \$I66.P28.GatPoly vout.$442.Metal2 8.91395e-05f
Cred_2305 \$I66.P28.GatPoly vout.$462.Metal2 8.89229e-05f
Cred_2306 \$I66.P28.GatPoly vout.$502.Metal2 8.54798e-05f
Cred_2307 \$I66.P28.GatPoly vout.$504.Metal2 4.90607e-08f
Cred_2308 \$I66.P28.GatPoly vout.$522.Metal2 7.07439e-05f
Cred_2309 \$I66.P28.GatPoly vout.$524.Metal2 6.09669e-07f
Cred_2310 \$I66.P28.GatPoly vout.$64.Metal1 0.0221207f
Cred_2311 \$I66.P28.GatPoly vout.$890.Metal3 7.15314e-06f
Cred_2312 \$I66.P28.GatPoly vout.$892.Metal3 2.4476e-06f
Cred_2313 \$I66.P28.GatPoly vout.P6.nSD 0.000238599f
Cred_2314 \$I66.P28.GatPoly vout.P8.nSD 7.44353e-07f
Cred_2315 \$I66.P28.GatPoly vref 3.1129e-07f
Cred_2316 \$I66.P28.GatPoly vref.P0.GatPoly 1.21386e-08f
Cred_2317 \$I66.P28.GatPoly vref.P0.nSD 8.46897e-08f
Cred_2318 \$I66.P28.GatPoly vref.P0.pSD 1.21967e-07f
Cred_2319 \$I66.P28.GatPoly vss 5.58563e-06f
Cred_2320 \$I66.P28.GatPoly vss.$1023.Metal4 3.35048e-09f
Cred_2321 \$I66.P28.GatPoly vss.$1027.Metal4 1.10014e-05f
Cred_2322 \$I66.P28.GatPoly vss.$1211.Metal5 5.7605e-06f
Cred_2323 \$I66.P28.GatPoly vss.$1229.Metal5 5.7605e-06f
Cred_2324 \$I66.P28.GatPoly vss.$127.Metal1 2.64147e-05f
Cred_2325 \$I66.P28.GatPoly vss.$1281.Metal5 6.63436e-05f
Cred_2326 \$I66.P28.GatPoly vss.$1299.Metal5 2.205e-05f
Cred_2327 \$I66.P28.GatPoly vss.$136.Metal1 1.84845e-09f
Cred_2328 \$I66.P28.GatPoly vss.$138.Metal1 0.00064368f
Cred_2329 \$I66.P28.GatPoly vss.$140.Metal1 0.000670407f
Cred_2330 \$I66.P28.GatPoly vss.$406.Metal1 6.68441e-05f
Cred_2331 \$I66.P28.GatPoly vss.$457.Metal2 3.85783e-07f
Cred_2332 \$I66.P28.GatPoly vss.$475.Metal2 1.5677e-07f
Cred_2333 \$I66.P28.GatPoly vss.$479.Metal2 1.75064e-06f
Cred_2334 \$I66.P28.GatPoly vss.$483.Metal2 0.016717f
Cred_2335 \$I66.P28.GatPoly vss.$487.Metal2 0.00224968f
Cred_2336 \$I66.P28.GatPoly vss.$811.Metal3 2.86008e-07f
Cred_2337 \$I66.P28.GatPoly vss.$815.Metal3 0.000933556f
Cred_2338 \$I66.P28.GatPoly vss.$819.Metal3 0.000960187f
Cred_2339 \$I66.P28.GatPoly vss.P0.GatPoly 9.44352e-07f
Cred_2340 \$I66.P28.GatPoly vss.P0.pSD 0.000855952f
Cred_2341 \$I66.P28.GatPoly vss.P10.nSD 0.014531f
Cred_2342 \$I66.P28.GatPoly vss.P7.nSD 1.26838e-06f
Cred_2343 \$I66.P29.GatPoly \$I67.$82.Metal2 0.000119851f
Cred_2344 \$I66.P29.GatPoly \$I67.P0.GatPoly 9.57432e-06f
Cred_2345 \$I66.P29.GatPoly \$I67.P3.GatPoly 8.72433e-07f
Cred_2346 \$I66.P29.GatPoly \$I67.P4.GatPoly 8.72358e-07f
Cred_2347 \$I66.P29.GatPoly vss 0.0234596f
Cred_2348 \$I66.P29.GatPoly vout.$1237.Metal4 3.17091e-06f
Cred_2349 \$I66.P29.GatPoly vout.$1238.Metal4 0.00360174f
Cred_2350 \$I66.P29.GatPoly vout.$124.Metal1 1.61159e-06f
Cred_2351 \$I66.P29.GatPoly vout.$125.Metal1 0.00483142f
Cred_2352 \$I66.P29.GatPoly vout.$1299.Metal4 4.63341e-07f
Cred_2353 \$I66.P29.GatPoly vout.$15.Metal1 0.00903491f
Cred_2354 \$I66.P29.GatPoly vout.$444.Metal2 8.91395e-05f
Cred_2355 \$I66.P29.GatPoly vout.$464.Metal2 8.89229e-05f
Cred_2356 \$I66.P29.GatPoly vout.$502.Metal2 6.83066e-08f
Cred_2357 \$I66.P29.GatPoly vout.$504.Metal2 8.54161e-05f
Cred_2358 \$I66.P29.GatPoly vout.$522.Metal2 8.90198e-07f
Cred_2359 \$I66.P29.GatPoly vout.$524.Metal2 6.79842e-05f
Cred_2360 \$I66.P29.GatPoly vout.$65.Metal1 0.0221207f
Cred_2361 \$I66.P29.GatPoly vout.$890.Metal3 3.40776e-06f
Cred_2362 \$I66.P29.GatPoly vout.$892.Metal3 3.9782e-06f
Cred_2363 \$I66.P29.GatPoly vout.P6.nSD 8.31621e-07f
Cred_2364 \$I66.P29.GatPoly vout.P8.nSD 0.000238052f
Cred_2365 \$I66.P29.GatPoly vref 1.55616e-07f
Cred_2366 \$I66.P29.GatPoly vref.P0.GatPoly 6.06813e-09f
Cred_2367 \$I66.P29.GatPoly vref.P0.nSD 4.23368e-08f
Cred_2368 \$I66.P29.GatPoly vref.P0.pSD 6.09717e-08f
Cred_2369 \$I66.P29.GatPoly vss 4.80298e-06f
Cred_2370 \$I66.P29.GatPoly vss.$1023.Metal4 1.67492e-09f
Cred_2371 \$I66.P29.GatPoly vss.$1027.Metal4 3.57764e-09f
Cred_2372 \$I66.P29.GatPoly vss.$1211.Metal5 4.95335e-06f
Cred_2373 \$I66.P29.GatPoly vss.$1229.Metal5 4.95335e-06f
Cred_2374 \$I66.P29.GatPoly vss.$127.Metal1 2.32321e-05f
Cred_2375 \$I66.P29.GatPoly vss.$1281.Metal5 6.29252e-05f
Cred_2376 \$I66.P29.GatPoly vss.$1299.Metal5 1.89604e-05f
Cred_2377 \$I66.P29.GatPoly vss.$136.Metal1 9.2405e-10f
Cred_2378 \$I66.P29.GatPoly vss.$138.Metal1 9.01921e-08f
Cred_2379 \$I66.P29.GatPoly vss.$140.Metal1 0.00158816f
Cred_2380 \$I66.P29.GatPoly vss.$406.Metal1 7.35611e-05f
Cred_2381 \$I66.P29.GatPoly vss.$457.Metal2 3.39301e-07f
Cred_2382 \$I66.P29.GatPoly vss.$475.Metal2 7.83701e-08f
Cred_2383 \$I66.P29.GatPoly vss.$479.Metal2 8.75157e-07f
Cred_2384 \$I66.P29.GatPoly vss.$483.Metal2 0.0155277f
Cred_2385 \$I66.P29.GatPoly vss.$487.Metal2 0.00326494f
Cred_2386 \$I66.P29.GatPoly vss.$811.Metal3 1.42977e-07f
Cred_2387 \$I66.P29.GatPoly vss.$815.Metal3 5.57537e-07f
Cred_2388 \$I66.P29.GatPoly vss.$819.Metal3 0.00200207f
Cred_2389 \$I66.P29.GatPoly vss.P0.GatPoly 8.30569e-07f
Cred_2390 \$I66.P29.GatPoly vss.P0.pSD 0.000835038f
Cred_2391 \$I66.P29.GatPoly vss.P10.nSD 0.0143404f
Cred_2392 \$I66.P29.GatPoly vss.P7.nSD 6.34069e-07f
Cred_2393 \$I66.P3.GatPoly \$I67.$82.Metal2 3.5743e-05f
Cred_2394 \$I66.P3.GatPoly \$I78 0.0194368f
Cred_2395 \$I66.P3.GatPoly vss 0.000245009f
Cred_2396 \$I66.P3.GatPoly vdd.$2365.Metal1 2.84702e-05f
Cred_2397 \$I66.P3.GatPoly vdd.$2370.Metal1 0.000527076f
Cred_2398 \$I66.P3.GatPoly vdd.$2372.Metal1 0.000500179f
Cred_2399 \$I66.P3.GatPoly vdd.$2399.Metal1 1.84666e-06f
Cred_2400 \$I66.P3.GatPoly vdd.$2747.Metal2 1.69787e-06f
Cred_2401 \$I66.P3.GatPoly vdd.$2749.Metal2 1.30365e-06f
Cred_2402 \$I66.P3.GatPoly vdd.$2751.Metal2 0.00228314f
Cred_2403 \$I66.P3.GatPoly vdd.$2755.Metal2 0.023846f
Cred_2404 \$I66.P3.GatPoly vdd.$2759.Metal2 1.53166e-06f
Cred_2405 \$I66.P3.GatPoly vdd.$2761.Metal2 6.33791e-07f
Cred_2406 \$I66.P3.GatPoly vdd.$2983.Metal3 3.55706e-07f
Cred_2407 \$I66.P3.GatPoly vdd.$2987.Metal3 0.000981188f
Cred_2408 \$I66.P3.GatPoly vdd.$2991.Metal3 0.000953119f
Cred_2409 \$I66.P3.GatPoly vdd.$2993.Metal3 4.5895e-07f
Cred_2410 \$I66.P3.GatPoly vdd.$3219.Metal4 4.19408e-09f
Cred_2411 \$I66.P3.GatPoly vdd.$3223.Metal4 1.12381e-05f
Cred_2412 \$I66.P3.GatPoly vdd.P0.nSD 0.000754598f
Cred_2413 \$I66.P3.GatPoly vdd.P0.pSD 1.48252e-06f
Cred_2414 \$I66.P3.GatPoly vdd.P1.GatPoly 7.04586e-06f
Cred_2415 \$I66.P3.GatPoly vdd.P1.pSD 3.28524e-06f
Cred_2416 \$I66.P3.GatPoly vdd.P2.GatPoly 8.21368e-08f
Cred_2417 \$I66.P3.GatPoly vdd.P3.pSD 0.0340118f
Cred_2418 \$I66.P3.GatPoly vdd.P5.pSD 3.34996e-06f
Cred_2419 \$I66.P3.GatPoly vout.$1032.Metal3 7.68135e-06f
Cred_2420 \$I66.P3.GatPoly vout.$1034.Metal3 5.95962e-06f
Cred_2421 \$I66.P3.GatPoly vout.$1112.Metal3 4.01743e-09f
Cred_2422 \$I66.P3.GatPoly vout.$1152.Metal3 9.51082e-09f
Cred_2423 \$I66.P3.GatPoly vout.$1154.Metal3 2.60128e-07f
Cred_2424 \$I66.P3.GatPoly vout.$1328.Metal4 2.67063e-06f
Cred_2425 \$I66.P3.GatPoly vout.$1329.Metal4 2.02294e-06f
Cred_2426 \$I66.P3.GatPoly vout.$1368.Metal4 8.77599e-08f
Cred_2427 \$I66.P3.GatPoly vout.$1369.Metal4 0.0256056f
Cred_2428 \$I66.P3.GatPoly vout.$1408.Metal4 1.11158e-06f
Cred_2429 \$I66.P3.GatPoly vout.$156.Metal1 8.86402e-06f
Cred_2430 \$I66.P3.GatPoly vout.$157.Metal1 0.00143418f
Cred_2431 \$I66.P3.GatPoly vout.$206.Metal1 3.22323e-06f
Cred_2432 \$I66.P3.GatPoly vout.$207.Metal1 0.00551577f
Cred_2433 \$I66.P3.GatPoly vout.$227.Metal1 0.00600163f
Cred_2434 \$I66.P3.GatPoly vout.$267.Metal1 0.00596824f
Cred_2435 \$I66.P3.GatPoly vout.$287.Metal1 0.00596897f
Cred_2436 \$I66.P3.GatPoly vout.$327.Metal1 0.00600124f
Cred_2437 \$I66.P3.GatPoly vout.$347.Metal1 0.00792118f
Cred_2438 \$I66.P3.GatPoly vout.$397.Metal1 0.00871131f
Cred_2439 \$I66.P3.GatPoly vout.$584.Metal2 2.24889e-06f
Cred_2440 \$I66.P3.GatPoly vout.$586.Metal2 2.17328e-05f
Cred_2441 \$I66.P3.GatPoly vout.$604.Metal2 2.24348e-07f
Cred_2442 \$I66.P3.GatPoly vout.$606.Metal2 3.27934e-05f
Cred_2443 \$I66.P3.GatPoly vout.$646.Metal2 1.8244e-05f
Cred_2444 \$I66.P3.GatPoly vout.$666.Metal2 3.60091e-05f
Cred_2445 \$I66.P3.GatPoly vout.$686.Metal2 1.04364e-05f
Cred_2446 \$I66.P3.GatPoly vout.$706.Metal2 3.55883e-05f
Cred_2447 \$I66.P3.GatPoly vout.$724.Metal2 4.20881e-11f
Cred_2448 \$I66.P3.GatPoly vout.$726.Metal2 1.93601e-05f
Cred_2449 \$I66.P3.GatPoly vout.$766.Metal2 8.46505e-05f
Cred_2450 \$I66.P3.GatPoly vout.$786.Metal2 8.72673e-05f
Cred_2451 \$I66.P3.GatPoly vout.P0.pSD 3.71561e-06f
Cred_2452 \$I66.P3.GatPoly vout.P2.pSD 0.000198348f
Cred_2453 \$I66.P3.GatPoly vss 0.000456016f
Cred_2454 \$I66.P3.GatPoly vss.$1211.Metal5 0.000169142f
Cred_2455 \$I66.P3.GatPoly vss.$1229.Metal5 0.000169142f
Cred_2456 \$I66.P3.GatPoly vss.$1281.Metal5 0.00064744f
Cred_2457 \$I66.P3.GatPoly vss.$1299.Metal5 0.00064744f
Cred_2458 \$I66.P30.GatPoly \$I67.$82.Metal2 0.0164758f
Cred_2459 \$I66.P30.GatPoly \$I67.P0.GatPoly 0.00132701f
Cred_2460 \$I66.P30.GatPoly \$I67.P3.GatPoly 0.0795269f
Cred_2461 \$I66.P30.GatPoly \$I67.P4.GatPoly 0.000185625f
Cred_2462 \$I66.P30.GatPoly vss 0.0232991f
Cred_2463 \$I66.P30.GatPoly vout.$1238.Metal4 0.00350137f
Cred_2464 \$I66.P30.GatPoly vout.$125.Metal1 0.0048068f
Cred_2465 \$I66.P30.GatPoly vout.$15.Metal1 0.00903491f
Cred_2466 \$I66.P30.GatPoly vout.$444.Metal2 8.91395e-05f
Cred_2467 \$I66.P30.GatPoly vout.$464.Metal2 8.89229e-05f
Cred_2468 \$I66.P30.GatPoly vout.$504.Metal2 8.53431e-05f
Cred_2469 \$I66.P30.GatPoly vout.$524.Metal2 6.87553e-05f
Cred_2470 \$I66.P30.GatPoly vout.$65.Metal1 0.0206248f
Cred_2471 \$I66.P30.GatPoly vout.$892.Metal3 3.3296e-07f
Cred_2472 \$I66.P30.GatPoly vout.P8.nSD 0.000236935f
Cred_2473 \$I66.P30.GatPoly vss 3.14768e-06f
Cred_2474 \$I66.P30.GatPoly vss.$1211.Metal5 3.24623e-06f
Cred_2475 \$I66.P30.GatPoly vss.$1229.Metal5 3.24623e-06f
Cred_2476 \$I66.P30.GatPoly vss.$127.Metal1 2.02615e-05f
Cred_2477 \$I66.P30.GatPoly vss.$1281.Metal5 4.88391e-05f
Cred_2478 \$I66.P30.GatPoly vss.$1299.Metal5 1.24259e-05f
Cred_2479 \$I66.P30.GatPoly vss.$140.Metal1 0.000999504f
Cred_2480 \$I66.P30.GatPoly vss.$143.Metal1 0.000495409f
Cred_2481 \$I66.P30.GatPoly vss.$406.Metal1 8.50809e-05f
Cred_2482 \$I66.P30.GatPoly vss.$457.Metal2 2.95917e-07f
Cred_2483 \$I66.P30.GatPoly vss.$487.Metal2 0.00605361f
Cred_2484 \$I66.P30.GatPoly vss.$489.Metal2 0.0122528f
Cred_2485 \$I66.P30.GatPoly vss.$821.Metal3 0.00196235f
Cred_2486 \$I66.P30.GatPoly vss.P0.GatPoly 7.24369e-07f
Cred_2487 \$I66.P30.GatPoly vss.P0.pSD 0.000832976f
Cred_2488 \$I66.P30.GatPoly vss.P11.nSD 0.0138432f
Cred_2489 \$I66.P31.GatPoly \$I67.$82.Metal2 0.0166508f
Cred_2490 \$I66.P31.GatPoly \$I67.P0.GatPoly 0.00134124f
Cred_2491 \$I66.P31.GatPoly \$I67.P3.GatPoly 0.00018755f
Cred_2492 \$I66.P31.GatPoly \$I67.P4.GatPoly 0.079536f
Cred_2493 \$I66.P31.GatPoly vss 0.0234169f
Cred_2494 \$I66.P31.GatPoly vout.$1239.Metal4 0.00189118f
Cred_2495 \$I66.P31.GatPoly vout.$126.Metal1 0.00481348f
Cred_2496 \$I66.P31.GatPoly vout.$1269.Metal4 0.00164987f
Cred_2497 \$I66.P31.GatPoly vout.$127.Metal1 1.07354e-06f
Cred_2498 \$I66.P31.GatPoly vout.$1299.Metal4 5.54242e-05f
Cred_2499 \$I66.P31.GatPoly vout.$16.Metal1 0.00903491f
Cred_2500 \$I66.P31.GatPoly vout.$446.Metal2 8.91395e-05f
Cred_2501 \$I66.P31.GatPoly vout.$466.Metal2 8.89229e-05f
Cred_2502 \$I66.P31.GatPoly vout.$506.Metal2 8.53418e-05f
Cred_2503 \$I66.P31.GatPoly vout.$526.Metal2 7.08167e-05f
Cred_2504 \$I66.P31.GatPoly vout.$528.Metal2 4.14857e-07f
Cred_2505 \$I66.P31.GatPoly vout.$66.Metal1 0.0206888f
Cred_2506 \$I66.P31.GatPoly vout.$894.Metal3 2.71248e-07f
Cred_2507 \$I66.P31.GatPoly vout.$934.Metal3 1.25286e-05f
Cred_2508 \$I66.P31.GatPoly vout.$936.Metal3 2.63304e-06f
Cred_2509 \$I66.P31.GatPoly vout.P10.nSD 0.00023966f
Cred_2510 \$I66.P31.GatPoly vout.P12.nSD 4.59225e-07f
Cred_2511 \$I66.P31.GatPoly vref 3.98545e-05f
Cred_2512 \$I66.P31.GatPoly vref.P0.GatPoly 1.53939e-06f
Cred_2513 \$I66.P31.GatPoly vref.P0.nSD 1.03884e-05f
Cred_2514 \$I66.P31.GatPoly vref.P0.pSD 1.01285e-05f
Cred_2515 \$I66.P31.GatPoly vss 3.71412e-06f
Cred_2516 \$I66.P31.GatPoly vss.$1037.Metal4 1.39681e-08f
Cred_2517 \$I66.P31.GatPoly vss.$1043.Metal4 3.57539e-09f
Cred_2518 \$I66.P31.GatPoly vss.$1211.Metal5 3.8304e-06f
Cred_2519 \$I66.P31.GatPoly vss.$1229.Metal5 3.8304e-06f
Cred_2520 \$I66.P31.GatPoly vss.$127.Metal1 1.40996e-05f
Cred_2521 \$I66.P31.GatPoly vss.$1281.Metal5 1.4662e-05f
Cred_2522 \$I66.P31.GatPoly vss.$1299.Metal5 7.0713e-05f
Cred_2523 \$I66.P31.GatPoly vss.$143.Metal1 0.000495635f
Cred_2524 \$I66.P31.GatPoly vss.$146.Metal1 0.00100053f
Cred_2525 \$I66.P31.GatPoly vss.$148.Metal1 9.01353e-08f
Cred_2526 \$I66.P31.GatPoly vss.$406.Metal1 0.000125581f
Cred_2527 \$I66.P31.GatPoly vss.$457.Metal2 2.05923e-07f
Cred_2528 \$I66.P31.GatPoly vss.$493.Metal2 0.0123298f
Cred_2529 \$I66.P31.GatPoly vss.$495.Metal2 0.00608057f
Cred_2530 \$I66.P31.GatPoly vss.$499.Metal2 5.4605e-06f
Cred_2531 \$I66.P31.GatPoly vss.$825.Metal3 1.79858e-06f
Cred_2532 \$I66.P31.GatPoly vss.$829.Metal3 0.00196532f
Cred_2533 \$I66.P31.GatPoly vss.$831.Metal3 1.5443e-06f
Cred_2534 \$I66.P31.GatPoly vss.$835.Metal3 3.03234e-07f
Cred_2535 \$I66.P31.GatPoly vss.P0.GatPoly 5.04075e-07f
Cred_2536 \$I66.P31.GatPoly vss.P0.pSD 0.000815598f
Cred_2537 \$I66.P31.GatPoly vss.P13.nSD 0.0139288f
Cred_2538 \$I66.P31.GatPoly vss.P15.nSD 3.40583e-06f
Cred_2539 \$I66.P32.GatPoly \$I67.$82.Metal2 0.000234825f
Cred_2540 \$I66.P32.GatPoly \$I67.P0.GatPoly 1.9097e-05f
Cred_2541 \$I66.P32.GatPoly \$I67.P3.GatPoly 2.14975e-06f
Cred_2542 \$I66.P32.GatPoly \$I67.P4.GatPoly 6.92221e-06f
Cred_2543 \$I66.P32.GatPoly vss 0.023513f
Cred_2544 \$I66.P32.GatPoly vout.$1239.Metal4 0.00185465f
Cred_2545 \$I66.P32.GatPoly vout.$126.Metal1 0.00483407f
Cred_2546 \$I66.P32.GatPoly vout.$1269.Metal4 0.000244415f
Cred_2547 \$I66.P32.GatPoly vout.$127.Metal1 1.4318e-06f
Cred_2548 \$I66.P32.GatPoly vout.$1299.Metal4 0.000122557f
Cred_2549 \$I66.P32.GatPoly vout.$16.Metal1 0.00903491f
Cred_2550 \$I66.P32.GatPoly vout.$446.Metal2 8.91395e-05f
Cred_2551 \$I66.P32.GatPoly vout.$466.Metal2 8.89229e-05f
Cred_2552 \$I66.P32.GatPoly vout.$506.Metal2 8.53418e-05f
Cred_2553 \$I66.P32.GatPoly vout.$526.Metal2 6.89806e-05f
Cred_2554 \$I66.P32.GatPoly vout.$528.Metal2 5.533e-07f
Cred_2555 \$I66.P32.GatPoly vout.$66.Metal1 0.022091f
Cred_2556 \$I66.P32.GatPoly vout.$894.Metal3 2.71248e-07f
Cred_2557 \$I66.P32.GatPoly vout.$934.Metal3 1.15047e-05f
Cred_2558 \$I66.P32.GatPoly vout.$936.Metal3 3.51172e-06f
Cred_2559 \$I66.P32.GatPoly vout.P10.nSD 0.000239364f
Cred_2560 \$I66.P32.GatPoly vout.P12.nSD 6.12474e-07f
Cred_2561 \$I66.P32.GatPoly vref 3.00326e-05f
Cred_2562 \$I66.P32.GatPoly vref.P0.GatPoly 1.15803e-06f
Cred_2563 \$I66.P32.GatPoly vref.P0.nSD 7.0033e-06f
Cred_2564 \$I66.P32.GatPoly vref.P0.pSD 6.89021e-06f
Cred_2565 \$I66.P32.GatPoly vss 3.77507e-07f
Cred_2566 \$I66.P32.GatPoly vss.$1037.Metal4 9.30911e-09f
Cred_2567 \$I66.P32.GatPoly vss.$1043.Metal4 4.76853e-09f
Cred_2568 \$I66.P32.GatPoly vss.$1211.Metal5 3.89325e-07f
Cred_2569 \$I66.P32.GatPoly vss.$1229.Metal5 3.89325e-07f
Cred_2570 \$I66.P32.GatPoly vss.$127.Metal1 1.20872e-05f
Cred_2571 \$I66.P32.GatPoly vss.$1281.Metal5 1.49026e-06f
Cred_2572 \$I66.P32.GatPoly vss.$1299.Metal5 1.4578e-05f
Cred_2573 \$I66.P32.GatPoly vss.$143.Metal1 1.508e-07f
Cred_2574 \$I66.P32.GatPoly vss.$146.Metal1 0.00158902f
Cred_2575 \$I66.P32.GatPoly vss.$148.Metal1 1.20214e-07f
Cred_2576 \$I66.P32.GatPoly vss.$406.Metal1 0.00014232f
Cred_2577 \$I66.P32.GatPoly vss.$457.Metal2 1.76532e-07f
Cred_2578 \$I66.P32.GatPoly vss.$493.Metal2 4.00432e-06f
Cred_2579 \$I66.P32.GatPoly vss.$495.Metal2 0.00328875f
Cred_2580 \$I66.P32.GatPoly vss.$499.Metal2 0.015669f
Cred_2581 \$I66.P32.GatPoly vss.$825.Metal3 1.19868e-06f
Cred_2582 \$I66.P32.GatPoly vss.$829.Metal3 1.97802e-06f
Cred_2583 \$I66.P32.GatPoly vss.$831.Metal3 0.00200315f
Cred_2584 \$I66.P32.GatPoly vss.$835.Metal3 4.04427e-07f
Cred_2585 \$I66.P32.GatPoly vss.P0.GatPoly 4.32128e-07f
Cred_2586 \$I66.P32.GatPoly vss.P0.pSD 0.000788762f
Cred_2587 \$I66.P32.GatPoly vss.P13.nSD 3.44492e-06f
Cred_2588 \$I66.P32.GatPoly vss.P15.nSD 0.0144791f
Cred_2589 \$I66.P33.GatPoly \$I67.$82.Metal2 0.000224025f
Cred_2590 \$I66.P33.GatPoly \$I67.P0.GatPoly 2.98997e-05f
Cred_2591 \$I66.P33.GatPoly \$I67.P3.GatPoly 1.85681e-06f
Cred_2592 \$I66.P33.GatPoly \$I67.P4.GatPoly 4.24259e-06f
Cred_2593 \$I66.P33.GatPoly vss 0.0234237f
Cred_2594 \$I66.P33.GatPoly vout.$1239.Metal4 1.30588e-06f
Cred_2595 \$I66.P33.GatPoly vout.$1240.Metal4 0.00185203f
Cred_2596 \$I66.P33.GatPoly vout.$126.Metal1 2.46277e-06f
Cred_2597 \$I66.P33.GatPoly vout.$1269.Metal4 0.000237662f
Cred_2598 \$I66.P33.GatPoly vout.$127.Metal1 0.00483646f
Cred_2599 \$I66.P33.GatPoly vout.$1299.Metal4 0.000102504f
Cred_2600 \$I66.P33.GatPoly vout.$17.Metal1 0.00903491f
Cred_2601 \$I66.P33.GatPoly vout.$448.Metal2 8.91395e-05f
Cred_2602 \$I66.P33.GatPoly vout.$468.Metal2 8.89229e-05f
Cred_2603 \$I66.P33.GatPoly vout.$508.Metal2 8.53418e-05f
Cred_2604 \$I66.P33.GatPoly vout.$526.Metal2 9.56783e-07f
Cred_2605 \$I66.P33.GatPoly vout.$528.Metal2 6.96452e-05f
Cred_2606 \$I66.P33.GatPoly vout.$67.Metal1 0.022091f
Cred_2607 \$I66.P33.GatPoly vout.$896.Metal3 2.71248e-07f
Cred_2608 \$I66.P33.GatPoly vout.$934.Metal3 5.73082e-06f
Cred_2609 \$I66.P33.GatPoly vout.$936.Metal3 4.46895e-06f
Cred_2610 \$I66.P33.GatPoly vout.P10.nSD 1.21403e-06f
Cred_2611 \$I66.P33.GatPoly vout.P12.nSD 0.000237701f
Cred_2612 \$I66.P33.GatPoly vref 1.67495e-05f
Cred_2613 \$I66.P33.GatPoly vref.P0.GatPoly 6.44965e-07f
Cred_2614 \$I66.P33.GatPoly vref.P0.nSD 3.54094e-06f
Cred_2615 \$I66.P33.GatPoly vref.P0.pSD 3.51448e-06f
Cred_2616 \$I66.P33.GatPoly vss 1.88718e-07f
Cred_2617 \$I66.P33.GatPoly vss.$1037.Metal4 4.65368e-09f
Cred_2618 \$I66.P33.GatPoly vss.$1043.Metal4 1.10002e-05f
Cred_2619 \$I66.P33.GatPoly vss.$1211.Metal5 1.94626e-07f
Cred_2620 \$I66.P33.GatPoly vss.$1229.Metal5 1.94626e-07f
Cred_2621 \$I66.P33.GatPoly vss.$127.Metal1 1.09302e-05f
Cred_2622 \$I66.P33.GatPoly vss.$1281.Metal5 7.44988e-07f
Cred_2623 \$I66.P33.GatPoly vss.$1299.Metal5 7.2876e-06f
Cred_2624 \$I66.P33.GatPoly vss.$143.Metal1 7.53857e-08f
Cred_2625 \$I66.P33.GatPoly vss.$146.Metal1 0.000670858f
Cred_2626 \$I66.P33.GatPoly vss.$148.Metal1 0.000643649f
Cred_2627 \$I66.P33.GatPoly vss.$406.Metal1 0.000161797f
Cred_2628 \$I66.P33.GatPoly vss.$457.Metal2 1.59634e-07f
Cred_2629 \$I66.P33.GatPoly vss.$493.Metal2 2.00178e-06f
Cred_2630 \$I66.P33.GatPoly vss.$495.Metal2 0.00227201f
Cred_2631 \$I66.P33.GatPoly vss.$499.Metal2 0.0168557f
Cred_2632 \$I66.P33.GatPoly vss.$825.Metal3 5.99224e-07f
Cred_2633 \$I66.P33.GatPoly vss.$829.Metal3 9.88823e-07f
Cred_2634 \$I66.P33.GatPoly vss.$831.Metal3 0.000960542f
Cred_2635 \$I66.P33.GatPoly vss.$835.Metal3 0.000932947f
Cred_2636 \$I66.P33.GatPoly vss.P0.GatPoly 3.90765e-07f
Cred_2637 \$I66.P33.GatPoly vss.P0.pSD 0.000789347f
Cred_2638 \$I66.P33.GatPoly vss.P13.nSD 1.72214e-06f
Cred_2639 \$I66.P33.GatPoly vss.P15.nSD 0.014668f
Cred_2640 \$I66.P34.GatPoly \$I67.$82.Metal2 8.00555e-05f
Cred_2641 \$I66.P34.GatPoly \$I67.P0.GatPoly 1.21759e-05f
Cred_2642 \$I66.P34.GatPoly \$I67.P3.GatPoly 5.87188e-07f
Cred_2643 \$I66.P34.GatPoly \$I67.P4.GatPoly 5.87188e-07f
Cred_2644 \$I66.P34.GatPoly vss 0.0233925f
Cred_2645 \$I66.P34.GatPoly vout.$1240.Metal4 0.00185203f
Cred_2646 \$I66.P34.GatPoly vout.$1269.Metal4 0.000222886f
Cred_2647 \$I66.P34.GatPoly vout.$127.Metal1 0.00482914f
Cred_2648 \$I66.P34.GatPoly vout.$1299.Metal4 6.70606e-05f
Cred_2649 \$I66.P34.GatPoly vout.$17.Metal1 0.00903491f
Cred_2650 \$I66.P34.GatPoly vout.$448.Metal2 8.91395e-05f
Cred_2651 \$I66.P34.GatPoly vout.$468.Metal2 8.89229e-05f
Cred_2652 \$I66.P34.GatPoly vout.$508.Metal2 8.53418e-05f
Cred_2653 \$I66.P34.GatPoly vout.$528.Metal2 6.70667e-05f
Cred_2654 \$I66.P34.GatPoly vout.$67.Metal1 0.022091f
Cred_2655 \$I66.P34.GatPoly vout.$896.Metal3 2.71248e-07f
Cred_2656 \$I66.P34.GatPoly vout.$936.Metal3 4.08708e-08f
Cred_2657 \$I66.P34.GatPoly vout.P12.nSD 0.000236935f
Cred_2658 \$I66.P34.GatPoly vss.$1047.Metal4 9.23518e-06f
Cred_2659 \$I66.P34.GatPoly vss.$127.Metal1 8.87888e-06f
Cred_2660 \$I66.P34.GatPoly vss.$148.Metal1 0.000516676f
Cred_2661 \$I66.P34.GatPoly vss.$150.Metal1 0.000539093f
Cred_2662 \$I66.P34.GatPoly vss.$406.Metal1 0.000176425f
Cred_2663 \$I66.P34.GatPoly vss.$457.Metal2 1.29675e-07f
Cred_2664 \$I66.P34.GatPoly vss.$503.Metal2 0.0173532f
Cred_2665 \$I66.P34.GatPoly vss.$507.Metal2 0.00190588f
Cred_2666 \$I66.P34.GatPoly vss.$835.Metal3 0.00078325f
Cred_2667 \$I66.P34.GatPoly vss.$839.Metal3 0.000805722f
Cred_2668 \$I66.P34.GatPoly vss.P0.GatPoly 3.17429e-07f
Cred_2669 \$I66.P34.GatPoly vss.P0.pSD 0.000726495f
Cred_2670 \$I66.P34.GatPoly vss.P17.nSD 0.015096f
Cred_2671 \$I66.P35.GatPoly vss 0.023561f
Cred_2672 \$I66.P35.GatPoly vout.$1241.Metal4 6.5232e-09f
Cred_2673 \$I66.P35.GatPoly vout.$1269.Metal4 0.000234921f
Cred_2674 \$I66.P35.GatPoly vout.$128.Metal1 0.00483735f
Cred_2675 \$I66.P35.GatPoly vout.$129.Metal1 5.37008e-07f
Cred_2676 \$I66.P35.GatPoly vout.$1299.Metal4 0.000114614f
Cred_2677 \$I66.P35.GatPoly vout.$18.Metal1 0.00903491f
Cred_2678 \$I66.P35.GatPoly vout.$450.Metal2 8.91182e-05f
Cred_2679 \$I66.P35.GatPoly vout.$470.Metal2 8.89175e-05f
Cred_2680 \$I66.P35.GatPoly vout.$510.Metal2 8.53418e-05f
Cred_2681 \$I66.P35.GatPoly vout.$530.Metal2 6.99838e-05f
Cred_2682 \$I66.P35.GatPoly vout.$532.Metal2 2.0752e-07f
Cred_2683 \$I66.P35.GatPoly vout.$68.Metal1 0.023943f
Cred_2684 \$I66.P35.GatPoly vout.$858.Metal3 3.25437e-07f
Cred_2685 \$I66.P35.GatPoly vout.$938.Metal3 6.40174e-06f
Cred_2686 \$I66.P35.GatPoly vout.$940.Metal3 1.3171e-06f
Cred_2687 \$I66.P35.GatPoly vout.P14.nSD 0.000238084f
Cred_2688 \$I66.P35.GatPoly vout.P16.nSD 2.29714e-07f
Cred_2689 \$I66.P35.GatPoly vref 5.20568e-06f
Cred_2690 \$I66.P35.GatPoly vref.P0.GatPoly 1.98088e-07f
Cred_2691 \$I66.P35.GatPoly vref.P0.nSD 1.19802e-07f
Cred_2692 \$I66.P35.GatPoly vref.P0.pSD 2.09982e-07f
Cred_2693 \$I66.P35.GatPoly vss.$1047.Metal4 1.95981e-09f
Cred_2694 \$I66.P35.GatPoly vss.$1053.Metal4 1.84526e-09f
Cred_2695 \$I66.P35.GatPoly vss.$127.Metal1 8.30234e-06f
Cred_2696 \$I66.P35.GatPoly vss.$150.Metal1 0.00166919f
Cred_2697 \$I66.P35.GatPoly vss.$153.Metal1 1.3881e-07f
Cred_2698 \$I66.P35.GatPoly vss.$406.Metal1 0.00020929f
Cred_2699 \$I66.P35.GatPoly vss.$457.Metal2 1.21255e-07f
Cred_2700 \$I66.P35.GatPoly vss.$503.Metal2 0.0160414f
Cred_2701 \$I66.P35.GatPoly vss.$507.Metal2 0.00287446f
Cred_2702 \$I66.P35.GatPoly vss.$509.Metal2 2.07514e-06f
Cred_2703 \$I66.P35.GatPoly vss.$835.Metal3 1.66214e-07f
Cred_2704 \$I66.P35.GatPoly vss.$839.Metal3 0.00199726f
Cred_2705 \$I66.P35.GatPoly vss.$841.Metal3 7.89996e-07f
Cred_2706 \$I66.P35.GatPoly vss.$845.Metal3 1.56499e-07f
Cred_2707 \$I66.P35.GatPoly vss.P0.GatPoly 2.96817e-07f
Cred_2708 \$I66.P35.GatPoly vss.P0.pSD 0.000746001f
Cred_2709 \$I66.P35.GatPoly vss.P17.nSD 0.0144283f
Cred_2710 \$I66.P35.GatPoly vss.P19.nSD 1.69297e-06f
Cred_2711 \$I66.P36.GatPoly vss 0.0235811f
Cred_2712 \$I66.P36.GatPoly vout.$1241.Metal4 0.00115263f
Cred_2713 \$I66.P36.GatPoly vout.$1269.Metal4 0.000238932f
Cred_2714 \$I66.P36.GatPoly vout.$128.Metal1 0.00483235f
Cred_2715 \$I66.P36.GatPoly vout.$129.Metal1 1.07422e-06f
Cred_2716 \$I66.P36.GatPoly vout.$1299.Metal4 0.000124679f
Cred_2717 \$I66.P36.GatPoly vout.$18.Metal1 0.00903491f
Cred_2718 \$I66.P36.GatPoly vout.$450.Metal2 8.91182e-05f
Cred_2719 \$I66.P36.GatPoly vout.$470.Metal2 8.89175e-05f
Cred_2720 \$I66.P36.GatPoly vout.$510.Metal2 8.53418e-05f
Cred_2721 \$I66.P36.GatPoly vout.$530.Metal2 6.82973e-05f
Cred_2722 \$I66.P36.GatPoly vout.$532.Metal2 4.15119e-07f
Cred_2723 \$I66.P36.GatPoly vout.$68.Metal1 0.0227904f
Cred_2724 \$I66.P36.GatPoly vout.$858.Metal3 3.25437e-07f
Cred_2725 \$I66.P36.GatPoly vout.$938.Metal3 7.41889e-06f
Cred_2726 \$I66.P36.GatPoly vout.$940.Metal3 2.6347e-06f
Cred_2727 \$I66.P36.GatPoly vout.P14.nSD 0.000238314f
Cred_2728 \$I66.P36.GatPoly vout.P16.nSD 4.59515e-07f
Cred_2729 \$I66.P36.GatPoly vref 6.94069e-06f
Cred_2730 \$I66.P36.GatPoly vref.P0.GatPoly 2.6411e-07f
Cred_2731 \$I66.P36.GatPoly vref.P0.nSD 1.59731e-07f
Cred_2732 \$I66.P36.GatPoly vref.P0.pSD 2.79967e-07f
Cred_2733 \$I66.P36.GatPoly vss.$1047.Metal4 1.30613e-09f
Cred_2734 \$I66.P36.GatPoly vss.$1053.Metal4 3.69121e-09f
Cred_2735 \$I66.P36.GatPoly vss.$127.Metal1 6.88093e-06f
Cred_2736 \$I66.P36.GatPoly vss.$150.Metal1 0.00102774f
Cred_2737 \$I66.P36.GatPoly vss.$153.Metal1 0.000509368f
Cred_2738 \$I66.P36.GatPoly vss.$406.Metal1 0.000233422f
Cred_2739 \$I66.P36.GatPoly vss.$457.Metal2 1.00495e-07f
Cred_2740 \$I66.P36.GatPoly vss.$503.Metal2 1.64201e-06f
Cred_2741 \$I66.P36.GatPoly vss.$507.Metal2 0.00707779f
Cred_2742 \$I66.P36.GatPoly vss.$509.Metal2 0.0119739f
Cred_2743 \$I66.P36.GatPoly vss.$835.Metal3 1.10775e-07f
Cred_2744 \$I66.P36.GatPoly vss.$839.Metal3 6.90522e-07f
Cred_2745 \$I66.P36.GatPoly vss.$841.Metal3 0.00196393f
Cred_2746 \$I66.P36.GatPoly vss.$845.Metal3 3.13057e-07f
Cred_2747 \$I66.P36.GatPoly vss.P0.GatPoly 2.46e-07f
Cred_2748 \$I66.P36.GatPoly vss.P0.pSD 0.0007001f
Cred_2749 \$I66.P36.GatPoly vss.P17.nSD 1.08984e-06f
Cred_2750 \$I66.P36.GatPoly vss.P19.nSD 0.0144659f
Cred_2751 \$I66.P37.GatPoly vss 0.023561f
Cred_2752 \$I66.P37.GatPoly vout.$1241.Metal4 6.46672e-09f
Cred_2753 \$I66.P37.GatPoly vout.$1269.Metal4 0.000234921f
Cred_2754 \$I66.P37.GatPoly vout.$128.Metal1 1.60419e-06f
Cred_2755 \$I66.P37.GatPoly vout.$129.Metal1 0.00483628f
Cred_2756 \$I66.P37.GatPoly vout.$1299.Metal4 0.000112103f
Cred_2757 \$I66.P37.GatPoly vout.$19.Metal1 0.00903491f
Cred_2758 \$I66.P37.GatPoly vout.$452.Metal2 8.91182e-05f
Cred_2759 \$I66.P37.GatPoly vout.$472.Metal2 8.89175e-05f
Cred_2760 \$I66.P37.GatPoly vout.$512.Metal2 8.53418e-05f
Cred_2761 \$I66.P37.GatPoly vout.$530.Metal2 6.15193e-07f
Cred_2762 \$I66.P37.GatPoly vout.$532.Metal2 6.95761e-05f
Cred_2763 \$I66.P37.GatPoly vout.$69.Metal1 0.023943f
Cred_2764 \$I66.P37.GatPoly vout.$860.Metal3 3.25492e-07f
Cred_2765 \$I66.P37.GatPoly vout.$938.Metal3 3.68831e-06f
Cred_2766 \$I66.P37.GatPoly vout.$940.Metal3 4.03053e-06f
Cred_2767 \$I66.P37.GatPoly vout.P14.nSD 6.89229e-07f
Cred_2768 \$I66.P37.GatPoly vout.P16.nSD 0.000237625f
Cred_2769 \$I66.P37.GatPoly vref 5.20568e-06f
Cred_2770 \$I66.P37.GatPoly vref.P0.GatPoly 1.98088e-07f
Cred_2771 \$I66.P37.GatPoly vref.P0.nSD 1.19802e-07f
Cred_2772 \$I66.P37.GatPoly vref.P0.pSD 2.09982e-07f
Cred_2773 \$I66.P37.GatPoly vss.$1047.Metal4 6.52939e-10f
Cred_2774 \$I66.P37.GatPoly vss.$1053.Metal4 1.14396e-05f
Cred_2775 \$I66.P37.GatPoly vss.$127.Metal1 6.22918e-06f
Cred_2776 \$I66.P37.GatPoly vss.$150.Metal1 0.000440377f
Cred_2777 \$I66.P37.GatPoly vss.$153.Metal1 0.000888148f
Cred_2778 \$I66.P37.GatPoly vss.$406.Metal1 0.000269158f
Cred_2779 \$I66.P37.GatPoly vss.$457.Metal2 9.09762e-08f
Cred_2780 \$I66.P37.GatPoly vss.$503.Metal2 8.20849e-07f
Cred_2781 \$I66.P37.GatPoly vss.$507.Metal2 0.00495118f
Cred_2782 \$I66.P37.GatPoly vss.$509.Metal2 0.0140833f
Cred_2783 \$I66.P37.GatPoly vss.$835.Metal3 5.53768e-08f
Cred_2784 \$I66.P37.GatPoly vss.$839.Metal3 3.45196e-07f
Cred_2785 \$I66.P37.GatPoly vss.$841.Metal3 0.000970844f
Cred_2786 \$I66.P37.GatPoly vss.$845.Metal3 0.000970211f
Cred_2787 \$I66.P37.GatPoly vss.P0.GatPoly 2.22699e-07f
Cred_2788 \$I66.P37.GatPoly vss.P0.pSD 0.000692651f
Cred_2789 \$I66.P37.GatPoly vss.P17.nSD 5.44815e-07f
Cred_2790 \$I66.P37.GatPoly vss.P19.nSD 0.0144573f
Cred_2791 \$I66.P38.GatPoly vss 0.0235006f
Cred_2792 \$I66.P38.GatPoly vout.$1241.Metal4 6.46672e-09f
Cred_2793 \$I66.P38.GatPoly vout.$1269.Metal4 0.000222886f
Cred_2794 \$I66.P38.GatPoly vout.$129.Metal1 0.00482914f
Cred_2795 \$I66.P38.GatPoly vout.$1299.Metal4 7.68699e-05f
Cred_2796 \$I66.P38.GatPoly vout.$19.Metal1 0.00903491f
Cred_2797 \$I66.P38.GatPoly vout.$452.Metal2 8.91182e-05f
Cred_2798 \$I66.P38.GatPoly vout.$472.Metal2 8.89175e-05f
Cred_2799 \$I66.P38.GatPoly vout.$512.Metal2 8.53418e-05f
Cred_2800 \$I66.P38.GatPoly vout.$532.Metal2 6.70667e-05f
Cred_2801 \$I66.P38.GatPoly vout.$69.Metal1 0.023943f
Cred_2802 \$I66.P38.GatPoly vout.$860.Metal3 3.25492e-07f
Cred_2803 \$I66.P38.GatPoly vout.$940.Metal3 4.08708e-08f
Cred_2804 \$I66.P38.GatPoly vout.P16.nSD 0.000236935f
Cred_2805 \$I66.P38.GatPoly vss.$1057.Metal4 8.35564e-06f
Cred_2806 \$I66.P38.GatPoly vss.$127.Metal1 5.00975e-06f
Cred_2807 \$I66.P38.GatPoly vss.$406.Metal1 0.000296314f
Cred_2808 \$I66.P38.GatPoly vss.$457.Metal2 7.31668e-08f
Cred_2809 \$I66.P38.GatPoly vss.$513.Metal2 0.0162946f
Cred_2810 \$I66.P38.GatPoly vss.$515.Metal2 0.00357489f
Cred_2811 \$I66.P38.GatPoly vss.$845.Metal3 0.000708654f
Cred_2812 \$I66.P38.GatPoly vss.$849.Metal3 0.000708654f
Cred_2813 \$I66.P38.GatPoly vss.P0.GatPoly 1.79104e-07f
Cred_2814 \$I66.P38.GatPoly vss.P0.pSD 0.00061963f
Cred_2815 \$I66.P38.GatPoly vss.P21.nSD 0.0157303f
Cred_2816 \$I66.P39.GatPoly vss 0.0235863f
Cred_2817 \$I66.P39.GatPoly vout.$1252.Metal4 6.4987e-09f
Cred_2818 \$I66.P39.GatPoly vout.$1269.Metal4 0.000230908f
Cred_2819 \$I66.P39.GatPoly vout.$1299.Metal4 0.000108939f
Cred_2820 \$I66.P39.GatPoly vout.$130.Metal1 0.00483745f
Cred_2821 \$I66.P39.GatPoly vout.$20.Metal1 0.00903491f
Cred_2822 \$I66.P39.GatPoly vout.$454.Metal2 8.91182e-05f
Cred_2823 \$I66.P39.GatPoly vout.$474.Metal2 8.89175e-05f
Cred_2824 \$I66.P39.GatPoly vout.$514.Metal2 8.53418e-05f
Cred_2825 \$I66.P39.GatPoly vout.$534.Metal2 7.05856e-05f
Cred_2826 \$I66.P39.GatPoly vout.$70.Metal1 0.0237835f
Cred_2827 \$I66.P39.GatPoly vout.$862.Metal3 3.25461e-07f
Cred_2828 \$I66.P39.GatPoly vout.$942.Metal3 9.95391e-06f
Cred_2829 \$I66.P39.GatPoly vout.P18.nSD 0.000239058f
Cred_2830 \$I66.P39.GatPoly vref 6.98467e-06f
Cred_2831 \$I66.P39.GatPoly vref.P0.GatPoly 1.32042e-07f
Cred_2832 \$I66.P39.GatPoly vref.P0.nSD 7.98581e-08f
Cred_2833 \$I66.P39.GatPoly vref.P0.pSD 1.3997e-07f
Cred_2834 \$I66.P39.GatPoly vss 1.8184e-06f
Cred_2835 \$I66.P39.GatPoly vss.$1057.Metal4 2.8394e-09f
Cred_2836 \$I66.P39.GatPoly vss.$1211.Metal5 1.87533e-06f
Cred_2837 \$I66.P39.GatPoly vss.$1229.Metal5 1.87533e-06f
Cred_2838 \$I66.P39.GatPoly vss.$127.Metal1 4.42606e-06f
Cred_2839 \$I66.P39.GatPoly vss.$1281.Metal5 7.17839e-06f
Cred_2840 \$I66.P39.GatPoly vss.$1299.Metal5 7.17839e-06f
Cred_2841 \$I66.P39.GatPoly vss.$153.Metal1 0.000527865f
Cred_2842 \$I66.P39.GatPoly vss.$156.Metal1 0.00106552f
Cred_2843 \$I66.P39.GatPoly vss.$159.Metal1 4.11838e-06f
Cred_2844 \$I66.P39.GatPoly vss.$406.Metal1 0.00043419f
Cred_2845 \$I66.P39.GatPoly vss.$457.Metal2 6.46419e-08f
Cred_2846 \$I66.P39.GatPoly vss.$513.Metal2 0.0136153f
Cred_2847 \$I66.P39.GatPoly vss.$515.Metal2 0.00542573f
Cred_2848 \$I66.P39.GatPoly vss.$519.Metal2 1.24831e-06f
Cred_2849 \$I66.P39.GatPoly vss.$521.Metal2 3.15078e-06f
Cred_2850 \$I66.P39.GatPoly vss.$525.Metal2 6.01483e-08f
Cred_2851 \$I66.P39.GatPoly vss.$845.Metal3 2.40814e-07f
Cred_2852 \$I66.P39.GatPoly vss.$849.Metal3 0.0019637f
Cred_2853 \$I66.P39.GatPoly vss.$851.Metal3 9.98955e-07f
Cred_2854 \$I66.P39.GatPoly vss.P0.GatPoly 1.58236e-07f
Cred_2855 \$I66.P39.GatPoly vss.P0.pSD 0.000607461f
Cred_2856 \$I66.P39.GatPoly vss.P1.GatPoly 7.08652e-06f
Cred_2857 \$I66.P39.GatPoly vss.P21.nSD 0.0144452f
Cred_2858 \$I66.P39.GatPoly vss.P23.nSD 1.09925e-06f
Cred_2859 \$I66.P39.GatPoly vss.P25.nSD 9.03751e-07f
Cred_2860 \$I66.P4.GatPoly \$I67.$82.Metal2 3.44444e-05f
Cred_2861 \$I66.P4.GatPoly \$I78 0.0193667f
Cred_2862 \$I66.P4.GatPoly vss 0.000233112f
Cred_2863 \$I66.P4.GatPoly vdd.$2365.Metal1 1.97548e-05f
Cred_2864 \$I66.P4.GatPoly vdd.$2370.Metal1 4.72594e-09f
Cred_2865 \$I66.P4.GatPoly vdd.$2372.Metal1 0.00149077f
Cred_2866 \$I66.P4.GatPoly vdd.$2375.Metal1 0.000738811f
Cred_2867 \$I66.P4.GatPoly vdd.$2399.Metal1 1.98862e-06f
Cred_2868 \$I66.P4.GatPoly vdd.$2747.Metal2 8.48842e-07f
Cred_2869 \$I66.P4.GatPoly vdd.$2749.Metal2 6.51752e-07f
Cred_2870 \$I66.P4.GatPoly vdd.$2751.Metal2 9.07472e-07f
Cred_2871 \$I66.P4.GatPoly vdd.$2755.Metal2 3.74886e-06f
Cred_2872 \$I66.P4.GatPoly vdd.$2759.Metal2 0.0173981f
Cred_2873 \$I66.P4.GatPoly vdd.$2761.Metal2 0.00580552f
Cred_2874 \$I66.P4.GatPoly vdd.$2983.Metal3 1.77833e-07f
Cred_2875 \$I66.P4.GatPoly vdd.$2987.Metal3 7.83731e-07f
Cred_2876 \$I66.P4.GatPoly vdd.$2991.Metal3 1.98887e-07f
Cred_2877 \$I66.P4.GatPoly vdd.$2993.Metal3 0.0104612f
Cred_2878 \$I66.P4.GatPoly vdd.$3219.Metal4 2.09681e-09f
Cred_2879 \$I66.P4.GatPoly vdd.$3223.Metal4 2.34504e-09f
Cred_2880 \$I66.P4.GatPoly vdd.P0.nSD 0.000681528f
Cred_2881 \$I66.P4.GatPoly vdd.P0.pSD 7.41178e-07f
Cred_2882 \$I66.P4.GatPoly vdd.P1.GatPoly 3.76812e-06f
Cred_2883 \$I66.P4.GatPoly vdd.P1.pSD 1.64244e-06f
Cred_2884 \$I66.P4.GatPoly vdd.P2.GatPoly 8.8451e-08f
Cred_2885 \$I66.P4.GatPoly vdd.P3.pSD 6.30269e-06f
Cred_2886 \$I66.P4.GatPoly vdd.P5.pSD 0.0280493f
Cred_2887 \$I66.P4.GatPoly vout.$1032.Metal3 3.84025e-06f
Cred_2888 \$I66.P4.GatPoly vout.$1034.Metal3 3.87398e-06f
Cred_2889 \$I66.P4.GatPoly vout.$1112.Metal3 2.00849e-09f
Cred_2890 \$I66.P4.GatPoly vout.$1152.Metal3 4.75488e-09f
Cred_2891 \$I66.P4.GatPoly vout.$1154.Metal3 2.60128e-07f
Cred_2892 \$I66.P4.GatPoly vout.$1328.Metal4 1.33517e-06f
Cred_2893 \$I66.P4.GatPoly vout.$1329.Metal4 1.33559e-06f
Cred_2894 \$I66.P4.GatPoly vout.$1368.Metal4 4.38751e-08f
Cred_2895 \$I66.P4.GatPoly vout.$1369.Metal4 0.0293813f
Cred_2896 \$I66.P4.GatPoly vout.$1408.Metal4 5.55726e-07f
Cred_2897 \$I66.P4.GatPoly vout.$156.Metal1 4.43152e-06f
Cred_2898 \$I66.P4.GatPoly vout.$157.Metal1 0.00142769f
Cred_2899 \$I66.P4.GatPoly vout.$206.Metal1 1.61144e-06f
Cred_2900 \$I66.P4.GatPoly vout.$207.Metal1 0.00550921f
Cred_2901 \$I66.P4.GatPoly vout.$227.Metal1 0.00600163f
Cred_2902 \$I66.P4.GatPoly vout.$267.Metal1 0.00596824f
Cred_2903 \$I66.P4.GatPoly vout.$287.Metal1 0.00596897f
Cred_2904 \$I66.P4.GatPoly vout.$327.Metal1 0.00600124f
Cred_2905 \$I66.P4.GatPoly vout.$347.Metal1 0.00792118f
Cred_2906 \$I66.P4.GatPoly vout.$397.Metal1 0.00871131f
Cred_2907 \$I66.P4.GatPoly vout.$584.Metal2 1.12432e-06f
Cred_2908 \$I66.P4.GatPoly vout.$586.Metal2 2.09974e-05f
Cred_2909 \$I66.P4.GatPoly vout.$604.Metal2 1.12162e-07f
Cred_2910 \$I66.P4.GatPoly vout.$606.Metal2 3.26084e-05f
Cred_2911 \$I66.P4.GatPoly vout.$646.Metal2 1.8244e-05f
Cred_2912 \$I66.P4.GatPoly vout.$666.Metal2 3.60091e-05f
Cred_2913 \$I66.P4.GatPoly vout.$686.Metal2 1.04364e-05f
Cred_2914 \$I66.P4.GatPoly vout.$706.Metal2 3.55883e-05f
Cred_2915 \$I66.P4.GatPoly vout.$724.Metal2 2.10417e-11f
Cred_2916 \$I66.P4.GatPoly vout.$726.Metal2 1.93601e-05f
Cred_2917 \$I66.P4.GatPoly vout.$766.Metal2 8.46505e-05f
Cred_2918 \$I66.P4.GatPoly vout.$786.Metal2 8.72673e-05f
Cred_2919 \$I66.P4.GatPoly vout.P0.pSD 1.8576e-06f
Cred_2920 \$I66.P4.GatPoly vout.P2.pSD 0.000197012f
Cred_2921 \$I66.P4.GatPoly vss 0.000449283f
Cred_2922 \$I66.P4.GatPoly vss.$1211.Metal5 0.000166603f
Cred_2923 \$I66.P4.GatPoly vss.$1229.Metal5 0.000166603f
Cred_2924 \$I66.P4.GatPoly vss.$1281.Metal5 0.000637723f
Cred_2925 \$I66.P4.GatPoly vss.$1299.Metal5 0.000637723f
Cred_2926 \$I66.P40.GatPoly vss 0.0236317f
Cred_2927 \$I66.P40.GatPoly vout.$1252.Metal4 6.4987e-09f
Cred_2928 \$I66.P40.GatPoly vout.$1269.Metal4 8.01956e-06f
Cred_2929 \$I66.P40.GatPoly vout.$1299.Metal4 4.1483e-05f
Cred_2930 \$I66.P40.GatPoly vout.$130.Metal1 0.00480734f
Cred_2931 \$I66.P40.GatPoly vout.$20.Metal1 0.00903491f
Cred_2932 \$I66.P40.GatPoly vout.$454.Metal2 8.91182e-05f
Cred_2933 \$I66.P40.GatPoly vout.$474.Metal2 8.89175e-05f
Cred_2934 \$I66.P40.GatPoly vout.$514.Metal2 8.53418e-05f
Cred_2935 \$I66.P40.GatPoly vout.$534.Metal2 6.95244e-05f
Cred_2936 \$I66.P40.GatPoly vout.$70.Metal1 0.0201156f
Cred_2937 \$I66.P40.GatPoly vout.$862.Metal3 3.25461e-07f
Cred_2938 \$I66.P40.GatPoly vout.$942.Metal3 1.46582e-05f
Cred_2939 \$I66.P40.GatPoly vout.P18.nSD 0.000239977f
Cred_2940 \$I66.P40.GatPoly vref 1.04993e-05f
Cred_2941 \$I66.P40.GatPoly vref.P0.GatPoly 1.31992e-07f
Cred_2942 \$I66.P40.GatPoly vref.P0.nSD 7.98279e-08f
Cred_2943 \$I66.P40.GatPoly vref.P0.pSD 1.39917e-07f
Cred_2944 \$I66.P40.GatPoly vss 0.00023497f
Cred_2945 \$I66.P40.GatPoly vss.$1057.Metal4 2.83832e-09f
Cred_2946 \$I66.P40.GatPoly vss.$1061.Metal4 0.00178447f
Cred_2947 \$I66.P40.GatPoly vss.$1211.Metal5 0.000242326f
Cred_2948 \$I66.P40.GatPoly vss.$1229.Metal5 0.000242326f
Cred_2949 \$I66.P40.GatPoly vss.$127.Metal1 3.3878e-06f
Cred_2950 \$I66.P40.GatPoly vss.$1281.Metal5 0.000927574f
Cred_2951 \$I66.P40.GatPoly vss.$1299.Metal5 0.000927574f
Cred_2952 \$I66.P40.GatPoly vss.$153.Metal1 1.50803e-07f
Cred_2953 \$I66.P40.GatPoly vss.$156.Metal1 0.00161708f
Cred_2954 \$I66.P40.GatPoly vss.$159.Metal1 0.000670863f
Cred_2955 \$I66.P40.GatPoly vss.$406.Metal1 0.0160653f
Cred_2956 \$I66.P40.GatPoly vss.$457.Metal2 4.94783e-08f
Cred_2957 \$I66.P40.GatPoly vss.$513.Metal2 2.56255e-06f
Cred_2958 \$I66.P40.GatPoly vss.$515.Metal2 0.00323351f
Cred_2959 \$I66.P40.GatPoly vss.$519.Metal2 0.0128186f
Cred_2960 \$I66.P40.GatPoly vss.$521.Metal2 6.30276e-06f
Cred_2961 \$I66.P40.GatPoly vss.$525.Metal2 9.79786e-06f
Cred_2962 \$I66.P40.GatPoly vss.$845.Metal3 2.40723e-07f
Cred_2963 \$I66.P40.GatPoly vss.$849.Metal3 1.35136e-06f
Cred_2964 \$I66.P40.GatPoly vss.$851.Metal3 0.00200245f
Cred_2965 \$I66.P40.GatPoly vss.P0.GatPoly 1.21117e-07f
Cred_2966 \$I66.P40.GatPoly vss.P0.pSD 0.00172098f
Cred_2967 \$I66.P40.GatPoly vss.P1.GatPoly 0.0854513f
Cred_2968 \$I66.P40.GatPoly vss.P21.nSD 2.17711e-06f
Cred_2969 \$I66.P40.GatPoly vss.P23.nSD 0.012015f
Cred_2970 \$I66.P40.GatPoly vss.P25.nSD 1.80784e-06f
Cred_2971 \$I66.P5.GatPoly \$I67.$82.Metal2 3.27124e-05f
Cred_2972 \$I66.P5.GatPoly \$I78 0.0192734f
Cred_2973 \$I66.P5.GatPoly vss 0.000218001f
Cred_2974 \$I66.P5.GatPoly vdd.$2365.Metal1 1.12432e-05f
Cred_2975 \$I66.P5.GatPoly vdd.$2372.Metal1 0.000753442f
Cred_2976 \$I66.P5.GatPoly vdd.$2375.Metal1 0.00152022f
Cred_2977 \$I66.P5.GatPoly vdd.$2399.Metal1 2.1472e-06f
Cred_2978 \$I66.P5.GatPoly vdd.$2759.Metal2 0.0140146f
Cred_2979 \$I66.P5.GatPoly vdd.$2761.Metal2 0.00834538f
Cred_2980 \$I66.P5.GatPoly vdd.$2993.Metal3 0.00521279f
Cred_2981 \$I66.P5.GatPoly vdd.$2997.Metal3 0.00521279f
Cred_2982 \$I66.P5.GatPoly vdd.$3229.Metal4 6.14632e-05f
Cred_2983 \$I66.P5.GatPoly vdd.P0.nSD 0.000601034f
Cred_2984 \$I66.P5.GatPoly vdd.P1.GatPoly 5.00079e-07f
Cred_2985 \$I66.P5.GatPoly vdd.P2.GatPoly 9.55043e-08f
Cred_2986 \$I66.P5.GatPoly vdd.P5.pSD 0.0280442f
Cred_2987 \$I66.P5.GatPoly vout.$1036.Metal3 5.28445e-08f
Cred_2988 \$I66.P5.GatPoly vout.$1156.Metal3 2.60128e-07f
Cred_2989 \$I66.P5.GatPoly vout.$1330.Metal4 1.92343e-09f
Cred_2990 \$I66.P5.GatPoly vout.$1370.Metal4 0.0284926f
Cred_2991 \$I66.P5.GatPoly vout.$158.Metal1 0.00138482f
Cred_2992 \$I66.P5.GatPoly vout.$208.Metal1 0.00549198f
Cred_2993 \$I66.P5.GatPoly vout.$228.Metal1 0.00600163f
Cred_2994 \$I66.P5.GatPoly vout.$268.Metal1 0.00596824f
Cred_2995 \$I66.P5.GatPoly vout.$288.Metal1 0.00596897f
Cred_2996 \$I66.P5.GatPoly vout.$328.Metal1 0.00600124f
Cred_2997 \$I66.P5.GatPoly vout.$348.Metal1 0.00792118f
Cred_2998 \$I66.P5.GatPoly vout.$398.Metal1 0.00871131f
Cred_2999 \$I66.P5.GatPoly vout.$588.Metal2 1.9285e-05f
Cred_3000 \$I66.P5.GatPoly vout.$608.Metal2 3.21554e-05f
Cred_3001 \$I66.P5.GatPoly vout.$648.Metal2 1.8244e-05f
Cred_3002 \$I66.P5.GatPoly vout.$668.Metal2 3.60091e-05f
Cred_3003 \$I66.P5.GatPoly vout.$688.Metal2 1.04364e-05f
Cred_3004 \$I66.P5.GatPoly vout.$708.Metal2 3.55883e-05f
Cred_3005 \$I66.P5.GatPoly vout.$728.Metal2 1.93601e-05f
Cred_3006 \$I66.P5.GatPoly vout.$768.Metal2 8.46505e-05f
Cred_3007 \$I66.P5.GatPoly vout.$788.Metal2 8.72673e-05f
Cred_3008 \$I66.P5.GatPoly vout.P4.pSD 0.000194628f
Cred_3009 \$I66.P5.GatPoly vss 0.000441034f
Cred_3010 \$I66.P5.GatPoly vss.$1211.Metal5 0.000163331f
Cred_3011 \$I66.P5.GatPoly vss.$1229.Metal5 0.000163331f
Cred_3012 \$I66.P5.GatPoly vss.$1281.Metal5 0.000625197f
Cred_3013 \$I66.P5.GatPoly vss.$1299.Metal5 0.000625197f
Cred_3014 \$I66.P6.GatPoly \$I67.$82.Metal2 3.43647e-05f
Cred_3015 \$I66.P6.GatPoly \$I67.P1.GatPoly 1.78262e-09f
Cred_3016 \$I66.P6.GatPoly \$I67.P2.GatPoly 1.69799e-09f
Cred_3017 \$I66.P6.GatPoly \$I78 0.0192847f
Cred_3018 \$I66.P6.GatPoly vss 0.000218967f
Cred_3019 \$I66.P6.GatPoly vdd.$2365.Metal1 1.04973e-05f
Cred_3020 \$I66.P6.GatPoly vdd.$2375.Metal1 0.00249737f
Cred_3021 \$I66.P6.GatPoly vdd.$2399.Metal1 2.6187e-06f
Cred_3022 \$I66.P6.GatPoly vdd.$2761.Metal2 0.00383702f
Cred_3023 \$I66.P6.GatPoly vdd.$2765.Metal2 0.0192723f
Cred_3024 \$I66.P6.GatPoly vdd.$2997.Metal3 0.0104559f
Cred_3025 \$I66.P6.GatPoly vdd.P0.nSD 0.000633793f
Cred_3026 \$I66.P6.GatPoly vdd.P1.GatPoly 4.66902e-07f
Cred_3027 \$I66.P6.GatPoly vdd.P2.GatPoly 1.16476e-07f
Cred_3028 \$I66.P6.GatPoly vdd.P7.pSD 0.0280138f
Cred_3029 \$I66.P6.GatPoly vout.$1036.Metal3 8.90929e-07f
Cred_3030 \$I66.P6.GatPoly vout.$1156.Metal3 2.60128e-07f
Cred_3031 \$I66.P6.GatPoly vout.$1330.Metal4 1.01739e-07f
Cred_3032 \$I66.P6.GatPoly vout.$1370.Metal4 0.0253088f
Cred_3033 \$I66.P6.GatPoly vout.$158.Metal1 0.00150532f
Cred_3034 \$I66.P6.GatPoly vout.$208.Metal1 0.00538944f
Cred_3035 \$I66.P6.GatPoly vout.$228.Metal1 0.00600163f
Cred_3036 \$I66.P6.GatPoly vout.$268.Metal1 0.00596824f
Cred_3037 \$I66.P6.GatPoly vout.$288.Metal1 0.00596897f
Cred_3038 \$I66.P6.GatPoly vout.$328.Metal1 0.00600124f
Cred_3039 \$I66.P6.GatPoly vout.$348.Metal1 0.00792118f
Cred_3040 \$I66.P6.GatPoly vout.$398.Metal1 0.00871131f
Cred_3041 \$I66.P6.GatPoly vout.$588.Metal2 1.62151e-05f
Cred_3042 \$I66.P6.GatPoly vout.$608.Metal2 2.99333e-05f
Cred_3043 \$I66.P6.GatPoly vout.$648.Metal2 1.8244e-05f
Cred_3044 \$I66.P6.GatPoly vout.$668.Metal2 3.60091e-05f
Cred_3045 \$I66.P6.GatPoly vout.$688.Metal2 1.04364e-05f
Cred_3046 \$I66.P6.GatPoly vout.$708.Metal2 3.55883e-05f
Cred_3047 \$I66.P6.GatPoly vout.$728.Metal2 1.93601e-05f
Cred_3048 \$I66.P6.GatPoly vout.$768.Metal2 8.46505e-05f
Cred_3049 \$I66.P6.GatPoly vout.$788.Metal2 8.72673e-05f
Cred_3050 \$I66.P6.GatPoly vout.P4.pSD 0.00019151f
Cred_3051 \$I66.P6.GatPoly vref 3.12304e-06f
Cred_3052 \$I66.P6.GatPoly vref.P0.GatPoly 1.21781e-07f
Cred_3053 \$I66.P6.GatPoly vref.P0.nSD 6.98129e-07f
Cred_3054 \$I66.P6.GatPoly vref.P0.pSD 2.03848e-06f
Cred_3055 \$I66.P6.GatPoly vss 0.000462025f
Cred_3056 \$I66.P6.GatPoly vss.$1211.Metal5 0.00016859f
Cred_3057 \$I66.P6.GatPoly vss.$1229.Metal5 0.00016859f
Cred_3058 \$I66.P6.GatPoly vss.$1281.Metal5 0.00064533f
Cred_3059 \$I66.P6.GatPoly vss.$1299.Metal5 0.00064533f
Cred_3060 \$I66.P7.GatPoly \$I67.$82.Metal2 4.41318e-05f
Cred_3061 \$I66.P7.GatPoly \$I78 0.0192734f
Cred_3062 \$I66.P7.GatPoly vss 0.000207557f
Cred_3063 \$I66.P7.GatPoly vdd.$2365.Metal1 8.85205e-06f
Cred_3064 \$I66.P7.GatPoly vdd.$2375.Metal1 0.000855036f
Cred_3065 \$I66.P7.GatPoly vdd.$2377.Metal1 0.000824985f
Cred_3066 \$I66.P7.GatPoly vdd.$2399.Metal1 2.81569e-06f
Cred_3067 \$I66.P7.GatPoly vdd.$2761.Metal2 0.00255167f
Cred_3068 \$I66.P7.GatPoly vdd.$2765.Metal2 0.0236738f
Cred_3069 \$I66.P7.GatPoly vdd.$2997.Metal3 0.0010831f
Cred_3070 \$I66.P7.GatPoly vdd.$3001.Metal3 0.00105301f
Cred_3071 \$I66.P7.GatPoly vdd.$3233.Metal4 1.24159e-05f
Cred_3072 \$I66.P7.GatPoly vdd.P0.nSD 0.0006069f
Cred_3073 \$I66.P7.GatPoly vdd.P1.GatPoly 3.93726e-07f
Cred_3074 \$I66.P7.GatPoly vdd.P2.GatPoly 1.25238e-07f
Cred_3075 \$I66.P7.GatPoly vdd.P7.pSD 0.0335723f
Cred_3076 \$I66.P7.GatPoly vout.$1038.Metal3 5.28445e-08f
Cred_3077 \$I66.P7.GatPoly vout.$1158.Metal3 2.60128e-07f
Cred_3078 \$I66.P7.GatPoly vout.$1331.Metal4 1.92343e-09f
Cred_3079 \$I66.P7.GatPoly vout.$1371.Metal4 0.0293806f
Cred_3080 \$I66.P7.GatPoly vout.$159.Metal1 0.0015478f
Cred_3081 \$I66.P7.GatPoly vout.$209.Metal1 0.00538919f
Cred_3082 \$I66.P7.GatPoly vout.$229.Metal1 0.00600163f
Cred_3083 \$I66.P7.GatPoly vout.$269.Metal1 0.00596824f
Cred_3084 \$I66.P7.GatPoly vout.$289.Metal1 0.00596897f
Cred_3085 \$I66.P7.GatPoly vout.$329.Metal1 0.00600124f
Cred_3086 \$I66.P7.GatPoly vout.$349.Metal1 0.00792118f
Cred_3087 \$I66.P7.GatPoly vout.$399.Metal1 0.00871131f
Cred_3088 \$I66.P7.GatPoly vout.$590.Metal2 1.56992e-05f
Cred_3089 \$I66.P7.GatPoly vout.$610.Metal2 2.9911e-05f
Cred_3090 \$I66.P7.GatPoly vout.$650.Metal2 1.8244e-05f
Cred_3091 \$I66.P7.GatPoly vout.$670.Metal2 3.60091e-05f
Cred_3092 \$I66.P7.GatPoly vout.$690.Metal2 1.04364e-05f
Cred_3093 \$I66.P7.GatPoly vout.$710.Metal2 3.55883e-05f
Cred_3094 \$I66.P7.GatPoly vout.$730.Metal2 1.93601e-05f
Cred_3095 \$I66.P7.GatPoly vout.$770.Metal2 8.46505e-05f
Cred_3096 \$I66.P7.GatPoly vout.$790.Metal2 8.72673e-05f
Cred_3097 \$I66.P7.GatPoly vout.P6.pSD 0.000191171f
Cred_3098 \$I66.P7.GatPoly vss 0.000467355f
Cred_3099 \$I66.P7.GatPoly vss.$1211.Metal5 0.000170536f
Cred_3100 \$I66.P7.GatPoly vss.$1229.Metal5 0.000170536f
Cred_3101 \$I66.P7.GatPoly vss.$1281.Metal5 0.000652775f
Cred_3102 \$I66.P7.GatPoly vss.$1299.Metal5 0.000652775f
Cred_3103 \$I66.P8.GatPoly \$I67.$82.Metal2 0.000116519f
Cred_3104 \$I66.P8.GatPoly \$I67.P1.GatPoly 2.05015e-06f
Cred_3105 \$I66.P8.GatPoly \$I67.P2.GatPoly 7.949e-07f
Cred_3106 \$I66.P8.GatPoly \$I78 0.0193204f
Cred_3107 \$I66.P8.GatPoly vss 0.000166902f
Cred_3108 \$I66.P8.GatPoly vdd.$2365.Metal1 7.92426e-06f
Cred_3109 \$I66.P8.GatPoly vdd.$2377.Metal1 0.00107328f
Cred_3110 \$I66.P8.GatPoly vdd.$2379.Metal1 0.0010733f
Cred_3111 \$I66.P8.GatPoly vdd.$2399.Metal1 3.30217e-06f
Cred_3112 \$I66.P8.GatPoly vdd.$2769.Metal2 0.0177289f
Cred_3113 \$I66.P8.GatPoly vdd.$2771.Metal2 0.00531291f
Cred_3114 \$I66.P8.GatPoly vdd.$2773.Metal2 3.43974e-07f
Cred_3115 \$I66.P8.GatPoly vdd.$2775.Metal2 1.06801e-06f
Cred_3116 \$I66.P8.GatPoly vdd.$3003.Metal3 0.010621f
Cred_3117 \$I66.P8.GatPoly vdd.$3007.Metal3 5.05358e-07f
Cred_3118 \$I66.P8.GatPoly vdd.$3011.Metal3 1.43165e-07f
Cred_3119 \$I66.P8.GatPoly vdd.$3239.Metal4 1.7295e-09f
Cred_3120 \$I66.P8.GatPoly vdd.$3243.Metal4 1.68803e-09f
Cred_3121 \$I66.P8.GatPoly vdd.P0.nSD 0.000622255f
Cred_3122 \$I66.P8.GatPoly vdd.P1.GatPoly 3.52459e-07f
Cred_3123 \$I66.P8.GatPoly vdd.P10.pSD 0.0280494f
Cred_3124 \$I66.P8.GatPoly vdd.P11.pSD 1.99366e-06f
Cred_3125 \$I66.P8.GatPoly vdd.P2.GatPoly 1.46876e-07f
Cred_3126 \$I66.P8.GatPoly vout.$1038.Metal3 1.49878e-06f
Cred_3127 \$I66.P8.GatPoly vout.$1040.Metal3 2.14394e-06f
Cred_3128 \$I66.P8.GatPoly vout.$1158.Metal3 2.60128e-07f
Cred_3129 \$I66.P8.GatPoly vout.$1331.Metal4 5.40517e-07f
Cred_3130 \$I66.P8.GatPoly vout.$1332.Metal4 7.87492e-07f
Cred_3131 \$I66.P8.GatPoly vout.$1371.Metal4 0.0253087f
Cred_3132 \$I66.P8.GatPoly vout.$1372.Metal4 5.5487e-07f
Cred_3133 \$I66.P8.GatPoly vout.$159.Metal1 0.00156908f
Cred_3134 \$I66.P8.GatPoly vout.$160.Metal1 2.97209e-06f
Cred_3135 \$I66.P8.GatPoly vout.$209.Metal1 0.00538962f
Cred_3136 \$I66.P8.GatPoly vout.$210.Metal1 6.10246e-07f
Cred_3137 \$I66.P8.GatPoly vout.$229.Metal1 0.00600163f
Cred_3138 \$I66.P8.GatPoly vout.$269.Metal1 0.00596824f
Cred_3139 \$I66.P8.GatPoly vout.$289.Metal1 0.00596897f
Cred_3140 \$I66.P8.GatPoly vout.$329.Metal1 0.00600124f
Cred_3141 \$I66.P8.GatPoly vout.$349.Metal1 0.00792118f
Cred_3142 \$I66.P8.GatPoly vout.$399.Metal1 0.00871131f
Cred_3143 \$I66.P8.GatPoly vout.$590.Metal2 1.61887e-05f
Cred_3144 \$I66.P8.GatPoly vout.$592.Metal2 6.35088e-07f
Cred_3145 \$I66.P8.GatPoly vout.$610.Metal2 2.99495e-05f
Cred_3146 \$I66.P8.GatPoly vout.$612.Metal2 5.62988e-08f
Cred_3147 \$I66.P8.GatPoly vout.$650.Metal2 1.8244e-05f
Cred_3148 \$I66.P8.GatPoly vout.$670.Metal2 3.60091e-05f
Cred_3149 \$I66.P8.GatPoly vout.$690.Metal2 1.04364e-05f
Cred_3150 \$I66.P8.GatPoly vout.$710.Metal2 3.55883e-05f
Cred_3151 \$I66.P8.GatPoly vout.$730.Metal2 1.93601e-05f
Cred_3152 \$I66.P8.GatPoly vout.$770.Metal2 8.46505e-05f
Cred_3153 \$I66.P8.GatPoly vout.$790.Metal2 8.72673e-05f
Cred_3154 \$I66.P8.GatPoly vout.P6.pSD 0.00019176f
Cred_3155 \$I66.P8.GatPoly vout.P8.pSD 1.10955e-06f
Cred_3156 \$I66.P8.GatPoly vref 3.01022e-06f
Cred_3157 \$I66.P8.GatPoly vref.P0.GatPoly 1.17522e-07f
Cred_3158 \$I66.P8.GatPoly vref.P0.nSD 6.43276e-07f
Cred_3159 \$I66.P8.GatPoly vref.P0.pSD 2.3739e-06f
Cred_3160 \$I66.P8.GatPoly vss 0.000471303f
Cred_3161 \$I66.P8.GatPoly vss.$1211.Metal5 0.000171976f
Cred_3162 \$I66.P8.GatPoly vss.$1229.Metal5 0.000171976f
Cred_3163 \$I66.P8.GatPoly vss.$1281.Metal5 0.000658289f
Cred_3164 \$I66.P8.GatPoly vss.$1299.Metal5 0.000658289f
Cred_3165 \$I66.P9.GatPoly \$I67.$82.Metal2 0.000158296f
Cred_3166 \$I66.P9.GatPoly \$I67.P1.GatPoly 3.56754e-06f
Cred_3167 \$I66.P9.GatPoly \$I67.P2.GatPoly 1.08208e-06f
Cred_3168 \$I66.P9.GatPoly \$I78 0.0193441f
Cred_3169 \$I66.P9.GatPoly vss 0.000168707f
Cred_3170 \$I66.P9.GatPoly vdd.$2365.Metal1 7.09543e-06f
Cred_3171 \$I66.P9.GatPoly vdd.$2379.Metal1 0.00230161f
Cred_3172 \$I66.P9.GatPoly vdd.$2399.Metal1 3.75558e-06f
Cred_3173 \$I66.P9.GatPoly vdd.$2769.Metal2 0.0144912f
Cred_3174 \$I66.P9.GatPoly vdd.$2771.Metal2 0.00784244f
Cred_3175 \$I66.P9.GatPoly vdd.$2773.Metal2 6.88024e-07f
Cred_3176 \$I66.P9.GatPoly vdd.$2775.Metal2 2.13625e-06f
Cred_3177 \$I66.P9.GatPoly vdd.$3003.Metal3 0.00521955f
Cred_3178 \$I66.P9.GatPoly vdd.$3007.Metal3 0.00521997f
Cred_3179 \$I66.P9.GatPoly vdd.$3011.Metal3 2.86361e-07f
Cred_3180 \$I66.P9.GatPoly vdd.$3239.Metal4 6.15395e-05f
Cred_3181 \$I66.P9.GatPoly vdd.$3243.Metal4 3.37644e-09f
Cred_3182 \$I66.P9.GatPoly vdd.P0.nSD 0.000624463f
Cred_3183 \$I66.P9.GatPoly vdd.P1.GatPoly 3.15594e-07f
Cred_3184 \$I66.P9.GatPoly vdd.P10.pSD 0.0280477f
Cred_3185 \$I66.P9.GatPoly vdd.P11.pSD 3.98776e-06f
Cred_3186 \$I66.P9.GatPoly vdd.P2.GatPoly 1.67042e-07f
Cred_3187 \$I66.P9.GatPoly vout.$1038.Metal3 1.15586e-06f
Cred_3188 \$I66.P9.GatPoly vout.$1040.Metal3 4.34119e-06f
Cred_3189 \$I66.P9.GatPoly vout.$1100.Metal3 1.02546e-07f
Cred_3190 \$I66.P9.GatPoly vout.$1160.Metal3 2.60128e-07f
Cred_3191 \$I66.P9.GatPoly vout.$1331.Metal4 4.30687e-07f
Cred_3192 \$I66.P9.GatPoly vout.$1332.Metal4 1.57708e-06f
Cred_3193 \$I66.P9.GatPoly vout.$1371.Metal4 2.33251e-07f
Cred_3194 \$I66.P9.GatPoly vout.$1372.Metal4 0.0253095f
Cred_3195 \$I66.P9.GatPoly vout.$159.Metal1 1.78355e-06f
Cred_3196 \$I66.P9.GatPoly vout.$160.Metal1 0.00156848f
Cred_3197 \$I66.P9.GatPoly vout.$209.Metal1 3.48737e-07f
Cred_3198 \$I66.P9.GatPoly vout.$210.Metal1 0.00539041f
Cred_3199 \$I66.P9.GatPoly vout.$230.Metal1 0.00600163f
Cred_3200 \$I66.P9.GatPoly vout.$270.Metal1 0.0059683f
Cred_3201 \$I66.P9.GatPoly vout.$290.Metal1 0.00596902f
Cred_3202 \$I66.P9.GatPoly vout.$330.Metal1 0.00600124f
Cred_3203 \$I66.P9.GatPoly vout.$350.Metal1 0.00792118f
Cred_3204 \$I66.P9.GatPoly vout.$400.Metal1 0.00871131f
Cred_3205 \$I66.P9.GatPoly vout.$590.Metal2 3.55924e-07f
Cred_3206 \$I66.P9.GatPoly vout.$592.Metal2 1.69695e-05f
Cred_3207 \$I66.P9.GatPoly vout.$610.Metal2 3.07832e-08f
Cred_3208 \$I66.P9.GatPoly vout.$612.Metal2 3.00236e-05f
Cred_3209 \$I66.P9.GatPoly vout.$652.Metal2 1.8244e-05f
Cred_3210 \$I66.P9.GatPoly vout.$672.Metal2 4.1125e-05f
Cred_3211 \$I66.P9.GatPoly vout.$712.Metal2 4.07043e-05f
Cred_3212 \$I66.P9.GatPoly vout.$732.Metal2 1.93601e-05f
Cred_3213 \$I66.P9.GatPoly vout.$772.Metal2 8.46505e-05f
Cred_3214 \$I66.P9.GatPoly vout.$792.Metal2 8.72673e-05f
Cred_3215 \$I66.P9.GatPoly vout.P6.pSD 4.71613e-07f
Cred_3216 \$I66.P9.GatPoly vout.P8.pSD 0.00019339f
Cred_3217 \$I66.P9.GatPoly vref 6.0211e-06f
Cred_3218 \$I66.P9.GatPoly vref.P0.GatPoly 2.3507e-07f
Cred_3219 \$I66.P9.GatPoly vref.P0.nSD 1.2867e-06f
Cred_3220 \$I66.P9.GatPoly vref.P0.pSD 4.74833e-06f
Cred_3221 \$I66.P9.GatPoly vss 0.000488768f
Cred_3222 \$I66.P9.GatPoly vss.$1211.Metal5 0.000178349f
Cred_3223 \$I66.P9.GatPoly vss.$1229.Metal5 0.000178349f
Cred_3224 \$I66.P9.GatPoly vss.$1281.Metal5 0.000682683f
Cred_3225 \$I66.P9.GatPoly vss.$1299.Metal5 0.000682683f
Cred_3226 \$I67 \$I67.$82.Metal2 0.00109996f
Cred_3227 \$I67 rfin 0.0363325f
Cred_3228 \$I67 vss 2.12934f
Cred_3229 \$I67 vss 0.0330806f
Cred_3230 \$I67 vss.$1211.Metal5 0.0161624f
Cred_3231 \$I67 vss.$1229.Metal5 0.0161624f
Cred_3232 \$I67 vss.$1281.Metal5 0.0618663f
Cred_3233 \$I67 vss.$1299.Metal5 0.0618663f
Cred_3234 \$I67.$82.Metal2 \$I78 0.297803f
Cred_3235 \$I67.$82.Metal2 rfin 0.00152683f
Cred_3236 \$I67.$82.Metal2 vss 2.257f
Cred_3237 \$I67.$82.Metal2 vdd.$2365.Metal1 0.00419572f
Cred_3238 \$I67.$82.Metal2 vdd.$2370.Metal1 9.04187e-07f
Cred_3239 \$I67.$82.Metal2 vdd.$2375.Metal1 1.01698e-06f
Cred_3240 \$I67.$82.Metal2 vdd.$2399.Metal1 0.001058f
Cred_3241 \$I67.$82.Metal2 vdd.$2749.Metal2 0.000542865f
Cred_3242 \$I67.$82.Metal2 vdd.$2751.Metal2 0.00032873f
Cred_3243 \$I67.$82.Metal2 vdd.$2755.Metal2 0.0007168f
Cred_3244 \$I67.$82.Metal2 vdd.$2759.Metal2 0.000562316f
Cred_3245 \$I67.$82.Metal2 vdd.$2761.Metal2 0.000318934f
Cred_3246 \$I67.$82.Metal2 vdd.$2765.Metal2 0.000706826f
Cred_3247 \$I67.$82.Metal2 vdd.$2769.Metal2 0.00117014f
Cred_3248 \$I67.$82.Metal2 vdd.$2771.Metal2 0.00042905f
Cred_3249 \$I67.$82.Metal2 vdd.$2773.Metal2 0.00155261f
Cred_3250 \$I67.$82.Metal2 vdd.$2775.Metal2 0.00481309f
Cred_3251 \$I67.$82.Metal2 vdd.$2779.Metal2 0.00390846f
Cred_3252 \$I67.$82.Metal2 vdd.$2781.Metal2 0.00126079f
Cred_3253 \$I67.$82.Metal2 vdd.$2783.Metal2 0.000130772f
Cred_3254 \$I67.$82.Metal2 vdd.$2785.Metal2 0.00035665f
Cred_3255 \$I67.$82.Metal2 vdd.$2987.Metal3 9.04187e-07f
Cred_3256 \$I67.$82.Metal2 vdd.$2997.Metal3 1.01698e-06f
Cred_3257 \$I67.$82.Metal2 vdd.P0.nSD 0.142017f
Cred_3258 \$I67.$82.Metal2 vdd.P1.GatPoly 0.000754872f
Cred_3259 \$I67.$82.Metal2 vdd.P1.pSD 0.000645851f
Cred_3260 \$I67.$82.Metal2 vdd.P10.pSD 0.00129861f
Cred_3261 \$I67.$82.Metal2 vdd.P11.pSD 0.0107928f
Cred_3262 \$I67.$82.Metal2 vdd.P13.pSD 0.00999475f
Cred_3263 \$I67.$82.Metal2 vdd.P15.pSD 0.000395809f
Cred_3264 \$I67.$82.Metal2 vdd.P2.GatPoly 4.70582e-05f
Cred_3265 \$I67.$82.Metal2 vdd.P3.pSD 0.000645466f
Cred_3266 \$I67.$82.Metal2 vdd.P5.pSD 0.000645761f
Cred_3267 \$I67.$82.Metal2 vdd.P7.pSD 0.000645648f
Cred_3268 \$I67.$82.Metal2 vout 0.0769129f
Cred_3269 \$I67.$82.Metal2 vout.$1032.Metal3 2.23559e-05f
Cred_3270 \$I67.$82.Metal2 vout.$1034.Metal3 2.23559e-05f
Cred_3271 \$I67.$82.Metal2 vout.$1036.Metal3 2.23559e-05f
Cred_3272 \$I67.$82.Metal2 vout.$1038.Metal3 0.000109902f
Cred_3273 \$I67.$82.Metal2 vout.$1040.Metal3 6.49827e-05f
Cred_3274 \$I67.$82.Metal2 vout.$121.Metal1 2.86862e-05f
Cred_3275 \$I67.$82.Metal2 vout.$122.Metal1 2.86942e-05f
Cred_3276 \$I67.$82.Metal2 vout.$123.Metal1 2.86942e-05f
Cred_3277 \$I67.$82.Metal2 vout.$1235.Metal4 2.62779e-06f
Cred_3278 \$I67.$82.Metal2 vout.$1236.Metal4 2.62779e-06f
Cred_3279 \$I67.$82.Metal2 vout.$1237.Metal4 0.00311809f
Cred_3280 \$I67.$82.Metal2 vout.$1238.Metal4 0.00147891f
Cred_3281 \$I67.$82.Metal2 vout.$1239.Metal4 0.00147481f
Cred_3282 \$I67.$82.Metal2 vout.$124.Metal1 4.48667e-05f
Cred_3283 \$I67.$82.Metal2 vout.$125.Metal1 4.47127e-05f
Cred_3284 \$I67.$82.Metal2 vout.$126.Metal1 4.46853e-05f
Cred_3285 \$I67.$82.Metal2 vout.$1264.Metal4 1.41373e-06f
Cred_3286 \$I67.$82.Metal2 vout.$127.Metal1 4.1945e-05f
Cred_3287 \$I67.$82.Metal2 vout.$1299.Metal4 0.049198f
Cred_3288 \$I67.$82.Metal2 vout.$1313.Metal4 0.0119727f
Cred_3289 \$I67.$82.Metal2 vout.$1328.Metal4 2.66259e-06f
Cred_3290 \$I67.$82.Metal2 vout.$1329.Metal4 2.66259e-06f
Cred_3291 \$I67.$82.Metal2 vout.$1330.Metal4 2.66259e-06f
Cred_3292 \$I67.$82.Metal2 vout.$1331.Metal4 0.00154279f
Cred_3293 \$I67.$82.Metal2 vout.$1332.Metal4 7.73945e-06f
Cred_3294 \$I67.$82.Metal2 vout.$1372.Metal4 0.00098811f
Cred_3295 \$I67.$82.Metal2 vout.$1383.Metal4 0.00098811f
Cred_3296 \$I67.$82.Metal2 vout.$156.Metal1 2.762e-05f
Cred_3297 \$I67.$82.Metal2 vout.$157.Metal1 2.762e-05f
Cred_3298 \$I67.$82.Metal2 vout.$158.Metal1 2.762e-05f
Cred_3299 \$I67.$82.Metal2 vout.$159.Metal1 4.25475e-05f
Cred_3300 \$I67.$82.Metal2 vout.$160.Metal1 8.0284e-05f
Cred_3301 \$I67.$82.Metal2 vout.$498.Metal2 4.68678e-07f
Cred_3302 \$I67.$82.Metal2 vout.$500.Metal2 4.68678e-07f
Cred_3303 \$I67.$82.Metal2 vout.$502.Metal2 4.14519e-06f
Cred_3304 \$I67.$82.Metal2 vout.$504.Metal2 7.30316e-07f
Cred_3305 \$I67.$82.Metal2 vout.$516.Metal2 0.00144248f
Cred_3306 \$I67.$82.Metal2 vout.$518.Metal2 0.00144332f
Cred_3307 \$I67.$82.Metal2 vout.$520.Metal2 0.00144332f
Cred_3308 \$I67.$82.Metal2 vout.$522.Metal2 0.00226308f
Cred_3309 \$I67.$82.Metal2 vout.$524.Metal2 0.00224904f
Cred_3310 \$I67.$82.Metal2 vout.$526.Metal2 0.00224618f
Cred_3311 \$I67.$82.Metal2 vout.$528.Metal2 0.00210843f
Cred_3312 \$I67.$82.Metal2 vout.$584.Metal2 0.00138767f
Cred_3313 \$I67.$82.Metal2 vout.$586.Metal2 0.00138767f
Cred_3314 \$I67.$82.Metal2 vout.$588.Metal2 0.00138767f
Cred_3315 \$I67.$82.Metal2 vout.$590.Metal2 0.00214074f
Cred_3316 \$I67.$82.Metal2 vout.$592.Metal2 0.0040336f
Cred_3317 \$I67.$82.Metal2 vout.$604.Metal2 4.48112e-07f
Cred_3318 \$I67.$82.Metal2 vout.$606.Metal2 4.48112e-07f
Cred_3319 \$I67.$82.Metal2 vout.$608.Metal2 4.48112e-07f
Cred_3320 \$I67.$82.Metal2 vout.$610.Metal2 2.20293e-06f
Cred_3321 \$I67.$82.Metal2 vout.$612.Metal2 1.30254e-06f
Cred_3322 \$I67.$82.Metal2 vout.$886.Metal3 2.33819e-05f
Cred_3323 \$I67.$82.Metal2 vout.$888.Metal3 2.33819e-05f
Cred_3324 \$I67.$82.Metal2 vout.$890.Metal3 0.0002068f
Cred_3325 \$I67.$82.Metal2 vout.$892.Metal3 3.64348e-05f
Cred_3326 \$I67.$82.Metal2 vout.$904.Metal3 2.59133e-05f
Cred_3327 \$I67.$82.Metal2 vout.$934.Metal3 4.3288e-05f
Cred_3328 \$I67.$82.Metal2 vout.$936.Metal3 4.06334e-05f
Cred_3329 \$I67.$82.Metal2 vout.P0.GatPoly 0.00985575f
Cred_3330 \$I67.$82.Metal2 vref 0.369159f
Cred_3331 \$I67.$82.Metal2 vref.P0.GatPoly 0.0312089f
Cred_3332 \$I67.$82.Metal2 vref.P0.nSD 0.0455586f
Cred_3333 \$I67.$82.Metal2 vref.P0.pSD 0.0809569f
Cred_3334 \$I67.$82.Metal2 vss 0.111645f
Cred_3335 \$I67.$82.Metal2 vss.$10.Metal1 2.18363e-06f
Cred_3336 \$I67.$82.Metal2 vss.$1211.Metal5 0.0711621f
Cred_3337 \$I67.$82.Metal2 vss.$1229.Metal5 0.0711621f
Cred_3338 \$I67.$82.Metal2 vss.$127.Metal1 0.00692383f
Cred_3339 \$I67.$82.Metal2 vss.$1281.Metal5 0.276538f
Cred_3340 \$I67.$82.Metal2 vss.$1299.Metal5 0.272394f
Cred_3341 \$I67.$82.Metal2 vss.$136.Metal1 1.51259e-06f
Cred_3342 \$I67.$82.Metal2 vss.$140.Metal1 2.87993e-06f
Cred_3343 \$I67.$82.Metal2 vss.$146.Metal1 2.70333e-06f
Cred_3344 \$I67.$82.Metal2 vss.$406.Metal1 0.0160219f
Cred_3345 \$I67.$82.Metal2 vss.$457.Metal2 0.000101122f
Cred_3346 \$I67.$82.Metal2 vss.$463.Metal2 0.000992377f
Cred_3347 \$I67.$82.Metal2 vss.$467.Metal2 0.000416018f
Cred_3348 \$I67.$82.Metal2 vss.$469.Metal2 0.000952135f
Cred_3349 \$I67.$82.Metal2 vss.$473.Metal2 0.000836396f
Cred_3350 \$I67.$82.Metal2 vss.$475.Metal2 0.00047438f
Cred_3351 \$I67.$82.Metal2 vss.$479.Metal2 0.00105129f
Cred_3352 \$I67.$82.Metal2 vss.$483.Metal2 0.00159224f
Cred_3353 \$I67.$82.Metal2 vss.$487.Metal2 0.00138308f
Cred_3354 \$I67.$82.Metal2 vss.$489.Metal2 0.00647198f
Cred_3355 \$I67.$82.Metal2 vss.$493.Metal2 0.00695721f
Cred_3356 \$I67.$82.Metal2 vss.$495.Metal2 0.00137697f
Cred_3357 \$I67.$82.Metal2 vss.$499.Metal2 0.0014946f
Cred_3358 \$I67.$82.Metal2 vss.$799.Metal3 2.18363e-06f
Cred_3359 \$I67.$82.Metal2 vss.$811.Metal3 1.51259e-06f
Cred_3360 \$I67.$82.Metal2 vss.$819.Metal3 2.87993e-06f
Cred_3361 \$I67.$82.Metal2 vss.$831.Metal3 2.70333e-06f
Cred_3362 \$I67.$82.Metal2 vss.P0.GatPoly 0.000944134f
Cred_3363 \$I67.$82.Metal2 vss.P0.pSD 0.12119f
Cred_3364 \$I67.$82.Metal2 vss.P1.nSD 0.000316549f
Cred_3365 \$I67.$82.Metal2 vss.P10.nSD 0.000492765f
Cred_3366 \$I67.$82.Metal2 vss.P11.nSD 0.00479473f
Cred_3367 \$I67.$82.Metal2 vss.P13.nSD 0.00500317f
Cred_3368 \$I67.$82.Metal2 vss.P15.nSD 0.000462547f
Cred_3369 \$I67.$82.Metal2 vss.P3.nSD 0.000315535f
Cred_3370 \$I67.$82.Metal2 vss.P5.nSD 0.000315999f
Cred_3371 \$I67.$82.Metal2 vss.P7.nSD 0.000315889f
Cred_3372 \$I67.P0.GatPoly \$I78 0.000234535f
Cred_3373 \$I67.P0.GatPoly vss 0.171767f
Cred_3374 \$I67.P0.GatPoly vdd.$2779.Metal2 3.16268e-05f
Cred_3375 \$I67.P0.GatPoly vdd.$2781.Metal2 1.02022e-05f
Cred_3376 \$I67.P0.GatPoly vdd.$2783.Metal2 1.98894e-05f
Cred_3377 \$I67.P0.GatPoly vdd.$2785.Metal2 5.42439e-05f
Cred_3378 \$I67.P0.GatPoly vdd.P13.pSD 3.39564e-05f
Cred_3379 \$I67.P0.GatPoly vdd.P15.pSD 6.01998e-05f
Cred_3380 \$I67.P0.GatPoly vout 0.00781427f
Cred_3381 \$I67.P0.GatPoly vout.$1237.Metal4 3.29803e-07f
Cred_3382 \$I67.P0.GatPoly vout.$1238.Metal4 0.000119116f
Cred_3383 \$I67.P0.GatPoly vout.$1239.Metal4 0.000118786f
Cred_3384 \$I67.P0.GatPoly vout.$124.Metal1 3.60129e-06f
Cred_3385 \$I67.P0.GatPoly vout.$125.Metal1 3.60129e-06f
Cred_3386 \$I67.P0.GatPoly vout.$126.Metal1 3.59908e-06f
Cred_3387 \$I67.P0.GatPoly vout.$127.Metal1 6.37954e-06f
Cred_3388 \$I67.P0.GatPoly vout.$1299.Metal4 0.00533004f
Cred_3389 \$I67.P0.GatPoly vout.$1313.Metal4 0.000122029f
Cred_3390 \$I67.P0.GatPoly vout.$502.Metal2 5.88218e-08f
Cred_3391 \$I67.P0.GatPoly vout.$504.Metal2 5.88218e-08f
Cred_3392 \$I67.P0.GatPoly vout.$522.Metal2 0.000181145f
Cred_3393 \$I67.P0.GatPoly vout.$524.Metal2 0.000181145f
Cred_3394 \$I67.P0.GatPoly vout.$526.Metal2 0.000180914f
Cred_3395 \$I67.P0.GatPoly vout.$528.Metal2 0.000320678f
Cred_3396 \$I67.P0.GatPoly vout.$890.Metal3 2.93457e-06f
Cred_3397 \$I67.P0.GatPoly vout.$892.Metal3 2.93457e-06f
Cred_3398 \$I67.P0.GatPoly vout.$934.Metal3 3.48654e-06f
Cred_3399 \$I67.P0.GatPoly vout.$936.Metal3 6.18006e-06f
Cred_3400 \$I67.P0.GatPoly vout.P0.GatPoly 0.00705533f
Cred_3401 \$I67.P0.GatPoly vref 0.04848f
Cred_3402 \$I67.P0.GatPoly vref.P0.GatPoly 0.00923616f
Cred_3403 \$I67.P0.GatPoly vref.P0.nSD 0.00304535f
Cred_3404 \$I67.P0.GatPoly vref.P0.pSD 0.00232681f
Cred_3405 \$I67.P0.GatPoly vss 0.000769136f
Cred_3406 \$I67.P0.GatPoly vss.$1211.Metal5 0.0007263f
Cred_3407 \$I67.P0.GatPoly vss.$1229.Metal5 0.0007263f
Cred_3408 \$I67.P0.GatPoly vss.$127.Metal1 0.000220744f
Cred_3409 \$I67.P0.GatPoly vss.$1281.Metal5 0.00278013f
Cred_3410 \$I67.P0.GatPoly vss.$1299.Metal5 0.00278013f
Cred_3411 \$I67.P0.GatPoly vss.$140.Metal1 2.31958e-07f
Cred_3412 \$I67.P0.GatPoly vss.$146.Metal1 4.11157e-07f
Cred_3413 \$I67.P0.GatPoly vss.$406.Metal1 0.00177371f
Cred_3414 \$I67.P0.GatPoly vss.$457.Metal2 3.22394e-06f
Cred_3415 \$I67.P0.GatPoly vss.$483.Metal2 0.000128244f
Cred_3416 \$I67.P0.GatPoly vss.$487.Metal2 0.000111397f
Cred_3417 \$I67.P0.GatPoly vss.$489.Metal2 0.000521273f
Cred_3418 \$I67.P0.GatPoly vss.$493.Metal2 0.000560354f
Cred_3419 \$I67.P0.GatPoly vss.$495.Metal2 0.000127309f
Cred_3420 \$I67.P0.GatPoly vss.$499.Metal2 0.000227318f
Cred_3421 \$I67.P0.GatPoly vss.$819.Metal3 2.31958e-07f
Cred_3422 \$I67.P0.GatPoly vss.$831.Metal3 4.11157e-07f
Cred_3423 \$I67.P0.GatPoly vss.P0.GatPoly 7.89182e-06f
Cred_3424 \$I67.P0.GatPoly vss.P0.pSD 0.0103021f
Cred_3425 \$I67.P0.GatPoly vss.P10.nSD 3.96887e-05f
Cred_3426 \$I67.P0.GatPoly vss.P11.nSD 0.000386182f
Cred_3427 \$I67.P0.GatPoly vss.P13.nSD 0.00040297f
Cred_3428 \$I67.P0.GatPoly vss.P15.nSD 7.03501e-05f
Cred_3429 \$I67.P1.GatPoly \$I78 0.0193869f
Cred_3430 \$I67.P1.GatPoly vss 0.000910016f
Cred_3431 \$I67.P1.GatPoly vdd.$2365.Metal1 1.01319e-05f
Cred_3432 \$I67.P1.GatPoly vdd.$2379.Metal1 0.000588948f
Cred_3433 \$I67.P1.GatPoly vdd.$2382.Metal1 0.0011883f
Cred_3434 \$I67.P1.GatPoly vdd.$2399.Metal1 9.33001e-06f
Cred_3435 \$I67.P1.GatPoly vdd.$2769.Metal2 8.4091e-06f
Cred_3436 \$I67.P1.GatPoly vdd.$2771.Metal2 3.08334e-06f
Cred_3437 \$I67.P1.GatPoly vdd.$2773.Metal2 0.00482743f
Cred_3438 \$I67.P1.GatPoly vdd.$2775.Metal2 0.0180394f
Cred_3439 \$I67.P1.GatPoly vdd.$2779.Metal2 2.40665e-05f
Cred_3440 \$I67.P1.GatPoly vdd.$2781.Metal2 7.7634e-06f
Cred_3441 \$I67.P1.GatPoly vdd.$3007.Metal3 0.00868564f
Cred_3442 \$I67.P1.GatPoly vdd.$3011.Metal3 0.00868564f
Cred_3443 \$I67.P1.GatPoly vdd.$3243.Metal4 0.000102411f
Cred_3444 \$I67.P1.GatPoly vdd.P0.nSD 0.00104385f
Cred_3445 \$I67.P1.GatPoly vdd.P1.GatPoly 4.5065e-07f
Cred_3446 \$I67.P1.GatPoly vdd.P10.pSD 9.3324e-06f
Cred_3447 \$I67.P1.GatPoly vdd.P11.pSD 0.0279726f
Cred_3448 \$I67.P1.GatPoly vdd.P13.pSD 6.55309e-05f
Cred_3449 \$I67.P1.GatPoly vdd.P2.GatPoly 4.14985e-07f
Cred_3450 \$I67.P1.GatPoly vout 0.000158294f
Cred_3451 \$I67.P1.GatPoly vout.$1040.Metal3 4.66994e-07f
Cred_3452 \$I67.P1.GatPoly vout.$1299.Metal4 1.90612e-09f
Cred_3453 \$I67.P1.GatPoly vout.$1313.Metal4 7.57718e-05f
Cred_3454 \$I67.P1.GatPoly vout.$1332.Metal4 5.5619e-08f
Cred_3455 \$I67.P1.GatPoly vout.$1372.Metal4 0.015036f
Cred_3456 \$I67.P1.GatPoly vout.$1383.Metal4 6.76389e-06f
Cred_3457 \$I67.P1.GatPoly vout.$160.Metal1 5.76955e-07f
Cred_3458 \$I67.P1.GatPoly vout.$592.Metal2 2.89872e-05f
Cred_3459 \$I67.P1.GatPoly vout.$612.Metal2 9.36063e-09f
Cred_3460 \$I67.P1.GatPoly vout.P0.GatPoly 2.4831e-08f
Cred_3461 \$I67.P1.GatPoly vref 0.00568654f
Cred_3462 \$I67.P1.GatPoly vref.P0.GatPoly 0.000221743f
Cred_3463 \$I67.P1.GatPoly vref.P0.nSD 0.00127118f
Cred_3464 \$I67.P1.GatPoly vref.P0.pSD 0.0428255f
Cred_3465 \$I67.P1.GatPoly vss 0.000497389f
Cred_3466 \$I67.P1.GatPoly vss.$1211.Metal5 0.000187073f
Cred_3467 \$I67.P1.GatPoly vss.$1229.Metal5 0.000187073f
Cred_3468 \$I67.P1.GatPoly vss.$1281.Metal5 0.000716077f
Cred_3469 \$I67.P1.GatPoly vss.$1299.Metal5 0.000716077f
Cred_3470 \$I67.P2.GatPoly \$I78 0.0193786f
Cred_3471 \$I67.P2.GatPoly vss 0.000886525f
Cred_3472 \$I67.P2.GatPoly vdd.$2365.Metal1 9.36016e-06f
Cred_3473 \$I67.P2.GatPoly vdd.$2382.Metal1 0.0011883f
Cred_3474 \$I67.P2.GatPoly vdd.$2385.Metal1 0.000588948f
Cred_3475 \$I67.P2.GatPoly vdd.$2399.Metal1 9.45271e-06f
Cred_3476 \$I67.P2.GatPoly vdd.$2769.Metal2 8.0099e-06f
Cred_3477 \$I67.P2.GatPoly vdd.$2771.Metal2 2.93696e-06f
Cred_3478 \$I67.P2.GatPoly vdd.$2773.Metal2 1.0628e-05f
Cred_3479 \$I67.P2.GatPoly vdd.$2775.Metal2 3.29469e-05f
Cred_3480 \$I67.P2.GatPoly vdd.$2779.Metal2 0.0180412f
Cred_3481 \$I67.P2.GatPoly vdd.$2781.Metal2 0.00482802f
Cred_3482 \$I67.P2.GatPoly vdd.$3011.Metal3 0.00868564f
Cred_3483 \$I67.P2.GatPoly vdd.$3015.Metal3 0.00868564f
Cred_3484 \$I67.P2.GatPoly vdd.$3247.Metal4 0.000102411f
Cred_3485 \$I67.P2.GatPoly vdd.P0.nSD 0.00100495f
Cred_3486 \$I67.P2.GatPoly vdd.P1.GatPoly 4.16326e-07f
Cred_3487 \$I67.P2.GatPoly vdd.P10.pSD 8.88937e-06f
Cred_3488 \$I67.P2.GatPoly vdd.P11.pSD 7.38798e-05f
Cred_3489 \$I67.P2.GatPoly vdd.P13.pSD 0.0279873f
Cred_3490 \$I67.P2.GatPoly vdd.P2.GatPoly 4.20442e-07f
Cred_3491 \$I67.P2.GatPoly vout 0.000166183f
Cred_3492 \$I67.P2.GatPoly vout.$1040.Metal3 4.44824e-07f
Cred_3493 \$I67.P2.GatPoly vout.$1299.Metal4 2.00112e-09f
Cred_3494 \$I67.P2.GatPoly vout.$1313.Metal4 7.95481e-05f
Cred_3495 \$I67.P2.GatPoly vout.$1332.Metal4 5.29787e-08f
Cred_3496 \$I67.P2.GatPoly vout.$1372.Metal4 6.76389e-06f
Cred_3497 \$I67.P2.GatPoly vout.$1373.Metal4 0.00154106f
Cred_3498 \$I67.P2.GatPoly vout.$1383.Metal4 0.0124564f
Cred_3499 \$I67.P2.GatPoly vout.$160.Metal1 5.49566e-07f
Cred_3500 \$I67.P2.GatPoly vout.$592.Metal2 2.76111e-05f
Cred_3501 \$I67.P2.GatPoly vout.$612.Metal2 8.91625e-09f
Cred_3502 \$I67.P2.GatPoly vout.P0.GatPoly 2.60685e-08f
Cred_3503 \$I67.P2.GatPoly vref 0.00568424f
Cred_3504 \$I67.P2.GatPoly vref.P0.GatPoly 0.000221654f
Cred_3505 \$I67.P2.GatPoly vref.P0.nSD 0.00127067f
Cred_3506 \$I67.P2.GatPoly vref.P0.pSD 0.0428239f
Cred_3507 \$I67.P2.GatPoly vss 0.000495209f
Cred_3508 \$I67.P2.GatPoly vss.$1211.Metal5 0.000186013f
Cred_3509 \$I67.P2.GatPoly vss.$1229.Metal5 0.000186013f
Cred_3510 \$I67.P2.GatPoly vss.$1281.Metal5 0.000712018f
Cred_3511 \$I67.P2.GatPoly vss.$1299.Metal5 0.000712018f
Cred_3512 \$I67.P3.GatPoly \$I78 1.52161e-05f
Cred_3513 \$I67.P3.GatPoly vss 0.0259095f
Cred_3514 \$I67.P3.GatPoly vdd.$2779.Metal2 2.88014e-06f
Cred_3515 \$I67.P3.GatPoly vdd.$2781.Metal2 9.29078e-07f
Cred_3516 \$I67.P3.GatPoly vdd.$2783.Metal2 9.59178e-07f
Cred_3517 \$I67.P3.GatPoly vdd.$2785.Metal2 2.61594e-06f
Cred_3518 \$I67.P3.GatPoly vdd.P13.pSD 3.09229e-06f
Cred_3519 \$I67.P3.GatPoly vdd.P15.pSD 2.90317e-06f
Cred_3520 \$I67.P3.GatPoly vout 0.000315163f
Cred_3521 \$I67.P3.GatPoly vout.$1237.Metal4 3.0034e-08f
Cred_3522 \$I67.P3.GatPoly vout.$1238.Metal4 0.00862204f
Cred_3523 \$I67.P3.GatPoly vout.$1239.Metal4 1.6642e-05f
Cred_3524 \$I67.P3.GatPoly vout.$124.Metal1 3.27957e-07f
Cred_3525 \$I67.P3.GatPoly vout.$125.Metal1 3.27957e-07f
Cred_3526 \$I67.P3.GatPoly vout.$126.Metal1 3.27756e-07f
Cred_3527 \$I67.P3.GatPoly vout.$127.Metal1 3.07657e-07f
Cred_3528 \$I67.P3.GatPoly vout.$1299.Metal4 0.000400894f
Cred_3529 \$I67.P3.GatPoly vout.$1313.Metal4 4.18816e-06f
Cred_3530 \$I67.P3.GatPoly vout.$502.Metal2 5.3567e-09f
Cred_3531 \$I67.P3.GatPoly vout.$504.Metal2 5.3567e-09f
Cred_3532 \$I67.P3.GatPoly vout.$522.Metal2 1.64962e-05f
Cred_3533 \$I67.P3.GatPoly vout.$524.Metal2 1.64962e-05f
Cred_3534 \$I67.P3.GatPoly vout.$526.Metal2 1.64752e-05f
Cred_3535 \$I67.P3.GatPoly vout.$528.Metal2 1.54649e-05f
Cred_3536 \$I67.P3.GatPoly vout.$890.Metal3 2.67241e-07f
Cred_3537 \$I67.P3.GatPoly vout.$892.Metal3 2.67241e-07f
Cred_3538 \$I67.P3.GatPoly vout.$934.Metal3 3.17507e-07f
Cred_3539 \$I67.P3.GatPoly vout.$936.Metal3 2.98037e-07f
Cred_3540 \$I67.P3.GatPoly vout.P0.GatPoly 7.22506e-05f
Cred_3541 \$I67.P3.GatPoly vref 0.0052243f
Cred_3542 \$I67.P3.GatPoly vref.P0.GatPoly 0.000300561f
Cred_3543 \$I67.P3.GatPoly vref.P0.nSD 0.0219042f
Cred_3544 \$I67.P3.GatPoly vref.P0.pSD 0.0013646f
Cred_3545 \$I67.P3.GatPoly vss 7.17398e-05f
Cred_3546 \$I67.P3.GatPoly vss.$1033.Metal4 1.01147e-05f
Cred_3547 \$I67.P3.GatPoly vss.$1211.Metal5 6.78921e-05f
Cred_3548 \$I67.P3.GatPoly vss.$1229.Metal5 6.78921e-05f
Cred_3549 \$I67.P3.GatPoly vss.$127.Metal1 3.46985e-05f
Cred_3550 \$I67.P3.GatPoly vss.$1281.Metal5 0.000259877f
Cred_3551 \$I67.P3.GatPoly vss.$1299.Metal5 0.000259877f
Cred_3552 \$I67.P3.GatPoly vss.$140.Metal1 0.000339451f
Cred_3553 \$I67.P3.GatPoly vss.$143.Metal1 0.000684922f
Cred_3554 \$I67.P3.GatPoly vss.$146.Metal1 1.98283e-08f
Cred_3555 \$I67.P3.GatPoly vss.$406.Metal1 0.000209216f
Cred_3556 \$I67.P3.GatPoly vss.$457.Metal2 5.06767e-07f
Cred_3557 \$I67.P3.GatPoly vss.$483.Metal2 1.16787e-05f
Cred_3558 \$I67.P3.GatPoly vss.$487.Metal2 0.00471224f
Cred_3559 \$I67.P3.GatPoly vss.$489.Metal2 0.0164478f
Cred_3560 \$I67.P3.GatPoly vss.$493.Metal2 7.16646e-05f
Cred_3561 \$I67.P3.GatPoly vss.$495.Metal2 1.24254e-05f
Cred_3562 \$I67.P3.GatPoly vss.$499.Metal2 1.09625e-05f
Cred_3563 \$I67.P3.GatPoly vss.$819.Metal3 2.11236e-08f
Cred_3564 \$I67.P3.GatPoly vss.$821.Metal3 0.000857845f
Cred_3565 \$I67.P3.GatPoly vss.$825.Metal3 0.000857845f
Cred_3566 \$I67.P3.GatPoly vss.$831.Metal3 1.98283e-08f
Cred_3567 \$I67.P3.GatPoly vss.P0.GatPoly 1.24051e-06f
Cred_3568 \$I67.P3.GatPoly vss.P0.pSD 0.00145504f
Cred_3569 \$I67.P3.GatPoly vss.P10.nSD 3.61431e-06f
Cred_3570 \$I67.P3.GatPoly vss.P11.nSD 0.0165207f
Cred_3571 \$I67.P3.GatPoly vss.P13.nSD 5.40405e-05f
Cred_3572 \$I67.P3.GatPoly vss.P15.nSD 3.39267e-06f
Cred_3573 \$I67.P4.GatPoly \$I78 1.52161e-05f
Cred_3574 \$I67.P4.GatPoly vss 0.025886f
Cred_3575 \$I67.P4.GatPoly vdd.$2779.Metal2 2.88014e-06f
Cred_3576 \$I67.P4.GatPoly vdd.$2781.Metal2 9.29078e-07f
Cred_3577 \$I67.P4.GatPoly vdd.$2783.Metal2 9.59178e-07f
Cred_3578 \$I67.P4.GatPoly vdd.$2785.Metal2 2.61594e-06f
Cred_3579 \$I67.P4.GatPoly vdd.P13.pSD 3.09229e-06f
Cred_3580 \$I67.P4.GatPoly vdd.P15.pSD 2.90317e-06f
Cred_3581 \$I67.P4.GatPoly vout 0.000315163f
Cred_3582 \$I67.P4.GatPoly vout.$1237.Metal4 3.0034e-08f
Cred_3583 \$I67.P4.GatPoly vout.$1238.Metal4 1.66721e-05f
Cred_3584 \$I67.P4.GatPoly vout.$1239.Metal4 0.00791992f
Cred_3585 \$I67.P4.GatPoly vout.$124.Metal1 3.27957e-07f
Cred_3586 \$I67.P4.GatPoly vout.$125.Metal1 3.27957e-07f
Cred_3587 \$I67.P4.GatPoly vout.$126.Metal1 3.27756e-07f
Cred_3588 \$I67.P4.GatPoly vout.$127.Metal1 3.07657e-07f
Cred_3589 \$I67.P4.GatPoly vout.$1299.Metal4 0.000407542f
Cred_3590 \$I67.P4.GatPoly vout.$1313.Metal4 4.18816e-06f
Cred_3591 \$I67.P4.GatPoly vout.$502.Metal2 5.3567e-09f
Cred_3592 \$I67.P4.GatPoly vout.$504.Metal2 5.3567e-09f
Cred_3593 \$I67.P4.GatPoly vout.$522.Metal2 1.64962e-05f
Cred_3594 \$I67.P4.GatPoly vout.$524.Metal2 1.64962e-05f
Cred_3595 \$I67.P4.GatPoly vout.$526.Metal2 1.64752e-05f
Cred_3596 \$I67.P4.GatPoly vout.$528.Metal2 1.54649e-05f
Cred_3597 \$I67.P4.GatPoly vout.$890.Metal3 2.67241e-07f
Cred_3598 \$I67.P4.GatPoly vout.$892.Metal3 2.67241e-07f
Cred_3599 \$I67.P4.GatPoly vout.$934.Metal3 3.17507e-07f
Cred_3600 \$I67.P4.GatPoly vout.$936.Metal3 2.98037e-07f
Cred_3601 \$I67.P4.GatPoly vout.P0.GatPoly 7.22506e-05f
Cred_3602 \$I67.P4.GatPoly vref 0.00522457f
Cred_3603 \$I67.P4.GatPoly vref.P0.GatPoly 0.000300572f
Cred_3604 \$I67.P4.GatPoly vref.P0.nSD 0.0219035f
Cred_3605 \$I67.P4.GatPoly vref.P0.pSD 0.00136471f
Cred_3606 \$I67.P4.GatPoly vss 7.13217e-05f
Cred_3607 \$I67.P4.GatPoly vss.$1037.Metal4 1.01147e-05f
Cred_3608 \$I67.P4.GatPoly vss.$1211.Metal5 6.74608e-05f
Cred_3609 \$I67.P4.GatPoly vss.$1229.Metal5 6.74608e-05f
Cred_3610 \$I67.P4.GatPoly vss.$127.Metal1 3.2258e-05f
Cred_3611 \$I67.P4.GatPoly vss.$1281.Metal5 0.000258226f
Cred_3612 \$I67.P4.GatPoly vss.$1299.Metal5 0.000258226f
Cred_3613 \$I67.P4.GatPoly vss.$140.Metal1 2.11236e-08f
Cred_3614 \$I67.P4.GatPoly vss.$143.Metal1 0.000684922f
Cred_3615 \$I67.P4.GatPoly vss.$146.Metal1 0.00033945f
Cred_3616 \$I67.P4.GatPoly vss.$406.Metal1 0.000216707f
Cred_3617 \$I67.P4.GatPoly vss.$457.Metal2 4.71124e-07f
Cred_3618 \$I67.P4.GatPoly vss.$483.Metal2 1.16787e-05f
Cred_3619 \$I67.P4.GatPoly vss.$487.Metal2 1.24353e-05f
Cred_3620 \$I67.P4.GatPoly vss.$489.Metal2 6.61892e-05f
Cred_3621 \$I67.P4.GatPoly vss.$493.Metal2 0.0164574f
Cred_3622 \$I67.P4.GatPoly vss.$495.Metal2 0.0047134f
Cred_3623 \$I67.P4.GatPoly vss.$499.Metal2 1.09625e-05f
Cred_3624 \$I67.P4.GatPoly vss.$819.Metal3 2.11236e-08f
Cred_3625 \$I67.P4.GatPoly vss.$825.Metal3 0.000857845f
Cred_3626 \$I67.P4.GatPoly vss.$829.Metal3 0.000857845f
Cred_3627 \$I67.P4.GatPoly vss.$831.Metal3 1.98283e-08f
Cred_3628 \$I67.P4.GatPoly vss.P0.GatPoly 1.15326e-06f
Cred_3629 \$I67.P4.GatPoly vss.P0.pSD 0.00141747f
Cred_3630 \$I67.P4.GatPoly vss.P10.nSD 3.61431e-06f
Cred_3631 \$I67.P4.GatPoly vss.P11.nSD 5.16885e-05f
Cred_3632 \$I67.P4.GatPoly vss.P13.nSD 0.0165332f
Cred_3633 \$I67.P4.GatPoly vss.P15.nSD 3.39267e-06f
Cred_3634 \$I78 vdd 0.0066338f
Cred_3635 \$I78 vdd.$2365.Metal1 0.225967f
Cred_3636 \$I78 vdd.$2367.Metal1 0.0531715f
Cred_3637 \$I78 vdd.$2370.Metal1 0.0485432f
Cred_3638 \$I78 vdd.$2372.Metal1 0.0485633f
Cred_3639 \$I78 vdd.$2375.Metal1 0.0485452f
Cred_3640 \$I78 vdd.$2377.Metal1 0.0392822f
Cred_3641 \$I78 vdd.$2379.Metal1 0.0480496f
Cred_3642 \$I78 vdd.$2382.Metal1 0.0592572f
Cred_3643 \$I78 vdd.$2385.Metal1 0.0480496f
Cred_3644 \$I78 vdd.$2387.Metal1 0.0392822f
Cred_3645 \$I78 vdd.$2389.Metal1 0.0485452f
Cred_3646 \$I78 vdd.$2392.Metal1 0.0485633f
Cred_3647 \$I78 vdd.$2394.Metal1 0.0485432f
Cred_3648 \$I78 vdd.$2397.Metal1 0.0531715f
Cred_3649 \$I78 vdd.$2399.Metal1 0.224677f
Cred_3650 \$I78 vdd.$2745.Metal2 0.0370619f
Cred_3651 \$I78 vdd.$2747.Metal2 0.170704f
Cred_3652 \$I78 vdd.$2749.Metal2 0.0355107f
Cred_3653 \$I78 vdd.$2751.Metal2 0.0197308f
Cred_3654 \$I78 vdd.$2755.Metal2 0.0398128f
Cred_3655 \$I78 vdd.$2759.Metal2 0.0309636f
Cred_3656 \$I78 vdd.$2761.Metal2 0.0215152f
Cred_3657 \$I78 vdd.$2765.Metal2 0.0394127f
Cred_3658 \$I78 vdd.$2769.Metal2 0.0315967f
Cred_3659 \$I78 vdd.$2771.Metal2 0.0142217f
Cred_3660 \$I78 vdd.$2773.Metal2 0.0138126f
Cred_3661 \$I78 vdd.$2775.Metal2 0.0331274f
Cred_3662 \$I78 vdd.$2779.Metal2 0.0331274f
Cred_3663 \$I78 vdd.$2781.Metal2 0.0138126f
Cred_3664 \$I78 vdd.$2783.Metal2 0.0142217f
Cred_3665 \$I78 vdd.$2785.Metal2 0.0315967f
Cred_3666 \$I78 vdd.$2789.Metal2 0.0394127f
Cred_3667 \$I78 vdd.$2793.Metal2 0.0215152f
Cred_3668 \$I78 vdd.$2795.Metal2 0.0309636f
Cred_3669 \$I78 vdd.$2799.Metal2 0.0398128f
Cred_3670 \$I78 vdd.$2803.Metal2 0.0197308f
Cred_3671 \$I78 vdd.$2805.Metal2 0.0355107f
Cred_3672 \$I78 vdd.$2807.Metal2 0.170704f
Cred_3673 \$I78 vdd.$2809.Metal2 0.0370619f
Cred_3674 \$I78 vdd.$2979.Metal3 0.0328507f
Cred_3675 \$I78 vdd.$2983.Metal3 0.00583064f
Cred_3676 \$I78 vdd.$2987.Metal3 0.00666051f
Cred_3677 \$I78 vdd.$2991.Metal3 0.00491132f
Cred_3678 \$I78 vdd.$2993.Metal3 0.00383615f
Cred_3679 \$I78 vdd.$2997.Metal3 0.00664049f
Cred_3680 \$I78 vdd.$3001.Metal3 0.00496492f
Cred_3681 \$I78 vdd.$3003.Metal3 0.00378687f
Cred_3682 \$I78 vdd.$3007.Metal3 0.00640711f
Cred_3683 \$I78 vdd.$3011.Metal3 0.00607686f
Cred_3684 \$I78 vdd.$3015.Metal3 0.00640711f
Cred_3685 \$I78 vdd.$3019.Metal3 0.00378687f
Cred_3686 \$I78 vdd.$3021.Metal3 0.00496492f
Cred_3687 \$I78 vdd.$3025.Metal3 0.00664049f
Cred_3688 \$I78 vdd.$3029.Metal3 0.00383615f
Cred_3689 \$I78 vdd.$3031.Metal3 0.00491132f
Cred_3690 \$I78 vdd.$3035.Metal3 0.00666051f
Cred_3691 \$I78 vdd.$3039.Metal3 0.00583064f
Cred_3692 \$I78 vdd.$3043.Metal3 0.0328507f
Cred_3693 \$I78 vdd.$3213.Metal4 0.027663f
Cred_3694 \$I78 vdd.$3215.Metal4 0.0041252f
Cred_3695 \$I78 vdd.$3219.Metal4 0.00547691f
Cred_3696 \$I78 vdd.$3223.Metal4 0.00275747f
Cred_3697 \$I78 vdd.$3225.Metal4 0.00392743f
Cred_3698 \$I78 vdd.$3229.Metal4 0.00511173f
Cred_3699 \$I78 vdd.$3233.Metal4 0.00279566f
Cred_3700 \$I78 vdd.$3235.Metal4 0.00390434f
Cred_3701 \$I78 vdd.$3239.Metal4 0.00505577f
Cred_3702 \$I78 vdd.$3243.Metal4 0.00435457f
Cred_3703 \$I78 vdd.$3247.Metal4 0.00435457f
Cred_3704 \$I78 vdd.$3251.Metal4 0.00505577f
Cred_3705 \$I78 vdd.$3255.Metal4 0.00390434f
Cred_3706 \$I78 vdd.$3257.Metal4 0.00279566f
Cred_3707 \$I78 vdd.$3261.Metal4 0.00511173f
Cred_3708 \$I78 vdd.$3265.Metal4 0.00392743f
Cred_3709 \$I78 vdd.$3267.Metal4 0.00275747f
Cred_3710 \$I78 vdd.$3271.Metal4 0.00547691f
Cred_3711 \$I78 vdd.$3275.Metal4 0.0041252f
Cred_3712 \$I78 vdd.$3277.Metal4 0.027663f
Cred_3713 \$I78 vdd.$3448.Metal5 0.00278232f
Cred_3714 \$I78 vdd.$3450.Metal5 0.00357473f
Cred_3715 \$I78 vdd.$3452.Metal5 0.00249293f
Cred_3716 \$I78 vdd.$3453.Metal5 0.00231787f
Cred_3717 \$I78 vdd.$3455.Metal5 0.00354088f
Cred_3718 \$I78 vdd.$3456.Metal5 0.00226103f
Cred_3719 \$I78 vdd.$3458.Metal5 0.00352633f
Cred_3720 \$I78 vdd.$3460.Metal5 0.00391598f
Cred_3721 \$I78 vdd.$3462.Metal5 0.00377467f
Cred_3722 \$I78 vdd.$3464.Metal5 0.00391598f
Cred_3723 \$I78 vdd.$3466.Metal5 0.00352633f
Cred_3724 \$I78 vdd.$3468.Metal5 0.00226103f
Cred_3725 \$I78 vdd.$3469.Metal5 0.00354088f
Cred_3726 \$I78 vdd.$3471.Metal5 0.00231787f
Cred_3727 \$I78 vdd.$3472.Metal5 0.00249293f
Cred_3728 \$I78 vdd.$3474.Metal5 0.00357473f
Cred_3729 \$I78 vdd.$3476.Metal5 0.00278232f
Cred_3730 \$I78 vdd.$3480.Metal5 0.0104636f
Cred_3731 \$I78 vdd.$3496.Metal5 0.0104636f
Cred_3732 \$I78 vdd.$3615.TopMetal1 0.00838315f
Cred_3733 \$I78 vdd.$3617.TopMetal1 0.00938179f
Cred_3734 \$I78 vdd.$3619.TopMetal1 0.00676162f
Cred_3735 \$I78 vdd.$3620.TopMetal1 0.00768981f
Cred_3736 \$I78 vdd.$3622.TopMetal1 0.00768981f
Cred_3737 \$I78 vdd.$3623.TopMetal1 0.00676162f
Cred_3738 \$I78 vdd.$3625.TopMetal1 0.00938179f
Cred_3739 \$I78 vdd.$3627.TopMetal1 0.00838315f
Cred_3740 \$I78 vdd.$3700.TopMetal1 0.0352374f
Cred_3741 \$I78 vdd.$3707.TopMetal1 0.0352374f
Cred_3742 \$I78 vdd.$4071.TopMetal1 0.00662023f
Cred_3743 \$I78 vdd.$4456.TopMetal1 3.55015e-07f
Cred_3744 \$I78 vdd.$4841.TopMetal1 1.9038e-11f
Cred_3745 \$I78 vdd.$5226.TopMetal1 1.02098e-15f
Cred_3746 \$I78 vdd.P0.GatPoly 1.393e-05f
Cred_3747 \$I78 vdd.P0.nSD 1.46744f
Cred_3748 \$I78 vdd.P0.pSD 0.140537f
Cred_3749 \$I78 vdd.P1.GatPoly 0.0311374f
Cred_3750 \$I78 vdd.P1.pSD 0.0114953f
Cred_3751 \$I78 vdd.P10.pSD 0.0121667f
Cred_3752 \$I78 vdd.P11.pSD 0.0127131f
Cred_3753 \$I78 vdd.P13.pSD 0.0127131f
Cred_3754 \$I78 vdd.P15.pSD 0.0121667f
Cred_3755 \$I78 vdd.P17.pSD 0.0121729f
Cred_3756 \$I78 vdd.P19.pSD 0.0121711f
Cred_3757 \$I78 vdd.P2.GatPoly 0.0308446f
Cred_3758 \$I78 vdd.P21.pSD 0.0121644f
Cred_3759 \$I78 vdd.P23.pSD 0.0114953f
Cred_3760 \$I78 vdd.P25.pSD 0.140537f
Cred_3761 \$I78 vdd.P3.pSD 0.0121644f
Cred_3762 \$I78 vdd.P5.pSD 0.0121711f
Cred_3763 \$I78 vdd.P7.pSD 0.0121729f
Cred_3764 \$I78 vout 0.0140913f
Cred_3765 \$I78 vout.$1002.Metal3 7.15149e-05f
Cred_3766 \$I78 vout.$1004.Metal3 7.15149e-05f
Cred_3767 \$I78 vout.$1006.Metal3 7.15149e-05f
Cred_3768 \$I78 vout.$1008.Metal3 7.15149e-05f
Cred_3769 \$I78 vout.$1010.Metal3 0.0124583f
Cred_3770 \$I78 vout.$1032.Metal3 0.0211564f
Cred_3771 \$I78 vout.$1034.Metal3 0.000113476f
Cred_3772 \$I78 vout.$1036.Metal3 5.9859e-05f
Cred_3773 \$I78 vout.$1038.Metal3 0.000113476f
Cred_3774 \$I78 vout.$1040.Metal3 0.000113476f
Cred_3775 \$I78 vout.$1050.Metal3 0.00763406f
Cred_3776 \$I78 vout.$1070.Metal3 0.00763406f
Cred_3777 \$I78 vout.$1072.Metal3 0.010362f
Cred_3778 \$I78 vout.$1110.Metal3 0.0101452f
Cred_3779 \$I78 vout.$1112.Metal3 0.0103438f
Cred_3780 \$I78 vout.$1150.Metal3 0.0101452f
Cred_3781 \$I78 vout.$1152.Metal3 0.0217844f
Cred_3782 \$I78 vout.$1154.Metal3 0.00167957f
Cred_3783 \$I78 vout.$1156.Metal3 0.00167957f
Cred_3784 \$I78 vout.$1158.Metal3 0.00167957f
Cred_3785 \$I78 vout.$1160.Metal3 0.00189025f
Cred_3786 \$I78 vout.$1162.Metal3 0.00189025f
Cred_3787 \$I78 vout.$1164.Metal3 0.00167957f
Cred_3788 \$I78 vout.$1166.Metal3 0.00167957f
Cred_3789 \$I78 vout.$1190.Metal3 0.0182489f
Cred_3790 \$I78 vout.$1208.Metal3 0.00214354f
Cred_3791 \$I78 vout.$1299.Metal4 7.05277e-05f
Cred_3792 \$I78 vout.$1313.Metal4 0.0672616f
Cred_3793 \$I78 vout.$1323.Metal4 0.00448812f
Cred_3794 \$I78 vout.$1328.Metal4 0.0212553f
Cred_3795 \$I78 vout.$1329.Metal4 0.00109943f
Cred_3796 \$I78 vout.$1330.Metal4 7.12921e-06f
Cred_3797 \$I78 vout.$1331.Metal4 0.00109943f
Cred_3798 \$I78 vout.$1332.Metal4 0.00109943f
Cred_3799 \$I78 vout.$1333.Metal4 0.00453845f
Cred_3800 \$I78 vout.$1343.Metal4 0.00448812f
Cred_3801 \$I78 vout.$1353.Metal4 0.00448812f
Cred_3802 \$I78 vout.$1363.Metal4 0.00453845f
Cred_3803 \$I78 vout.$1368.Metal4 0.0170997f
Cred_3804 \$I78 vout.$1369.Metal4 0.00743474f
Cred_3805 \$I78 vout.$1370.Metal4 0.00718962f
Cred_3806 \$I78 vout.$1371.Metal4 0.00709605f
Cred_3807 \$I78 vout.$1372.Metal4 0.0111726f
Cred_3808 \$I78 vout.$1373.Metal4 0.00531865f
Cred_3809 \$I78 vout.$1383.Metal4 0.00992677f
Cred_3810 \$I78 vout.$1384.Metal4 0.00453845f
Cred_3811 \$I78 vout.$1394.Metal4 0.00660422f
Cred_3812 \$I78 vout.$1395.Metal4 0.00448812f
Cred_3813 \$I78 vout.$1405.Metal4 0.00453845f
Cred_3814 \$I78 vout.$1408.Metal4 0.0256928f
Cred_3815 \$I78 vout.$1415.Metal4 0.0129104f
Cred_3816 \$I78 vout.$1416.Metal4 0.0171776f
Cred_3817 \$I78 vout.$156.Metal1 0.00697415f
Cred_3818 \$I78 vout.$157.Metal1 0.00696419f
Cred_3819 \$I78 vout.$158.Metal1 0.00696413f
Cred_3820 \$I78 vout.$159.Metal1 0.00696419f
Cred_3821 \$I78 vout.$160.Metal1 0.00696419f
Cred_3822 \$I78 vout.$161.Metal1 0.00696409f
Cred_3823 \$I78 vout.$162.Metal1 0.00696409f
Cred_3824 \$I78 vout.$163.Metal1 0.00696409f
Cred_3825 \$I78 vout.$164.Metal1 0.00696409f
Cred_3826 \$I78 vout.$165.Metal1 0.00696591f
Cred_3827 \$I78 vout.$396.Metal1 0.00640433f
Cred_3828 \$I78 vout.$397.Metal1 0.0063953f
Cred_3829 \$I78 vout.$398.Metal1 0.0063953f
Cred_3830 \$I78 vout.$399.Metal1 0.0063953f
Cred_3831 \$I78 vout.$400.Metal1 0.00639556f
Cred_3832 \$I78 vout.$401.Metal1 0.00639556f
Cred_3833 \$I78 vout.$402.Metal1 0.0063953f
Cred_3834 \$I78 vout.$403.Metal1 0.0063953f
Cred_3835 \$I78 vout.$404.Metal1 0.00639406f
Cred_3836 \$I78 vout.$405.Metal1 0.00639961f
Cred_3837 \$I78 vout.$584.Metal2 0.00465774f
Cred_3838 \$I78 vout.$586.Metal2 0.0037206f
Cred_3839 \$I78 vout.$588.Metal2 0.00371556f
Cred_3840 \$I78 vout.$590.Metal2 0.0037206f
Cred_3841 \$I78 vout.$592.Metal2 0.0037206f
Cred_3842 \$I78 vout.$594.Metal2 0.00371084f
Cred_3843 \$I78 vout.$596.Metal2 0.00371084f
Cred_3844 \$I78 vout.$598.Metal2 0.00371084f
Cred_3845 \$I78 vout.$600.Metal2 0.00371084f
Cred_3846 \$I78 vout.$602.Metal2 0.00380245f
Cred_3847 \$I78 vout.$604.Metal2 0.000266702f
Cred_3848 \$I78 vout.$606.Metal2 2.27456e-06f
Cred_3849 \$I78 vout.$608.Metal2 1.19984e-06f
Cred_3850 \$I78 vout.$610.Metal2 2.27456e-06f
Cred_3851 \$I78 vout.$612.Metal2 2.27456e-06f
Cred_3852 \$I78 vout.$622.Metal2 5.03342e-05f
Cred_3853 \$I78 vout.$644.Metal2 5.2052e-05f
Cred_3854 \$I78 vout.$682.Metal2 5.03342e-05f
Cred_3855 \$I78 vout.$684.Metal2 5.03342e-05f
Cred_3856 \$I78 vout.$722.Metal2 5.03342e-05f
Cred_3857 \$I78 vout.$724.Metal2 5.18595e-05f
Cred_3858 \$I78 vout.$762.Metal2 5.03342e-05f
Cred_3859 \$I78 vout.$764.Metal2 0.000281097f
Cred_3860 \$I78 vout.$766.Metal2 3.3666e-05f
Cred_3861 \$I78 vout.$768.Metal2 3.3666e-05f
Cred_3862 \$I78 vout.$770.Metal2 3.3666e-05f
Cred_3863 \$I78 vout.$772.Metal2 3.78891e-05f
Cred_3864 \$I78 vout.$774.Metal2 3.78891e-05f
Cred_3865 \$I78 vout.$776.Metal2 3.3666e-05f
Cred_3866 \$I78 vout.$778.Metal2 3.3666e-05f
Cred_3867 \$I78 vout.$784.Metal2 0.00382377f
Cred_3868 \$I78 vout.$786.Metal2 0.00296848f
Cred_3869 \$I78 vout.$788.Metal2 0.00296848f
Cred_3870 \$I78 vout.$790.Metal2 0.00296848f
Cred_3871 \$I78 vout.$792.Metal2 0.00298993f
Cred_3872 \$I78 vout.$794.Metal2 0.00298993f
Cred_3873 \$I78 vout.$796.Metal2 0.00296848f
Cred_3874 \$I78 vout.$798.Metal2 0.00296848f
Cred_3875 \$I78 vout.$800.Metal2 0.00283749f
Cred_3876 \$I78 vout.$802.Metal2 0.00332912f
Cred_3877 \$I78 vout.P0.GatPoly 0.00218992f
Cred_3878 \$I78 vref 0.055306f
Cred_3879 \$I78 vref.P0.GatPoly 0.00110189f
Cred_3880 \$I78 vref.P0.nSD 0.00492468f
Cred_3881 \$I78 vref.P0.pSD 0.0242283f
Cred_3882 \$I78 vss 0.144399f
Cred_3883 \$I78 vss.$1211.Metal5 0.0321204f
Cred_3884 \$I78 vss.$1229.Metal5 0.0321204f
Cred_3885 \$I78 vss.$1281.Metal5 0.12295f
Cred_3886 \$I78 vss.$1299.Metal5 0.12295f
Cred_3887 rfin vss 3.26259f
Cred_3888 vss vdd 0.796555f
Cred_3889 vss vdd.$2365.Metal1 0.170734f
Cred_3890 vss vdd.$2367.Metal1 0.0407532f
Cred_3891 vss vdd.$2370.Metal1 0.0408374f
Cred_3892 vss vdd.$2372.Metal1 0.0408364f
Cred_3893 vss vdd.$2375.Metal1 0.0408375f
Cred_3894 vss vdd.$2377.Metal1 0.0328287f
Cred_3895 vss vdd.$2379.Metal1 0.0407554f
Cred_3896 vss vdd.$2382.Metal1 0.0488493f
Cred_3897 vss vdd.$2385.Metal1 0.0407554f
Cred_3898 vss vdd.$2387.Metal1 0.0328287f
Cred_3899 vss vdd.$2389.Metal1 0.0408381f
Cred_3900 vss vdd.$2392.Metal1 0.0408364f
Cred_3901 vss vdd.$2394.Metal1 0.040838f
Cred_3902 vss vdd.$2397.Metal1 0.0407532f
Cred_3903 vss vdd.$2399.Metal1 0.172549f
Cred_3904 vss vdd.$2745.Metal2 0.0451737f
Cred_3905 vss vdd.$2747.Metal2 0.0719927f
Cred_3906 vss vdd.$2749.Metal2 0.0197875f
Cred_3907 vss vdd.$2751.Metal2 0.0220659f
Cred_3908 vss vdd.$2755.Metal2 0.0295112f
Cred_3909 vss vdd.$2759.Metal2 0.02231f
Cred_3910 vss vdd.$2761.Metal2 0.0220522f
Cred_3911 vss vdd.$2765.Metal2 0.029496f
Cred_3912 vss vdd.$2769.Metal2 0.0214287f
Cred_3913 vss vdd.$2771.Metal2 0.0143369f
Cred_3914 vss vdd.$2773.Metal2 0.0144979f
Cred_3915 vss vdd.$2775.Metal2 0.0216207f
Cred_3916 vss vdd.$2779.Metal2 0.0227282f
Cred_3917 vss vdd.$2781.Metal2 0.0148552f
Cred_3918 vss vdd.$2783.Metal2 0.0147298f
Cred_3919 vss vdd.$2785.Metal2 0.0225003f
Cred_3920 vss vdd.$2789.Metal2 0.0298893f
Cred_3921 vss vdd.$2793.Metal2 0.0222297f
Cred_3922 vss vdd.$2795.Metal2 0.0226229f
Cred_3923 vss vdd.$2799.Metal2 0.0299101f
Cred_3924 vss vdd.$2803.Metal2 0.0222489f
Cred_3925 vss vdd.$2805.Metal2 0.0200896f
Cred_3926 vss vdd.$2807.Metal2 0.0719927f
Cred_3927 vss vdd.$2809.Metal2 0.0451737f
Cred_3928 vss vdd.$2979.Metal3 0.050296f
Cred_3929 vss vdd.$2983.Metal3 0.0256552f
Cred_3930 vss vdd.$2987.Metal3 0.0257395f
Cred_3931 vss vdd.$2991.Metal3 0.0193095f
Cred_3932 vss vdd.$2993.Metal3 0.0192963f
Cred_3933 vss vdd.$2997.Metal3 0.0257396f
Cred_3934 vss vdd.$3001.Metal3 0.0193095f
Cred_3935 vss vdd.$3003.Metal3 0.0192963f
Cred_3936 vss vdd.$3007.Metal3 0.0256552f
Cred_3937 vss vdd.$3011.Metal3 0.0257383f
Cred_3938 vss vdd.$3015.Metal3 0.0256552f
Cred_3939 vss vdd.$3019.Metal3 0.0192963f
Cred_3940 vss vdd.$3021.Metal3 0.0193095f
Cred_3941 vss vdd.$3025.Metal3 0.0257402f
Cred_3942 vss vdd.$3029.Metal3 0.0192963f
Cred_3943 vss vdd.$3031.Metal3 0.0193095f
Cred_3944 vss vdd.$3035.Metal3 0.02574f
Cred_3945 vss vdd.$3039.Metal3 0.0256552f
Cred_3946 vss vdd.$3043.Metal3 0.050296f
Cred_3947 vss vdd.$3213.Metal4 0.0422293f
Cred_3948 vss vdd.$3215.Metal4 0.0180271f
Cred_3949 vss vdd.$3219.Metal4 0.0239504f
Cred_3950 vss vdd.$3223.Metal4 0.0180201f
Cred_3951 vss vdd.$3225.Metal4 0.0179307f
Cred_3952 vss vdd.$3229.Metal4 0.0239503f
Cred_3953 vss vdd.$3233.Metal4 0.0180057f
Cred_3954 vss vdd.$3235.Metal4 0.0179451f
Cred_3955 vss vdd.$3239.Metal4 0.0239504f
Cred_3956 vss vdd.$3243.Metal4 0.0240027f
Cred_3957 vss vdd.$3247.Metal4 0.0240027f
Cred_3958 vss vdd.$3251.Metal4 0.0239504f
Cred_3959 vss vdd.$3255.Metal4 0.0179451f
Cred_3960 vss vdd.$3257.Metal4 0.0180057f
Cred_3961 vss vdd.$3261.Metal4 0.0239503f
Cred_3962 vss vdd.$3265.Metal4 0.0179307f
Cred_3963 vss vdd.$3267.Metal4 0.0180201f
Cred_3964 vss vdd.$3271.Metal4 0.0239504f
Cred_3965 vss vdd.$3275.Metal4 0.0180271f
Cred_3966 vss vdd.$3277.Metal4 0.0422293f
Cred_3967 vss vdd.$3448.Metal5 0.00557392f
Cred_3968 vss vdd.$3450.Metal5 0.00497825f
Cred_3969 vss vdd.$3452.Metal5 0.00369516f
Cred_3970 vss vdd.$3453.Metal5 0.00374833f
Cred_3971 vss vdd.$3455.Metal5 0.00375333f
Cred_3972 vss vdd.$3456.Metal5 0.00369896f
Cred_3973 vss vdd.$3458.Metal5 0.00498028f
Cred_3974 vss vdd.$3460.Metal5 0.0125706f
Cred_3975 vss vdd.$3462.Metal5 0.0228419f
Cred_3976 vss vdd.$3464.Metal5 0.0125706f
Cred_3977 vss vdd.$3466.Metal5 0.00498028f
Cred_3978 vss vdd.$3468.Metal5 0.00369896f
Cred_3979 vss vdd.$3469.Metal5 0.00375333f
Cred_3980 vss vdd.$3471.Metal5 0.00374833f
Cred_3981 vss vdd.$3472.Metal5 0.00369516f
Cred_3982 vss vdd.$3474.Metal5 0.00497825f
Cred_3983 vss vdd.$3476.Metal5 0.00557392f
Cred_3984 vss vdd.$3480.Metal5 0.0175271f
Cred_3985 vss vdd.$3496.Metal5 0.0175271f
Cred_3986 vss vdd.$3615.TopMetal1 0.040721f
Cred_3987 vss vdd.$3617.TopMetal1 0.0126862f
Cred_3988 vss vdd.$3619.TopMetal1 0.00950626f
Cred_3989 vss vdd.$3620.TopMetal1 0.0339764f
Cred_3990 vss vdd.$3622.TopMetal1 0.0339764f
Cred_3991 vss vdd.$3623.TopMetal1 0.00950626f
Cred_3992 vss vdd.$3625.TopMetal1 0.0126862f
Cred_3993 vss vdd.$3627.TopMetal1 0.040721f
Cred_3994 vss vdd.$3700.TopMetal1 0.337621f
Cred_3995 vss vdd.$3707.TopMetal1 0.337621f
Cred_3996 vss vdd.$4071.TopMetal1 3.1989f
Cred_3997 vss vdd.$4456.TopMetal1 1.62831f
Cred_3998 vss vdd.$4841.TopMetal1 1.62833f
Cred_3999 vss vdd.$5226.TopMetal1 3.56394f
Cred_4000 vss vdd.P0.GatPoly 0.32247f
Cred_4001 vss vdd.P0.nSD 1.16481f
Cred_4002 vss vdd.P0.pSD 0.0260163f
Cred_4003 vss vdd.P1.GatPoly 0.00438398f
Cred_4004 vss vdd.P1.pSD 0.000877917f
Cred_4005 vss vdd.P13.pSD 0.00118906f
Cred_4006 vss vdd.P15.pSD 0.00118926f
Cred_4007 vss vdd.P17.pSD 0.00125534f
Cred_4008 vss vdd.P19.pSD 0.00123712f
Cred_4009 vss vdd.P2.GatPoly 0.00481985f
Cred_4010 vss vdd.P21.pSD 0.00125294f
Cred_4011 vss vdd.P23.pSD 0.0012373f
Cred_4012 vss vdd.P25.pSD 0.0260163f
Cred_4013 vss vdd.P3.pSD 0.000893779f
Cred_4014 vss vdd.P5.pSD 0.000877794f
Cred_4015 vss vdd.P7.pSD 0.000896072f
Cred_4016 vss vout 0.299505f
Cred_4017 vss vout.$1002.Metal3 4.91965e-05f
Cred_4018 vss vout.$1004.Metal3 2.56524e-05f
Cred_4019 vss vout.$1006.Metal3 5.11682e-05f
Cred_4020 vss vout.$1008.Metal3 5.11682e-05f
Cred_4021 vss vout.$1010.Metal3 0.00989638f
Cred_4022 vss vout.$1032.Metal3 0.017382f
Cred_4023 vss vout.$1034.Metal3 0.000156039f
Cred_4024 vss vout.$1036.Metal3 3.03888e-05f
Cred_4025 vss vout.$1040.Metal3 0.000106212f
Cred_4026 vss vout.$1050.Metal3 0.00634773f
Cred_4027 vss vout.$1070.Metal3 0.00634773f
Cred_4028 vss vout.$1072.Metal3 0.00866045f
Cred_4029 vss vout.$11.Metal1 0.00637176f
Cred_4030 vss vout.$1110.Metal3 0.00843573f
Cred_4031 vss vout.$1112.Metal3 0.00864157f
Cred_4032 vss vout.$1150.Metal3 0.00843573f
Cred_4033 vss vout.$1152.Metal3 0.0167728f
Cred_4034 vss vout.$1190.Metal3 0.0136246f
Cred_4035 vss vout.$12.Metal1 0.0063624f
Cred_4036 vss vout.$121.Metal1 0.00704501f
Cred_4037 vss vout.$122.Metal1 0.00703859f
Cred_4038 vss vout.$123.Metal1 0.00703838f
Cred_4039 vss vout.$1235.Metal4 0.0529381f
Cred_4040 vss vout.$1236.Metal4 0.0112426f
Cred_4041 vss vout.$1237.Metal4 0.0132307f
Cred_4042 vss vout.$1238.Metal4 0.0226656f
Cred_4043 vss vout.$1239.Metal4 0.0117366f
Cred_4044 vss vout.$124.Metal1 0.00701104f
Cred_4045 vss vout.$1240.Metal4 0.00778874f
Cred_4046 vss vout.$1241.Metal4 0.0152043f
Cred_4047 vss vout.$125.Metal1 0.0070112f
Cred_4048 vss vout.$1252.Metal4 0.0371416f
Cred_4049 vss vout.$126.Metal1 0.00701086f
Cred_4050 vss vout.$1261.Metal4 0.00921214f
Cred_4051 vss vout.$1264.Metal4 0.0410166f
Cred_4052 vss vout.$1269.Metal4 0.0116238f
Cred_4053 vss vout.$127.Metal1 0.00701086f
Cred_4054 vss vout.$1279.Metal4 0.00921214f
Cred_4055 vss vout.$128.Metal1 0.00705533f
Cred_4056 vss vout.$1289.Metal4 0.00912034f
Cred_4057 vss vout.$129.Metal1 0.00705533f
Cred_4058 vss vout.$1299.Metal4 0.172357f
Cred_4059 vss vout.$13.Metal1 0.0063624f
Cred_4060 vss vout.$130.Metal1 0.00705839f
Cred_4061 vss vout.$1313.Metal4 0.0576954f
Cred_4062 vss vout.$1323.Metal4 0.00465632f
Cred_4063 vss vout.$1328.Metal4 0.0231651f
Cred_4064 vss vout.$1329.Metal4 0.00256342f
Cred_4065 vss vout.$1330.Metal4 3.61931e-06f
Cred_4066 vss vout.$1332.Metal4 0.0021638f
Cred_4067 vss vout.$1333.Metal4 0.00469817f
Cred_4068 vss vout.$1343.Metal4 0.00465632f
Cred_4069 vss vout.$1353.Metal4 0.00465632f
Cred_4070 vss vout.$1363.Metal4 0.00469817f
Cred_4071 vss vout.$1368.Metal4 0.018985f
Cred_4072 vss vout.$1369.Metal4 0.00339015f
Cred_4073 vss vout.$1370.Metal4 0.00169507f
Cred_4074 vss vout.$1371.Metal4 0.00100065f
Cred_4075 vss vout.$1372.Metal4 0.00122572f
Cred_4076 vss vout.$1373.Metal4 0.00752118f
Cred_4077 vss vout.$1384.Metal4 0.00469817f
Cred_4078 vss vout.$1395.Metal4 0.00465632f
Cred_4079 vss vout.$14.Metal1 0.0063624f
Cred_4080 vss vout.$1405.Metal4 0.00469817f
Cred_4081 vss vout.$1408.Metal4 0.0220826f
Cred_4082 vss vout.$1416.Metal4 0.0135533f
Cred_4083 vss vout.$15.Metal1 0.00636271f
Cred_4084 vss vout.$156.Metal1 4.55686e-05f
Cred_4085 vss vout.$157.Metal1 3.76772e-05f
Cred_4086 vss vout.$158.Metal1 3.75443e-05f
Cred_4087 vss vout.$16.Metal1 0.00636271f
Cred_4088 vss vout.$160.Metal1 1.12289e-07f
Cred_4089 vss vout.$161.Metal1 5.08432e-05f
Cred_4090 vss vout.$162.Metal1 2.65111e-05f
Cred_4091 vss vout.$163.Metal1 5.2881e-05f
Cred_4092 vss vout.$164.Metal1 5.2881e-05f
Cred_4093 vss vout.$165.Metal1 5.42236e-05f
Cred_4094 vss vout.$17.Metal1 0.0063624f
Cred_4095 vss vout.$18.Metal1 0.00636125f
Cred_4096 vss vout.$19.Metal1 0.00636128f
Cred_4097 vss vout.$20.Metal1 0.00636424f
Cred_4098 vss vout.$396.Metal1 7.52369e-06f
Cred_4099 vss vout.$405.Metal1 4.05246e-06f
Cred_4100 vss vout.$436.Metal2 0.0037311f
Cred_4101 vss vout.$438.Metal2 0.00293942f
Cred_4102 vss vout.$440.Metal2 0.00293942f
Cred_4103 vss vout.$442.Metal2 0.00293942f
Cred_4104 vss vout.$444.Metal2 0.00296496f
Cred_4105 vss vout.$446.Metal2 0.00296496f
Cred_4106 vss vout.$448.Metal2 0.00293942f
Cred_4107 vss vout.$450.Metal2 0.00281887f
Cred_4108 vss vout.$452.Metal2 0.00282012f
Cred_4109 vss vout.$454.Metal2 0.00296904f
Cred_4110 vss vout.$458.Metal2 3.06963e-05f
Cred_4111 vss vout.$460.Metal2 3.06963e-05f
Cred_4112 vss vout.$462.Metal2 3.06963e-05f
Cred_4113 vss vout.$464.Metal2 3.57238e-05f
Cred_4114 vss vout.$466.Metal2 3.57238e-05f
Cred_4115 vss vout.$468.Metal2 3.06963e-05f
Cred_4116 vss vout.$474.Metal2 9.18032e-05f
Cred_4117 vss vout.$476.Metal2 8.64848e-05f
Cred_4118 vss vout.$498.Metal2 8.59498e-06f
Cred_4119 vss vout.$500.Metal2 3.77248e-06f
Cred_4120 vss vout.$502.Metal2 4.16546e-06f
Cred_4121 vss vout.$504.Metal2 7.69877e-06f
Cred_4122 vss vout.$514.Metal2 9.18032e-05f
Cred_4123 vss vout.$516.Metal2 0.00628434f
Cred_4124 vss vout.$518.Metal2 0.00573698f
Cred_4125 vss vout.$520.Metal2 0.00571716f
Cred_4126 vss vout.$522.Metal2 0.00434358f
Cred_4127 vss vout.$524.Metal2 0.0043581f
Cred_4128 vss vout.$526.Metal2 0.00432672f
Cred_4129 vss vout.$528.Metal2 0.00432672f
Cred_4130 vss vout.$530.Metal2 0.00656183f
Cred_4131 vss vout.$532.Metal2 0.00656183f
Cred_4132 vss vout.$534.Metal2 0.00671601f
Cred_4133 vss vout.$584.Metal2 0.00264458f
Cred_4134 vss vout.$586.Metal2 0.0018981f
Cred_4135 vss vout.$588.Metal2 0.00188629f
Cred_4136 vss vout.$592.Metal2 9.98114e-06f
Cred_4137 vss vout.$594.Metal2 0.00255276f
Cred_4138 vss vout.$596.Metal2 0.00133108f
Cred_4139 vss vout.$598.Metal2 0.00265508f
Cred_4140 vss vout.$600.Metal2 0.00265508f
Cred_4141 vss vout.$602.Metal2 0.00272249f
Cred_4142 vss vout.$604.Metal2 0.000216672f
Cred_4143 vss vout.$606.Metal2 3.12771e-06f
Cred_4144 vss vout.$608.Metal2 6.09126e-07f
Cred_4145 vss vout.$612.Metal2 2.12896e-06f
Cred_4146 vss vout.$622.Metal2 4.18529e-05f
Cred_4147 vss vout.$644.Metal2 4.36331e-05f
Cred_4148 vss vout.$682.Metal2 4.18529e-05f
Cred_4149 vss vout.$684.Metal2 4.18529e-05f
Cred_4150 vss vout.$722.Metal2 4.18529e-05f
Cred_4151 vss vout.$724.Metal2 4.34332e-05f
Cred_4152 vss vout.$762.Metal2 4.18529e-05f
Cred_4153 vss vout.$764.Metal2 0.000206335f
Cred_4154 vss vout.$784.Metal2 0.000713311f
Cred_4155 vss vout.$802.Metal2 0.00034933f
Cred_4156 vss vout.$858.Metal3 0.00183736f
Cred_4157 vss vout.$860.Metal3 0.00190219f
Cred_4158 vss vout.$862.Metal3 0.0235518f
Cred_4159 vss vout.$864.Metal3 0.0329864f
Cred_4160 vss vout.$886.Metal3 0.00196021f
Cred_4161 vss vout.$888.Metal3 0.00171962f
Cred_4162 vss vout.$890.Metal3 0.00173922f
Cred_4163 vss vout.$892.Metal3 0.00216631f
Cred_4164 vss vout.$894.Metal3 0.00178223f
Cred_4165 vss vout.$896.Metal3 0.00153141f
Cred_4166 vss vout.$902.Metal3 0.0185035f
Cred_4167 vss vout.$904.Metal3 0.0227075f
Cred_4168 vss vout.$934.Metal3 8.3384e-05f
Cred_4169 vss vout.$936.Metal3 8.3384e-05f
Cred_4170 vss vout.$938.Metal3 0.000126459f
Cred_4171 vss vout.$940.Metal3 0.000126459f
Cred_4172 vss vout.$942.Metal3 0.022049f
Cred_4173 vss vout.P0.GatPoly 0.151902f
Cred_4174 vss vref 0.798285f
Cred_4175 vss vref.P0.GatPoly 0.144763f
Cred_4176 vss vref.P0.nSD 0.0419616f
Cred_4177 vss vref.P0.pSD 0.0554945f
Cred_4179 vss vss.$10.Metal1 0.105436f
Cred_4180 vss vss.$1001.Metal4 0.0470493f
Cred_4181 vss vss.$1003.Metal4 0.0222917f
Cred_4182 vss vss.$1005.Metal4 0.0158879f
Cred_4183 vss vss.$1007.Metal4 0.0160114f
Cred_4184 vss vss.$1009.Metal4 0.0158765f
Cred_4185 vss vss.$1011.Metal4 0.0136167f
Cred_4186 vss vss.$1013.Metal4 0.0126234f
Cred_4187 vss vss.$1015.Metal4 0.0136175f
Cred_4188 vss vss.$1017.Metal4 0.0127913f
Cred_4189 vss vss.$1019.Metal4 0.0133687f
Cred_4190 vss vss.$1021.Metal4 0.0134931f
Cred_4191 vss vss.$1023.Metal4 0.0126652f
Cred_4192 vss vss.$1025.Metal4 0.0135346f
Cred_4193 vss vss.$1027.Metal4 0.0127493f
Cred_4194 vss vss.$1029.Metal4 0.0134102f
Cred_4195 vss vss.$1031.Metal4 0.0133895f
Cred_4196 vss vss.$1033.Metal4 0.0193325f
Cred_4197 vss vss.$1037.Metal4 0.0193325f
Cred_4198 vss vss.$1039.Metal4 0.0133895f
Cred_4199 vss vss.$1041.Metal4 0.0134102f
Cred_4200 vss vss.$1043.Metal4 0.0127493f
Cred_4201 vss vss.$1045.Metal4 0.0136175f
Cred_4202 vss vss.$1047.Metal4 0.0126654f
Cred_4203 vss vss.$1049.Metal4 0.0134931f
Cred_4204 vss vss.$1051.Metal4 0.0133687f
Cred_4205 vss vss.$1053.Metal4 0.0127913f
Cred_4206 vss vss.$1055.Metal4 0.0136175f
Cred_4207 vss vss.$1057.Metal4 0.0126234f
Cred_4208 vss vss.$1059.Metal4 0.0136167f
Cred_4209 vss vss.$1061.Metal4 0.0157167f
Cred_4210 vss vss.$1063.Metal4 0.0157998f
Cred_4211 vss vss.$1065.Metal4 0.0157045f
Cred_4212 vss vss.$1067.Metal4 0.0220491f
Cred_4213 vss vss.$1069.Metal4 0.0468403f
Cred_4214 vss vss.$1211.Metal5 8.25887f
Cred_4215 vss vss.$1229.Metal5 8.19062f
Cred_4216 vss vss.$1246.Metal5 0.0445705f
Cred_4217 vss vss.$127.Metal1 0.448562f
Cred_4218 vss vss.$1281.Metal5 11.5776f
Cred_4219 vss vss.$1299.Metal5 11.4997f
Cred_4220 vss vss.$13.Metal1 0.104921f
Cred_4221 vss vss.$136.Metal1 0.0885958f
Cred_4222 vss vss.$138.Metal1 0.070187f
Cred_4223 vss vss.$140.Metal1 0.0884682f
Cred_4224 vss vss.$143.Metal1 0.106551f
Cred_4225 vss vss.$146.Metal1 0.0884682f
Cred_4226 vss vss.$148.Metal1 0.070187f
Cred_4227 vss vss.$150.Metal1 0.0885967f
Cred_4228 vss vss.$153.Metal1 0.104921f
Cred_4229 vss vss.$156.Metal1 0.105437f
Cred_4230 vss vss.$159.Metal1 0.33071f
Cred_4231 vss vss.$406.Metal1 0.737068f
Cred_4232 vss vss.$457.Metal2 0.0720501f
Cred_4233 vss vss.$461.Metal2 0.207778f
Cred_4234 vss vss.$463.Metal2 0.0669566f
Cred_4235 vss vss.$467.Metal2 0.0410751f
Cred_4236 vss vss.$469.Metal2 0.0576908f
Cred_4237 vss vss.$473.Metal2 0.0542848f
Cred_4238 vss vss.$475.Metal2 0.0438045f
Cred_4239 vss vss.$479.Metal2 0.0699388f
Cred_4240 vss vss.$483.Metal2 0.0680303f
Cred_4241 vss vss.$487.Metal2 0.0425085f
Cred_4242 vss vss.$489.Metal2 0.0557684f
Cred_4243 vss vss.$493.Metal2 0.0557684f
Cred_4244 vss vss.$495.Metal2 0.0425085f
Cred_4245 vss vss.$499.Metal2 0.0680303f
Cred_4246 vss vss.$503.Metal2 0.0705662f
Cred_4247 vss vss.$507.Metal2 0.0440875f
Cred_4248 vss vss.$509.Metal2 0.0547837f
Cred_4249 vss vss.$513.Metal2 0.0582587f
Cred_4250 vss vss.$515.Metal2 0.0413232f
Cred_4251 vss vss.$519.Metal2 0.067547f
Cred_4252 vss vss.$521.Metal2 0.207778f
Cred_4253 vss vss.$525.Metal2 0.070327f
Cred_4254 vss vss.$793.Metal3 0.072766f
Cred_4255 vss vss.$795.Metal3 0.0252772f
Cred_4256 vss vss.$799.Metal3 0.0247913f
Cred_4257 vss vss.$801.Metal3 0.0236661f
Cred_4258 vss vss.$805.Metal3 0.0311271f
Cred_4259 vss vss.$809.Metal3 0.0234803f
Cred_4260 vss vss.$811.Metal3 0.0237563f
Cred_4261 vss vss.$815.Metal3 0.0311122f
Cred_4262 vss vss.$819.Metal3 0.0236887f
Cred_4263 vss vss.$821.Metal3 0.0233854f
Cred_4264 vss vss.$825.Metal3 0.0312806f
Cred_4265 vss vss.$829.Metal3 0.0233854f
Cred_4266 vss vss.$831.Metal3 0.0236887f
Cred_4267 vss vss.$835.Metal3 0.0311324f
Cred_4268 vss vss.$839.Metal3 0.0237775f
Cred_4269 vss vss.$841.Metal3 0.0234803f
Cred_4270 vss vss.$845.Metal3 0.0311271f
Cred_4271 vss vss.$849.Metal3 0.0236661f
Cred_4272 vss vss.$851.Metal3 0.0246472f
Cred_4273 vss vss.$855.Metal3 0.0249919f
Cred_4274 vss vss.$857.Metal3 0.0723972f
Cred_4275 vss vss.P0.GatPoly 0.0436483f
Cred_4276 vss vss.P0.nSD 0.0604584f
Cred_4277 vss vss.P0.pSD 1.38184f
Cred_4278 vss vss.P1.GatPoly 0.039933f
Cred_4279 vss vss.P1.nSD 0.00846377f
Cred_4280 vss vss.P10.nSD 0.00853128f
Cred_4281 vss vss.P11.nSD 0.00898107f
Cred_4282 vss vss.P13.nSD 0.00898107f
Cred_4283 vss vss.P15.nSD 0.00853128f
Cred_4284 vss vss.P17.nSD 0.00900735f
Cred_4285 vss vss.P19.nSD 0.00899452f
Cred_4286 vss vss.P21.nSD 0.0089797f
Cred_4287 vss vss.P23.nSD 0.00865259f
Cred_4288 vss vss.P25.nSD 0.0604584f
Cred_4289 vss vss.P3.nSD 0.00879149f
Cred_4290 vss vss.P5.nSD 0.00880602f
Cred_4291 vss vss.P7.nSD 0.00881893f
Cred_4292 vdd vss 199.55f
Cred_4293 vdd vss.$1211.Metal5 26.9064f
Cred_4294 vdd vss.$1229.Metal5 26.9064f
Cred_4295 vdd vss.$1281.Metal5 102.992f
Cred_4296 vdd vss.$1299.Metal5 102.992f
Cred_4297 vdd.$2365.Metal1 vout 0.000167311f
Cred_4298 vdd.$2365.Metal1 vout.$1002.Metal3 2.58495e-09f
Cred_4299 vdd.$2365.Metal1 vout.$1004.Metal3 1.68676e-09f
Cred_4300 vdd.$2365.Metal1 vout.$1006.Metal3 1.64075e-09f
Cred_4301 vdd.$2365.Metal1 vout.$1008.Metal3 1.24238e-09f
Cred_4302 vdd.$2365.Metal1 vout.$1010.Metal3 9.82649e-10f
Cred_4303 vdd.$2365.Metal1 vout.$1032.Metal3 1.05387e-08f
Cred_4304 vdd.$2365.Metal1 vout.$1034.Metal3 7.84824e-09f
Cred_4305 vdd.$2365.Metal1 vout.$1036.Metal3 5.48533e-09f
Cred_4306 vdd.$2365.Metal1 vout.$1038.Metal3 4.2113e-09f
Cred_4307 vdd.$2365.Metal1 vout.$1040.Metal3 3.67783e-09f
Cred_4308 vdd.$2365.Metal1 vout.$1299.Metal4 3.89736e-07f
Cred_4309 vdd.$2365.Metal1 vout.$1313.Metal4 0.000129918f
Cred_4310 vdd.$2365.Metal1 vout.$1328.Metal4 1.25516e-09f
Cred_4311 vdd.$2365.Metal1 vout.$1329.Metal4 9.34727e-10f
Cred_4312 vdd.$2365.Metal1 vout.$1330.Metal4 6.53304e-10f
Cred_4313 vdd.$2365.Metal1 vout.$1331.Metal4 5.01567e-10f
Cred_4314 vdd.$2365.Metal1 vout.$1332.Metal4 4.38031e-10f
Cred_4315 vdd.$2365.Metal1 vout.$156.Metal1 0.0001061f
Cred_4316 vdd.$2365.Metal1 vout.$157.Metal1 7.90135e-05f
Cred_4317 vdd.$2365.Metal1 vout.$158.Metal1 5.52245e-05f
Cred_4318 vdd.$2365.Metal1 vout.$159.Metal1 4.2398e-05f
Cred_4319 vdd.$2365.Metal1 vout.$160.Metal1 3.70272e-05f
Cred_4320 vdd.$2365.Metal1 vout.$161.Metal1 2.17828e-05f
Cred_4321 vdd.$2365.Metal1 vout.$162.Metal1 1.42139e-05f
Cred_4322 vdd.$2365.Metal1 vout.$163.Metal1 1.38263e-05f
Cred_4323 vdd.$2365.Metal1 vout.$164.Metal1 1.04693e-05f
Cred_4324 vdd.$2365.Metal1 vout.$165.Metal1 8.28057e-06f
Cred_4325 vdd.$2365.Metal1 vout.$584.Metal2 6.54155e-07f
Cred_4326 vdd.$2365.Metal1 vout.$586.Metal2 4.87155e-07f
Cred_4327 vdd.$2365.Metal1 vout.$588.Metal2 3.40485e-07f
Cred_4328 vdd.$2365.Metal1 vout.$590.Metal2 2.61404e-07f
Cred_4329 vdd.$2365.Metal1 vout.$592.Metal2 2.2829e-07f
Cred_4330 vdd.$2365.Metal1 vout.$594.Metal2 1.34131e-07f
Cred_4331 vdd.$2365.Metal1 vout.$596.Metal2 8.75243e-08f
Cred_4332 vdd.$2365.Metal1 vout.$598.Metal2 8.51372e-08f
Cred_4333 vdd.$2365.Metal1 vout.$600.Metal2 6.44659e-08f
Cred_4334 vdd.$2365.Metal1 vout.$602.Metal2 5.09888e-08f
Cred_4335 vdd.$2365.Metal1 vout.$604.Metal2 2.11242e-10f
Cred_4336 vdd.$2365.Metal1 vout.$606.Metal2 1.57314e-10f
Cred_4337 vdd.$2365.Metal1 vout.$608.Metal2 1.0995e-10f
Cred_4338 vdd.$2365.Metal1 vout.$610.Metal2 8.44133e-11f
Cred_4339 vdd.$2365.Metal1 vout.$612.Metal2 7.37201e-11f
Cred_4340 vdd.$2365.Metal1 vout.P0.GatPoly 2.51813e-05f
Cred_4341 vdd.$2365.Metal1 vref 0.000343541f
Cred_4342 vdd.$2365.Metal1 vref.P0.GatPoly 1.23008e-05f
Cred_4343 vdd.$2365.Metal1 vref.P0.nSD 5.89837e-05f
Cred_4344 vdd.$2365.Metal1 vref.P0.pSD 0.00019546f
Cred_4345 vdd.$2365.Metal1 vss 0.0264379f
Cred_4346 vdd.$2365.Metal1 vss.$1211.Metal5 0.00488021f
Cred_4347 vdd.$2365.Metal1 vss.$1229.Metal5 0.00488021f
Cred_4348 vdd.$2365.Metal1 vss.$127.Metal1 6.54402e-05f
Cred_4349 vdd.$2365.Metal1 vss.$1281.Metal5 0.0186804f
Cred_4350 vdd.$2365.Metal1 vss.$1299.Metal5 0.0186804f
Cred_4351 vdd.$2365.Metal1 vss.$406.Metal1 4.89155e-05f
Cred_4352 vdd.$2365.Metal1 vss.$457.Metal2 9.55746e-07f
Cred_4353 vdd.$2365.Metal1 vss.P0.GatPoly 2.33955e-06f
Cred_4354 vdd.$2365.Metal1 vss.P0.pSD 0.000764698f
Cred_4355 vdd.$2367.Metal1 vout.$1152.Metal3 4.42513e-08f
Cred_4356 vdd.$2367.Metal1 vout.$1408.Metal4 5.50118e-09f
Cred_4357 vdd.$2367.Metal1 vout.$396.Metal1 0.000447393f
Cred_4358 vdd.$2367.Metal1 vout.$764.Metal2 8.86993e-10f
Cred_4359 vdd.$2367.Metal1 vout.$784.Metal2 2.75837e-06f
Cred_4360 vdd.$2367.Metal1 vss 0.0068246f
Cred_4361 vdd.$2367.Metal1 vss.$1211.Metal5 0.000450867f
Cred_4362 vdd.$2367.Metal1 vss.$1229.Metal5 0.000450867f
Cred_4363 vdd.$2367.Metal1 vss.$1281.Metal5 0.00172583f
Cred_4364 vdd.$2367.Metal1 vss.$1299.Metal5 0.00172583f
Cred_4365 vdd.$2370.Metal1 vout.$1032.Metal3 8.49086e-06f
Cred_4366 vdd.$2370.Metal1 vout.$1034.Metal3 9.68087e-06f
Cred_4367 vdd.$2370.Metal1 vout.$1072.Metal3 5.69854e-06f
Cred_4368 vdd.$2370.Metal1 vout.$1074.Metal3 4.34266e-06f
Cred_4369 vdd.$2370.Metal1 vout.$1112.Metal3 1.0796e-05f
Cred_4370 vdd.$2370.Metal1 vout.$1114.Metal3 5.79824e-06f
Cred_4371 vdd.$2370.Metal1 vout.$1152.Metal3 2.60518e-05f
Cred_4372 vdd.$2370.Metal1 vout.$1154.Metal3 1.37385e-05f
Cred_4373 vdd.$2370.Metal1 vout.$1328.Metal4 3.05957e-06f
Cred_4374 vdd.$2370.Metal1 vout.$1329.Metal4 2.80578e-06f
Cred_4375 vdd.$2370.Metal1 vout.$1368.Metal4 9.76282e-05f
Cred_4376 vdd.$2370.Metal1 vout.$1369.Metal4 1.77746e-05f
Cred_4377 vdd.$2370.Metal1 vout.$1408.Metal4 0.00113752f
Cred_4378 vdd.$2370.Metal1 vout.$156.Metal1 3.05189e-05f
Cred_4379 vdd.$2370.Metal1 vout.$157.Metal1 3.04946e-05f
Cred_4380 vdd.$2370.Metal1 vout.$206.Metal1 2.79835e-05f
Cred_4381 vdd.$2370.Metal1 vout.$207.Metal1 2.79436e-05f
Cred_4382 vdd.$2370.Metal1 vout.$226.Metal1 2.08893e-05f
Cred_4383 vdd.$2370.Metal1 vout.$227.Metal1 2.16828e-05f
Cred_4384 vdd.$2370.Metal1 vout.$266.Metal1 2.1801e-05f
Cred_4385 vdd.$2370.Metal1 vout.$267.Metal1 2.18743e-05f
Cred_4386 vdd.$2370.Metal1 vout.$286.Metal1 2.21617e-05f
Cred_4387 vdd.$2370.Metal1 vout.$287.Metal1 2.22975e-05f
Cred_4388 vdd.$2370.Metal1 vout.$326.Metal1 2.29565e-05f
Cred_4389 vdd.$2370.Metal1 vout.$327.Metal1 2.25251e-05f
Cred_4390 vdd.$2370.Metal1 vout.$346.Metal1 3.14292e-05f
Cred_4391 vdd.$2370.Metal1 vout.$347.Metal1 3.08468e-05f
Cred_4392 vdd.$2370.Metal1 vout.$396.Metal1 0.00404196f
Cred_4393 vdd.$2370.Metal1 vout.$397.Metal1 3.46708e-05f
Cred_4394 vdd.$2370.Metal1 vout.$584.Metal2 4.94024e-05f
Cred_4395 vdd.$2370.Metal1 vout.$586.Metal2 4.85505e-05f
Cred_4396 vdd.$2370.Metal1 vout.$604.Metal2 4.03495e-05f
Cred_4397 vdd.$2370.Metal1 vout.$606.Metal2 4.03591e-05f
Cred_4398 vdd.$2370.Metal1 vout.$644.Metal2 4.04606e-05f
Cred_4399 vdd.$2370.Metal1 vout.$646.Metal2 4.1863e-05f
Cred_4400 vdd.$2370.Metal1 vout.$664.Metal2 2.9453e-05f
Cred_4401 vdd.$2370.Metal1 vout.$666.Metal2 2.80241e-05f
Cred_4402 vdd.$2370.Metal1 vout.$684.Metal2 3.10358e-05f
Cred_4403 vdd.$2370.Metal1 vout.$686.Metal2 3.07121e-05f
Cred_4404 vdd.$2370.Metal1 vout.$704.Metal2 3.35564e-05f
Cred_4405 vdd.$2370.Metal1 vout.$706.Metal2 3.28616e-05f
Cred_4406 vdd.$2370.Metal1 vout.$724.Metal2 5.24701e-05f
Cred_4407 vdd.$2370.Metal1 vout.$726.Metal2 5.13472e-05f
Cred_4408 vdd.$2370.Metal1 vout.$764.Metal2 5.59249e-05f
Cred_4409 vdd.$2370.Metal1 vout.$766.Metal2 5.47443e-05f
Cred_4410 vdd.$2370.Metal1 vout.$784.Metal2 0.00011635f
Cred_4411 vdd.$2370.Metal1 vout.$786.Metal2 7.26806e-05f
Cred_4412 vdd.$2370.Metal1 vout.P0.pSD 8.81307e-06f
Cred_4413 vdd.$2370.Metal1 vout.P2.pSD 7.99816e-07f
Cred_4414 vdd.$2370.Metal1 vss 0.00553465f
Cred_4415 vdd.$2370.Metal1 vss.$1211.Metal5 0.000366374f
Cred_4416 vdd.$2370.Metal1 vss.$1229.Metal5 0.000366374f
Cred_4417 vdd.$2370.Metal1 vss.$1281.Metal5 0.0014024f
Cred_4418 vdd.$2370.Metal1 vss.$1299.Metal5 0.0014024f
Cred_4419 vdd.$2372.Metal1 vout.$1154.Metal3 7.90307e-07f
Cred_4420 vdd.$2372.Metal1 vout.$1156.Metal3 7.78216e-08f
Cred_4421 vdd.$2372.Metal1 vout.$1369.Metal4 9.07041e-06f
Cred_4422 vdd.$2372.Metal1 vout.$1370.Metal4 0.000395772f
Cred_4423 vdd.$2372.Metal1 vout.$397.Metal1 0.00360778f
Cred_4424 vdd.$2372.Metal1 vout.$398.Metal1 0.000786797f
Cred_4425 vdd.$2372.Metal1 vout.$766.Metal2 1.58413e-08f
Cred_4426 vdd.$2372.Metal1 vout.$768.Metal2 1.55989e-09f
Cred_4427 vdd.$2372.Metal1 vout.$786.Metal2 4.92631e-05f
Cred_4428 vdd.$2372.Metal1 vout.$788.Metal2 4.85094e-06f
Cred_4429 vdd.$2372.Metal1 vout.P2.pSD 0.00171297f
Cred_4430 vdd.$2372.Metal1 vss 0.00459913f
Cred_4431 vdd.$2372.Metal1 vss.$1211.Metal5 0.000303841f
Cred_4432 vdd.$2372.Metal1 vss.$1229.Metal5 0.000303841f
Cred_4433 vdd.$2372.Metal1 vss.$1281.Metal5 0.00116304f
Cred_4434 vdd.$2372.Metal1 vss.$1299.Metal5 0.00116304f
Cred_4435 vdd.$2375.Metal1 vout.$1036.Metal3 9.17655e-06f
Cred_4436 vdd.$2375.Metal1 vout.$1038.Metal3 1.04943e-05f
Cred_4437 vdd.$2375.Metal1 vout.$1076.Metal3 5.76068e-06f
Cred_4438 vdd.$2375.Metal1 vout.$1078.Metal3 6.1172e-06f
Cred_4439 vdd.$2375.Metal1 vout.$1116.Metal3 6.47496e-06f
Cred_4440 vdd.$2375.Metal1 vout.$1118.Metal3 6.52152e-06f
Cred_4441 vdd.$2375.Metal1 vout.$1156.Metal3 1.64442e-05f
Cred_4442 vdd.$2375.Metal1 vout.$1158.Metal3 1.54523e-05f
Cred_4443 vdd.$2375.Metal1 vout.$1330.Metal4 3.06214e-06f
Cred_4444 vdd.$2375.Metal1 vout.$1331.Metal4 3.1596e-06f
Cred_4445 vdd.$2375.Metal1 vout.$1370.Metal4 0.00204473f
Cred_4446 vdd.$2375.Metal1 vout.$1371.Metal4 1.95288e-05f
Cred_4447 vdd.$2375.Metal1 vout.$158.Metal1 3.46964e-05f
Cred_4448 vdd.$2375.Metal1 vout.$159.Metal1 3.42986e-05f
Cred_4449 vdd.$2375.Metal1 vout.$208.Metal1 3.21643e-05f
Cred_4450 vdd.$2375.Metal1 vout.$209.Metal1 3.14294e-05f
Cred_4451 vdd.$2375.Metal1 vout.$228.Metal1 2.3958e-05f
Cred_4452 vdd.$2375.Metal1 vout.$229.Metal1 2.43966e-05f
Cred_4453 vdd.$2375.Metal1 vout.$268.Metal1 2.40099e-05f
Cred_4454 vdd.$2375.Metal1 vout.$269.Metal1 2.46068e-05f
Cred_4455 vdd.$2375.Metal1 vout.$288.Metal1 2.49262e-05f
Cred_4456 vdd.$2375.Metal1 vout.$289.Metal1 2.50816e-05f
Cred_4457 vdd.$2375.Metal1 vout.$328.Metal1 2.58202e-05f
Cred_4458 vdd.$2375.Metal1 vout.$329.Metal1 2.53349e-05f
Cred_4459 vdd.$2375.Metal1 vout.$348.Metal1 3.53498e-05f
Cred_4460 vdd.$2375.Metal1 vout.$349.Metal1 3.46947e-05f
Cred_4461 vdd.$2375.Metal1 vout.$398.Metal1 0.00455936f
Cred_4462 vdd.$2375.Metal1 vout.$399.Metal1 3.89957e-05f
Cred_4463 vdd.$2375.Metal1 vout.$588.Metal2 5.60745e-05f
Cred_4464 vdd.$2375.Metal1 vout.$590.Metal2 5.46068e-05f
Cred_4465 vdd.$2375.Metal1 vout.$608.Metal2 4.53705e-05f
Cred_4466 vdd.$2375.Metal1 vout.$610.Metal2 4.53935e-05f
Cred_4467 vdd.$2375.Metal1 vout.$648.Metal2 4.70909e-05f
Cred_4468 vdd.$2375.Metal1 vout.$650.Metal2 4.63064e-05f
Cred_4469 vdd.$2375.Metal1 vout.$668.Metal2 3.31279e-05f
Cred_4470 vdd.$2375.Metal1 vout.$670.Metal2 3.23241e-05f
Cred_4471 vdd.$2375.Metal1 vout.$688.Metal2 3.49073e-05f
Cred_4472 vdd.$2375.Metal1 vout.$690.Metal2 3.45432e-05f
Cred_4473 vdd.$2375.Metal1 vout.$708.Metal2 3.77422e-05f
Cred_4474 vdd.$2375.Metal1 vout.$710.Metal2 3.69608e-05f
Cred_4475 vdd.$2375.Metal1 vout.$728.Metal2 5.89664e-05f
Cred_4476 vdd.$2375.Metal1 vout.$730.Metal2 5.77523e-05f
Cred_4477 vdd.$2375.Metal1 vout.$768.Metal2 6.28829e-05f
Cred_4478 vdd.$2375.Metal1 vout.$770.Metal2 6.15732e-05f
Cred_4479 vdd.$2375.Metal1 vout.$788.Metal2 0.00012742f
Cred_4480 vdd.$2375.Metal1 vout.$790.Metal2 8.17469e-05f
Cred_4481 vdd.$2375.Metal1 vout.P4.pSD 8.91852e-06f
Cred_4482 vdd.$2375.Metal1 vout.P6.pSD 8.99599e-07f
Cred_4483 vdd.$2375.Metal1 vss 0.00460443f
Cred_4484 vdd.$2375.Metal1 vss.$1211.Metal5 0.000304918f
Cred_4485 vdd.$2375.Metal1 vss.$1229.Metal5 0.000304918f
Cred_4486 vdd.$2375.Metal1 vss.$1281.Metal5 0.00116716f
Cred_4487 vdd.$2375.Metal1 vss.$1299.Metal5 0.00116716f
Cred_4488 vdd.$2377.Metal1 vout.$1158.Metal3 7.90307e-07f
Cred_4489 vdd.$2377.Metal1 vout.$1371.Metal4 9.07041e-06f
Cred_4490 vdd.$2377.Metal1 vout.$399.Metal1 0.00360778f
Cred_4491 vdd.$2377.Metal1 vout.$770.Metal2 1.58413e-08f
Cred_4492 vdd.$2377.Metal1 vout.$790.Metal2 4.92631e-05f
Cred_4493 vdd.$2377.Metal1 vout.P6.pSD 0.00176822f
Cred_4494 vdd.$2377.Metal1 vss 0.00369884f
Cred_4495 vdd.$2377.Metal1 vss.$1211.Metal5 0.000244364f
Cred_4496 vdd.$2377.Metal1 vss.$1229.Metal5 0.000244364f
Cred_4497 vdd.$2377.Metal1 vss.$1281.Metal5 0.000935375f
Cred_4498 vdd.$2377.Metal1 vss.$1299.Metal5 0.000935375f
Cred_4499 vdd.$2379.Metal1 vout.$1160.Metal3 4.31854e-07f
Cred_4500 vdd.$2379.Metal1 vout.$1372.Metal4 0.0019654f
Cred_4501 vdd.$2379.Metal1 vout.$400.Metal1 0.00436616f
Cred_4502 vdd.$2379.Metal1 vout.$772.Metal2 8.65627e-09f
Cred_4503 vdd.$2379.Metal1 vout.$792.Metal2 2.69192e-05f
Cred_4504 vdd.$2379.Metal1 vss 0.00355029f
Cred_4505 vdd.$2379.Metal1 vss.$1211.Metal5 0.00023455f
Cred_4506 vdd.$2379.Metal1 vss.$1229.Metal5 0.00023455f
Cred_4507 vdd.$2379.Metal1 vss.$1281.Metal5 0.000897809f
Cred_4508 vdd.$2379.Metal1 vss.$1299.Metal5 0.000897809f
Cred_4509 vdd.$2382.Metal1 vout.$1160.Metal3 8.71475e-08f
Cred_4510 vdd.$2382.Metal1 vout.$1162.Metal3 8.71475e-08f
Cred_4511 vdd.$2382.Metal1 vout.$1372.Metal4 0.000380817f
Cred_4512 vdd.$2382.Metal1 vout.$1383.Metal4 0.000380817f
Cred_4513 vdd.$2382.Metal1 vout.$400.Metal1 0.000881085f
Cred_4514 vdd.$2382.Metal1 vout.$401.Metal1 0.000881085f
Cred_4515 vdd.$2382.Metal1 vout.$772.Metal2 1.74682e-09f
Cred_4516 vdd.$2382.Metal1 vout.$774.Metal2 1.74682e-09f
Cred_4517 vdd.$2382.Metal1 vout.$792.Metal2 5.43227e-06f
Cred_4518 vdd.$2382.Metal1 vout.$794.Metal2 5.43227e-06f
Cred_4519 vdd.$2382.Metal1 vref 0.000199711f
Cred_4520 vdd.$2382.Metal1 vref.P0.GatPoly 7.78761e-06f
Cred_4521 vdd.$2382.Metal1 vref.P0.nSD 4.46438e-05f
Cred_4522 vdd.$2382.Metal1 vref.P0.pSD 0.00448742f
Cred_4523 vdd.$2382.Metal1 vss 0.000778284f
Cred_4524 vdd.$2382.Metal1 vss.$1211.Metal5 5.14173e-05f
Cred_4525 vdd.$2382.Metal1 vss.$1229.Metal5 5.14173e-05f
Cred_4526 vdd.$2382.Metal1 vss.$1281.Metal5 0.000196815f
Cred_4527 vdd.$2382.Metal1 vss.$1299.Metal5 0.000196815f
Cred_4528 vdd.$2385.Metal1 vout.$1162.Metal3 3.4574e-07f
Cred_4529 vdd.$2385.Metal1 vout.$1373.Metal4 0.00359244f
Cred_4530 vdd.$2385.Metal1 vout.$1383.Metal4 0.000749827f
Cred_4531 vdd.$2385.Metal1 vout.$401.Metal1 0.00349552f
Cred_4532 vdd.$2385.Metal1 vout.$774.Metal2 6.93017e-09f
Cred_4533 vdd.$2385.Metal1 vout.$794.Metal2 2.15514e-05f
Cred_4534 vdd.$2385.Metal1 vss 0.00355029f
Cred_4535 vdd.$2385.Metal1 vss.$1211.Metal5 0.00023455f
Cred_4536 vdd.$2385.Metal1 vss.$1229.Metal5 0.00023455f
Cred_4537 vdd.$2385.Metal1 vss.$1281.Metal5 0.000897809f
Cred_4538 vdd.$2385.Metal1 vss.$1299.Metal5 0.000897809f
Cred_4539 vdd.$2387.Metal1 vout.$1164.Metal3 7.90307e-07f
Cred_4540 vdd.$2387.Metal1 vout.$1373.Metal4 0.00276185f
Cred_4541 vdd.$2387.Metal1 vout.$1394.Metal4 9.82484e-08f
Cred_4542 vdd.$2387.Metal1 vout.$402.Metal1 0.00360778f
Cred_4543 vdd.$2387.Metal1 vout.$776.Metal2 1.58413e-08f
Cred_4544 vdd.$2387.Metal1 vout.$796.Metal2 4.92631e-05f
Cred_4545 vdd.$2387.Metal1 vout.P12.pSD 0.00176822f
Cred_4546 vdd.$2387.Metal1 vss 0.00369846f
Cred_4547 vdd.$2387.Metal1 vss.$1211.Metal5 0.000244339f
Cred_4548 vdd.$2387.Metal1 vss.$1229.Metal5 0.000244339f
Cred_4549 vdd.$2387.Metal1 vss.$1281.Metal5 0.000935278f
Cred_4550 vdd.$2387.Metal1 vss.$1299.Metal5 0.000935278f
Cred_4551 vdd.$2389.Metal1 vout 1.36937e-06f
Cred_4552 vdd.$2389.Metal1 vout.$1004.Metal3 5.88391e-06f
Cred_4553 vdd.$2389.Metal1 vout.$1006.Metal3 5.93982e-06f
Cred_4554 vdd.$2389.Metal1 vout.$1044.Metal3 4.80879e-06f
Cred_4555 vdd.$2389.Metal1 vout.$1046.Metal3 4.54381e-06f
Cred_4556 vdd.$2389.Metal1 vout.$1066.Metal3 3.60393e-06f
Cred_4557 vdd.$2389.Metal1 vout.$1084.Metal3 6.09541e-06f
Cred_4558 vdd.$2389.Metal1 vout.$1106.Metal3 4.39082e-06f
Cred_4559 vdd.$2389.Metal1 vout.$1124.Metal3 6.8476e-06f
Cred_4560 vdd.$2389.Metal1 vout.$1126.Metal3 4.90195e-06f
Cred_4561 vdd.$2389.Metal1 vout.$1164.Metal3 1.5748e-05f
Cred_4562 vdd.$2389.Metal1 vout.$1166.Metal3 1.60919e-05f
Cred_4563 vdd.$2389.Metal1 vout.$1299.Metal4 1.64895e-11f
Cred_4564 vdd.$2389.Metal1 vout.$1313.Metal4 2.90869e-06f
Cred_4565 vdd.$2389.Metal1 vout.$1323.Metal4 6.15512e-06f
Cred_4566 vdd.$2389.Metal1 vout.$1333.Metal4 2.85515e-06f
Cred_4567 vdd.$2389.Metal1 vout.$1343.Metal4 6.3415e-06f
Cred_4568 vdd.$2389.Metal1 vout.$1353.Metal4 2.95586e-06f
Cred_4569 vdd.$2389.Metal1 vout.$1363.Metal4 3.04464e-06f
Cred_4570 vdd.$2389.Metal1 vout.$1373.Metal4 0.00504345f
Cred_4571 vdd.$2389.Metal1 vout.$1384.Metal4 6.05164e-06f
Cred_4572 vdd.$2389.Metal1 vout.$1394.Metal4 1.34976e-05f
Cred_4573 vdd.$2389.Metal1 vout.$1395.Metal4 1.869e-06f
Cred_4574 vdd.$2389.Metal1 vout.$1405.Metal4 1.90684e-06f
Cred_4575 vdd.$2389.Metal1 vout.$1415.Metal4 9.78687e-06f
Cred_4576 vdd.$2389.Metal1 vout.$162.Metal1 3.47241e-05f
Cred_4577 vdd.$2389.Metal1 vout.$163.Metal1 3.33907e-05f
Cred_4578 vdd.$2389.Metal1 vout.$212.Metal1 3.21749e-05f
Cred_4579 vdd.$2389.Metal1 vout.$213.Metal1 3.03034e-05f
Cred_4580 vdd.$2389.Metal1 vout.$232.Metal1 2.45057e-05f
Cred_4581 vdd.$2389.Metal1 vout.$233.Metal1 2.3269e-05f
Cred_4582 vdd.$2389.Metal1 vout.$272.Metal1 2.36468e-05f
Cred_4583 vdd.$2389.Metal1 vout.$273.Metal1 2.45868e-05f
Cred_4584 vdd.$2389.Metal1 vout.$292.Metal1 2.49262e-05f
Cred_4585 vdd.$2389.Metal1 vout.$293.Metal1 2.52962e-05f
Cred_4586 vdd.$2389.Metal1 vout.$332.Metal1 2.58202e-05f
Cred_4587 vdd.$2389.Metal1 vout.$333.Metal1 2.53349e-05f
Cred_4588 vdd.$2389.Metal1 vout.$352.Metal1 3.53498e-05f
Cred_4589 vdd.$2389.Metal1 vout.$353.Metal1 3.46947e-05f
Cred_4590 vdd.$2389.Metal1 vout.$402.Metal1 3.96149e-05f
Cred_4591 vdd.$2389.Metal1 vout.$403.Metal1 0.0039868f
Cred_4592 vdd.$2389.Metal1 vout.$596.Metal2 5.3985e-05f
Cred_4593 vdd.$2389.Metal1 vout.$598.Metal2 5.41944e-05f
Cred_4594 vdd.$2389.Metal1 vout.$616.Metal2 4.52883e-05f
Cred_4595 vdd.$2389.Metal1 vout.$618.Metal2 4.52735e-05f
Cred_4596 vdd.$2389.Metal1 vout.$656.Metal2 4.55191e-05f
Cred_4597 vdd.$2389.Metal1 vout.$658.Metal2 4.70584e-05f
Cred_4598 vdd.$2389.Metal1 vout.$676.Metal2 3.23268e-05f
Cred_4599 vdd.$2389.Metal1 vout.$678.Metal2 4.89559e-05f
Cred_4600 vdd.$2389.Metal1 vout.$696.Metal2 3.55708e-05f
Cred_4601 vdd.$2389.Metal1 vout.$716.Metal2 3.77422e-05f
Cred_4602 vdd.$2389.Metal1 vout.$718.Metal2 5.3569e-05f
Cred_4603 vdd.$2389.Metal1 vout.$736.Metal2 5.89664e-05f
Cred_4604 vdd.$2389.Metal1 vout.$738.Metal2 5.77523e-05f
Cred_4605 vdd.$2389.Metal1 vout.$776.Metal2 6.28689e-05f
Cred_4606 vdd.$2389.Metal1 vout.$778.Metal2 6.15861e-05f
Cred_4607 vdd.$2389.Metal1 vout.$796.Metal2 8.40216e-05f
Cred_4608 vdd.$2389.Metal1 vout.$798.Metal2 0.000121619f
Cred_4609 vdd.$2389.Metal1 vout.P0.GatPoly 2.14808e-10f
Cred_4610 vdd.$2389.Metal1 vout.P12.pSD 9.17887e-07f
Cred_4611 vdd.$2389.Metal1 vout.P14.pSD 8.89116e-06f
Cred_4612 vdd.$2389.Metal1 vss 0.00459983f
Cred_4613 vdd.$2389.Metal1 vss.$1211.Metal5 0.00030422f
Cred_4614 vdd.$2389.Metal1 vss.$1229.Metal5 0.00030422f
Cred_4615 vdd.$2389.Metal1 vss.$1281.Metal5 0.00116449f
Cred_4616 vdd.$2389.Metal1 vss.$1299.Metal5 0.00116449f
Cred_4617 vdd.$2392.Metal1 vout.$1166.Metal3 4.97846e-08f
Cred_4618 vdd.$2392.Metal1 vout.$1208.Metal3 9.48572e-07f
Cred_4619 vdd.$2392.Metal1 vout.$1373.Metal4 0.00394386f
Cred_4620 vdd.$2392.Metal1 vout.$1415.Metal4 2.48121e-08f
Cred_4621 vdd.$2392.Metal1 vout.$403.Metal1 0.000503336f
Cred_4622 vdd.$2392.Metal1 vout.$404.Metal1 0.00360778f
Cred_4623 vdd.$2392.Metal1 vout.$778.Metal2 9.97905e-10f
Cred_4624 vdd.$2392.Metal1 vout.$798.Metal2 3.10328e-06f
Cred_4625 vdd.$2392.Metal1 vout.$800.Metal2 4.92009e-05f
Cred_4626 vdd.$2392.Metal1 vout.P16.pSD 0.00171297f
Cred_4627 vdd.$2392.Metal1 vss 0.00459875f
Cred_4628 vdd.$2392.Metal1 vss.$1211.Metal5 0.000303816f
Cred_4629 vdd.$2392.Metal1 vss.$1229.Metal5 0.000303816f
Cred_4630 vdd.$2392.Metal1 vss.$1281.Metal5 0.00116294f
Cred_4631 vdd.$2392.Metal1 vss.$1299.Metal5 0.00116294f
Cred_4632 vdd.$2394.Metal1 vout 1.2175e-06f
Cred_4633 vdd.$2394.Metal1 vout.$1008.Metal3 5.23135e-06f
Cred_4634 vdd.$2394.Metal1 vout.$1010.Metal3 6.31743e-06f
Cred_4635 vdd.$2394.Metal1 vout.$1048.Metal3 4.27546e-06f
Cred_4636 vdd.$2394.Metal1 vout.$1050.Metal3 5.31662e-06f
Cred_4637 vdd.$2394.Metal1 vout.$1070.Metal3 3.64983e-06f
Cred_4638 vdd.$2394.Metal1 vout.$1088.Metal3 4.67681e-06f
Cred_4639 vdd.$2394.Metal1 vout.$1110.Metal3 5.67899e-06f
Cred_4640 vdd.$2394.Metal1 vout.$1128.Metal3 6.08816e-06f
Cred_4641 vdd.$2394.Metal1 vout.$1150.Metal3 7.02592e-06f
Cred_4642 vdd.$2394.Metal1 vout.$1168.Metal3 6.74032e-06f
Cred_4643 vdd.$2394.Metal1 vout.$1190.Metal3 1.30323e-05f
Cred_4644 vdd.$2394.Metal1 vout.$1208.Metal3 8.83379e-06f
Cred_4645 vdd.$2394.Metal1 vout.$1299.Metal4 1.46607e-11f
Cred_4646 vdd.$2394.Metal1 vout.$1313.Metal4 2.59855e-06f
Cred_4647 vdd.$2394.Metal1 vout.$1323.Metal4 2.46652e-06f
Cred_4648 vdd.$2394.Metal1 vout.$1333.Metal4 6.28831e-06f
Cred_4649 vdd.$2394.Metal1 vout.$1343.Metal4 2.54121e-06f
Cred_4650 vdd.$2394.Metal1 vout.$1353.Metal4 2.62803e-06f
Cred_4651 vdd.$2394.Metal1 vout.$1363.Metal4 2.7159e-06f
Cred_4652 vdd.$2394.Metal1 vout.$1373.Metal4 0.00261984f
Cred_4653 vdd.$2394.Metal1 vout.$1384.Metal4 3.16851e-06f
Cred_4654 vdd.$2394.Metal1 vout.$1395.Metal4 3.2845e-06f
Cred_4655 vdd.$2394.Metal1 vout.$1405.Metal4 5.44708e-06f
Cred_4656 vdd.$2394.Metal1 vout.$1415.Metal4 5.99563e-06f
Cred_4657 vdd.$2394.Metal1 vout.$1416.Metal4 1.28678e-05f
Cred_4658 vdd.$2394.Metal1 vout.$164.Metal1 3.0873e-05f
Cred_4659 vdd.$2394.Metal1 vout.$165.Metal1 3.04915e-05f
Cred_4660 vdd.$2394.Metal1 vout.$214.Metal1 2.86065e-05f
Cred_4661 vdd.$2394.Metal1 vout.$215.Metal1 2.79436e-05f
Cred_4662 vdd.$2394.Metal1 vout.$234.Metal1 2.17708e-05f
Cred_4663 vdd.$2394.Metal1 vout.$235.Metal1 2.12793e-05f
Cred_4664 vdd.$2394.Metal1 vout.$274.Metal1 2.20362e-05f
Cred_4665 vdd.$2394.Metal1 vout.$275.Metal1 2.17106e-05f
Cred_4666 vdd.$2394.Metal1 vout.$294.Metal1 2.24658e-05f
Cred_4667 vdd.$2394.Metal1 vout.$295.Metal1 2.21867e-05f
Cred_4668 vdd.$2394.Metal1 vout.$334.Metal1 2.29565e-05f
Cred_4669 vdd.$2394.Metal1 vout.$335.Metal1 2.24871e-05f
Cred_4670 vdd.$2394.Metal1 vout.$354.Metal1 3.14292e-05f
Cred_4671 vdd.$2394.Metal1 vout.$355.Metal1 3.05383e-05f
Cred_4672 vdd.$2394.Metal1 vout.$404.Metal1 3.52159e-05f
Cred_4673 vdd.$2394.Metal1 vout.$405.Metal1 0.00404141f
Cred_4674 vdd.$2394.Metal1 vout.$600.Metal2 4.79977e-05f
Cred_4675 vdd.$2394.Metal1 vout.$602.Metal2 4.8201e-05f
Cred_4676 vdd.$2394.Metal1 vout.$620.Metal2 4.02655e-05f
Cred_4677 vdd.$2394.Metal1 vout.$622.Metal2 4.02735e-05f
Cred_4678 vdd.$2394.Metal1 vout.$660.Metal2 4.04706e-05f
Cred_4679 vdd.$2394.Metal1 vout.$662.Metal2 4.18423e-05f
Cred_4680 vdd.$2394.Metal1 vout.$680.Metal2 2.87414e-05f
Cred_4681 vdd.$2394.Metal1 vout.$682.Metal2 4.38156e-05f
Cred_4682 vdd.$2394.Metal1 vout.$700.Metal2 3.1629e-05f
Cred_4683 vdd.$2394.Metal1 vout.$720.Metal2 3.35564e-05f
Cred_4684 vdd.$2394.Metal1 vout.$722.Metal2 4.79299e-05f
Cred_4685 vdd.$2394.Metal1 vout.$740.Metal2 5.24266e-05f
Cred_4686 vdd.$2394.Metal1 vout.$742.Metal2 3.39924e-05f
Cred_4687 vdd.$2394.Metal1 vout.$762.Metal2 3.53654e-05f
Cred_4688 vdd.$2394.Metal1 vout.$780.Metal2 5.57508e-05f
Cred_4689 vdd.$2394.Metal1 vout.$782.Metal2 3.7246e-05f
Cred_4690 vdd.$2394.Metal1 vout.$800.Metal2 7.41327e-05f
Cred_4691 vdd.$2394.Metal1 vout.$802.Metal2 0.000113932f
Cred_4692 vdd.$2394.Metal1 vout.P0.GatPoly 1.90984e-10f
Cred_4693 vdd.$2394.Metal1 vout.P16.pSD 8.15975e-07f
Cred_4694 vdd.$2394.Metal1 vout.P18.pSD 8.80548e-06f
Cred_4695 vdd.$2394.Metal1 vss 0.00495785f
Cred_4696 vdd.$2394.Metal1 vss.$1211.Metal5 0.000434859f
Cred_4697 vdd.$2394.Metal1 vss.$1229.Metal5 0.000434859f
Cred_4698 vdd.$2394.Metal1 vss.$1281.Metal5 0.00166455f
Cred_4699 vdd.$2394.Metal1 vss.$1299.Metal5 0.00166455f
Cred_4700 vdd.$2397.Metal1 vout.$1190.Metal3 4.92696e-08f
Cred_4701 vdd.$2397.Metal1 vout.$1416.Metal4 2.96666e-09f
Cred_4702 vdd.$2397.Metal1 vout.$405.Metal1 0.000447393f
Cred_4703 vdd.$2397.Metal1 vout.$802.Metal2 2.75679e-06f
Cred_4704 vdd.$2397.Metal1 vss 0.00543323f
Cred_4705 vdd.$2397.Metal1 vss.$1211.Metal5 0.000613389f
Cred_4706 vdd.$2397.Metal1 vss.$1229.Metal5 0.000613389f
Cred_4707 vdd.$2397.Metal1 vss.$1281.Metal5 0.00234793f
Cred_4708 vdd.$2397.Metal1 vss.$1299.Metal5 0.00234793f
Cred_4709 vdd.$2399.Metal1 vout 0.000715345f
Cred_4710 vdd.$2399.Metal1 vout.$1002.Metal3 4.13031e-09f
Cred_4711 vdd.$2399.Metal1 vout.$1004.Metal3 4.4754e-09f
Cred_4712 vdd.$2399.Metal1 vout.$1006.Metal3 7.24663e-09f
Cred_4713 vdd.$2399.Metal1 vout.$1008.Metal3 9.14665e-09f
Cred_4714 vdd.$2399.Metal1 vout.$1010.Metal3 1.20674e-08f
Cred_4715 vdd.$2399.Metal1 vout.$1032.Metal3 8.58165e-10f
Cred_4716 vdd.$2399.Metal1 vout.$1034.Metal3 1.06602e-09f
Cred_4717 vdd.$2399.Metal1 vout.$1036.Metal3 1.24197e-09f
Cred_4718 vdd.$2399.Metal1 vout.$1038.Metal3 1.58722e-09f
Cred_4719 vdd.$2399.Metal1 vout.$1040.Metal3 2.30177e-09f
Cred_4720 vdd.$2399.Metal1 vout.$1299.Metal4 1.10506e-06f
Cred_4721 vdd.$2399.Metal1 vout.$1313.Metal4 0.00343581f
Cred_4722 vdd.$2399.Metal1 vout.$1328.Metal4 1.02208e-10f
Cred_4723 vdd.$2399.Metal1 vout.$1329.Metal4 1.26963e-10f
Cred_4724 vdd.$2399.Metal1 vout.$1330.Metal4 1.47918e-10f
Cred_4725 vdd.$2399.Metal1 vout.$1331.Metal4 1.89038e-10f
Cred_4726 vdd.$2399.Metal1 vout.$1332.Metal4 2.74141e-10f
Cred_4727 vdd.$2399.Metal1 vout.$156.Metal1 8.63972e-06f
Cred_4728 vdd.$2399.Metal1 vout.$157.Metal1 1.07323e-05f
Cred_4729 vdd.$2399.Metal1 vout.$158.Metal1 1.25037e-05f
Cred_4730 vdd.$2399.Metal1 vout.$159.Metal1 1.59796e-05f
Cred_4731 vdd.$2399.Metal1 vout.$160.Metal1 2.31735e-05f
Cred_4732 vdd.$2399.Metal1 vout.$161.Metal1 3.48052e-05f
Cred_4733 vdd.$2399.Metal1 vout.$162.Metal1 3.77132e-05f
Cred_4734 vdd.$2399.Metal1 vout.$163.Metal1 6.10658e-05f
Cred_4735 vdd.$2399.Metal1 vout.$164.Metal1 7.70768e-05f
Cred_4736 vdd.$2399.Metal1 vout.$165.Metal1 0.000101689f
Cred_4737 vdd.$2399.Metal1 vout.$584.Metal2 5.32679e-08f
Cred_4738 vdd.$2399.Metal1 vout.$586.Metal2 6.61697e-08f
Cred_4739 vdd.$2399.Metal1 vout.$588.Metal2 7.70912e-08f
Cred_4740 vdd.$2399.Metal1 vout.$590.Metal2 9.85219e-08f
Cred_4741 vdd.$2399.Metal1 vout.$592.Metal2 1.42875e-07f
Cred_4742 vdd.$2399.Metal1 vout.$594.Metal2 2.14318e-07f
Cred_4743 vdd.$2399.Metal1 vout.$596.Metal2 2.32224e-07f
Cred_4744 vdd.$2399.Metal1 vout.$598.Metal2 3.76021e-07f
Cred_4745 vdd.$2399.Metal1 vout.$600.Metal2 4.74612e-07f
Cred_4746 vdd.$2399.Metal1 vout.$602.Metal2 6.26167e-07f
Cred_4747 vdd.$2399.Metal1 vout.$604.Metal2 1.72014e-11f
Cred_4748 vdd.$2399.Metal1 vout.$606.Metal2 2.13677e-11f
Cred_4749 vdd.$2399.Metal1 vout.$608.Metal2 2.48945e-11f
Cred_4750 vdd.$2399.Metal1 vout.$610.Metal2 3.1815e-11f
Cred_4751 vdd.$2399.Metal1 vout.$612.Metal2 4.61377e-11f
Cred_4752 vdd.$2399.Metal1 vout.P0.GatPoly 7.1249e-05f
Cred_4753 vdd.$2399.Metal1 vref 0.00197243f
Cred_4754 vdd.$2399.Metal1 vref.P0.GatPoly 9.02276e-06f
Cred_4755 vdd.$2399.Metal1 vref.P0.nSD 1.30689e-05f
Cred_4756 vdd.$2399.Metal1 vref.P0.pSD 5.8155e-05f
Cred_4757 vdd.$2399.Metal1 vss 0.0225977f
Cred_4758 vdd.$2399.Metal1 vss.$1211.Metal5 0.00502828f
Cred_4759 vdd.$2399.Metal1 vss.$1229.Metal5 0.00502828f
Cred_4760 vdd.$2399.Metal1 vss.$127.Metal1 7.36883e-06f
Cred_4761 vdd.$2399.Metal1 vss.$1281.Metal5 0.0192472f
Cred_4762 vdd.$2399.Metal1 vss.$1299.Metal5 0.0192472f
Cred_4763 vdd.$2399.Metal1 vss.$406.Metal1 0.000394112f
Cred_4764 vdd.$2399.Metal1 vss.$457.Metal2 1.07621e-07f
Cred_4765 vdd.$2399.Metal1 vss.P0.GatPoly 2.63443e-07f
Cred_4766 vdd.$2399.Metal1 vss.P0.pSD 0.000471696f
Cred_4767 vdd.$2745.Metal2 vss 0.00994188f
Cred_4768 vdd.$2745.Metal2 vss.$1211.Metal5 0.00100516f
Cred_4769 vdd.$2745.Metal2 vss.$1229.Metal5 0.00100516f
Cred_4770 vdd.$2745.Metal2 vss.$1281.Metal5 0.00384755f
Cred_4771 vdd.$2745.Metal2 vss.$1299.Metal5 0.00384755f
Cred_4772 vdd.$2747.Metal2 vout.$1032.Metal3 0.00312186f
Cred_4773 vdd.$2747.Metal2 vout.$1072.Metal3 0.00169154f
Cred_4774 vdd.$2747.Metal2 vout.$1112.Metal3 0.00223654f
Cred_4775 vdd.$2747.Metal2 vout.$1152.Metal3 0.00524941f
Cred_4776 vdd.$2747.Metal2 vout.$1328.Metal4 0.000171812f
Cred_4777 vdd.$2747.Metal2 vout.$1368.Metal4 0.0015218f
Cred_4778 vdd.$2747.Metal2 vout.$1408.Metal4 0.00396622f
Cred_4779 vdd.$2747.Metal2 vout.$156.Metal1 8.34517e-05f
Cred_4780 vdd.$2747.Metal2 vout.$206.Metal1 4.6112e-05f
Cred_4781 vdd.$2747.Metal2 vout.$226.Metal1 4.89067e-06f
Cred_4782 vdd.$2747.Metal2 vout.$326.Metal1 6.38036e-06f
Cred_4783 vdd.$2747.Metal2 vout.$346.Metal1 5.18404e-05f
Cred_4784 vdd.$2747.Metal2 vout.$396.Metal1 0.000114809f
Cred_4785 vdd.$2747.Metal2 vout.$584.Metal2 0.00930003f
Cred_4786 vdd.$2747.Metal2 vout.$604.Metal2 0.00769547f
Cred_4787 vdd.$2747.Metal2 vout.$644.Metal2 0.00788266f
Cred_4788 vdd.$2747.Metal2 vout.$664.Metal2 0.00548563f
Cred_4789 vdd.$2747.Metal2 vout.$684.Metal2 0.00525265f
Cred_4790 vdd.$2747.Metal2 vout.$704.Metal2 0.00550219f
Cred_4791 vdd.$2747.Metal2 vout.$724.Metal2 0.00862611f
Cred_4792 vdd.$2747.Metal2 vout.$764.Metal2 0.00918525f
Cred_4793 vdd.$2747.Metal2 vout.$784.Metal2 0.0123915f
Cred_4794 vdd.$2747.Metal2 vss 0.0310236f
Cred_4795 vdd.$2747.Metal2 vss.$1211.Metal5 0.00540067f
Cred_4796 vdd.$2747.Metal2 vss.$1229.Metal5 0.00540067f
Cred_4797 vdd.$2747.Metal2 vss.$1281.Metal5 0.0206727f
Cred_4798 vdd.$2747.Metal2 vss.$1299.Metal5 0.0206727f
Cred_4799 vdd.$2749.Metal2 vout.$1032.Metal3 0.00797737f
Cred_4800 vdd.$2749.Metal2 vout.$1072.Metal3 0.00350087f
Cred_4801 vdd.$2749.Metal2 vout.$1112.Metal3 0.00421749f
Cred_4802 vdd.$2749.Metal2 vout.$1152.Metal3 0.00947442f
Cred_4803 vdd.$2749.Metal2 vout.$1328.Metal4 0.00370394f
Cred_4804 vdd.$2749.Metal2 vout.$1368.Metal4 0.00248136f
Cred_4805 vdd.$2749.Metal2 vout.$1408.Metal4 0.00389936f
Cred_4806 vdd.$2749.Metal2 vout.$156.Metal1 0.0188533f
Cred_4807 vdd.$2749.Metal2 vout.$206.Metal1 0.0173405f
Cred_4808 vdd.$2749.Metal2 vout.$226.Metal1 0.0131943f
Cred_4809 vdd.$2749.Metal2 vout.$266.Metal1 0.0130402f
Cred_4810 vdd.$2749.Metal2 vout.$286.Metal1 0.0136548f
Cred_4811 vdd.$2749.Metal2 vout.$326.Metal1 0.0139582f
Cred_4812 vdd.$2749.Metal2 vout.$346.Metal1 0.0191161f
Cred_4813 vdd.$2749.Metal2 vout.$396.Metal1 0.0214083f
Cred_4814 vdd.$2749.Metal2 vout.$584.Metal2 0.0305743f
Cred_4815 vdd.$2749.Metal2 vout.$604.Metal2 0.0251647f
Cred_4816 vdd.$2749.Metal2 vout.$644.Metal2 0.0256567f
Cred_4817 vdd.$2749.Metal2 vout.$664.Metal2 0.0174736f
Cred_4818 vdd.$2749.Metal2 vout.$684.Metal2 0.0191219f
Cred_4819 vdd.$2749.Metal2 vout.$704.Metal2 0.0205134f
Cred_4820 vdd.$2749.Metal2 vout.$724.Metal2 0.0325511f
Cred_4821 vdd.$2749.Metal2 vout.$764.Metal2 0.0341845f
Cred_4822 vdd.$2749.Metal2 vout.$784.Metal2 0.0452281f
Cred_4823 vdd.$2749.Metal2 vout.P0.pSD 0.000495537f
Cred_4824 vdd.$2749.Metal2 vss 0.0139105f
Cred_4825 vdd.$2749.Metal2 vss.$1211.Metal5 0.00153719f
Cred_4826 vdd.$2749.Metal2 vss.$1229.Metal5 0.00153719f
Cred_4827 vdd.$2749.Metal2 vss.$1281.Metal5 0.00588405f
Cred_4828 vdd.$2749.Metal2 vss.$1299.Metal5 0.00588405f
Cred_4829 vdd.$2751.Metal2 vout.$1032.Metal3 0.00430947f
Cred_4830 vdd.$2751.Metal2 vout.$1034.Metal3 0.000821049f
Cred_4831 vdd.$2751.Metal2 vout.$1072.Metal3 0.00204671f
Cred_4832 vdd.$2751.Metal2 vout.$1074.Metal3 0.000368308f
Cred_4833 vdd.$2751.Metal2 vout.$1112.Metal3 0.00245029f
Cred_4834 vdd.$2751.Metal2 vout.$1114.Metal3 0.000491758f
Cred_4835 vdd.$2751.Metal2 vout.$1152.Metal3 0.00561149f
Cred_4836 vdd.$2751.Metal2 vout.$1154.Metal3 0.00116518f
Cred_4837 vdd.$2751.Metal2 vout.$1328.Metal4 0.00197287f
Cred_4838 vdd.$2751.Metal2 vout.$1329.Metal4 0.000237963f
Cred_4839 vdd.$2751.Metal2 vout.$1368.Metal4 0.00191694f
Cred_4840 vdd.$2751.Metal2 vout.$1369.Metal4 0.00150749f
Cred_4841 vdd.$2751.Metal2 vout.$1408.Metal4 0.00365954f
Cred_4842 vdd.$2751.Metal2 vout.$156.Metal1 0.0113386f
Cred_4843 vdd.$2751.Metal2 vout.$157.Metal1 0.00258629f
Cred_4844 vdd.$2751.Metal2 vout.$206.Metal1 0.0104226f
Cred_4845 vdd.$2751.Metal2 vout.$207.Metal1 0.00236994f
Cred_4846 vdd.$2751.Metal2 vout.$226.Metal1 0.00789738f
Cred_4847 vdd.$2751.Metal2 vout.$227.Metal1 0.00183896f
Cred_4848 vdd.$2751.Metal2 vout.$266.Metal1 0.00790334f
Cred_4849 vdd.$2751.Metal2 vout.$267.Metal1 0.00185519f
Cred_4850 vdd.$2751.Metal2 vout.$286.Metal1 0.0082193f
Cred_4851 vdd.$2751.Metal2 vout.$287.Metal1 0.00189108f
Cred_4852 vdd.$2751.Metal2 vout.$326.Metal1 0.00842732f
Cred_4853 vdd.$2751.Metal2 vout.$327.Metal1 0.00191039f
Cred_4854 vdd.$2751.Metal2 vout.$346.Metal1 0.011539f
Cred_4855 vdd.$2751.Metal2 vout.$347.Metal1 0.00261617f
Cred_4856 vdd.$2751.Metal2 vout.$396.Metal1 0.0129959f
Cred_4857 vdd.$2751.Metal2 vout.$397.Metal1 0.00294048f
Cred_4858 vdd.$2751.Metal2 vout.$584.Metal2 0.0180442f
Cred_4859 vdd.$2751.Metal2 vout.$586.Metal2 0.00411765f
Cred_4860 vdd.$2751.Metal2 vout.$604.Metal2 0.0148236f
Cred_4861 vdd.$2751.Metal2 vout.$606.Metal2 0.00342291f
Cred_4862 vdd.$2751.Metal2 vout.$644.Metal2 0.0150546f
Cred_4863 vdd.$2751.Metal2 vout.$646.Metal2 0.00355046f
Cred_4864 vdd.$2751.Metal2 vout.$664.Metal2 0.0104096f
Cred_4865 vdd.$2751.Metal2 vout.$666.Metal2 0.00237677f
Cred_4866 vdd.$2751.Metal2 vout.$684.Metal2 0.0113177f
Cred_4867 vdd.$2751.Metal2 vout.$686.Metal2 0.00260474f
Cred_4868 vdd.$2751.Metal2 vout.$704.Metal2 0.0121684f
Cred_4869 vdd.$2751.Metal2 vout.$706.Metal2 0.00278704f
Cred_4870 vdd.$2751.Metal2 vout.$724.Metal2 0.0192433f
Cred_4871 vdd.$2751.Metal2 vout.$726.Metal2 0.00435483f
Cred_4872 vdd.$2751.Metal2 vout.$764.Metal2 0.0202779f
Cred_4873 vdd.$2751.Metal2 vout.$766.Metal2 0.00464295f
Cred_4874 vdd.$2751.Metal2 vout.$784.Metal2 0.0300576f
Cred_4875 vdd.$2751.Metal2 vout.$786.Metal2 0.00616416f
Cred_4876 vdd.$2751.Metal2 vout.P0.pSD 0.00236781f
Cred_4877 vdd.$2751.Metal2 vout.P2.pSD 6.78336e-05f
Cred_4878 vdd.$2751.Metal2 vss 0.0100217f
Cred_4879 vdd.$2751.Metal2 vss.$1211.Metal5 0.000887988f
Cred_4880 vdd.$2751.Metal2 vss.$1229.Metal5 0.000887988f
Cred_4881 vdd.$2751.Metal2 vss.$1281.Metal5 0.00339903f
Cred_4882 vdd.$2751.Metal2 vss.$1299.Metal5 0.00339903f
Cred_4883 vdd.$2755.Metal2 vout.$1032.Metal3 0.00673119f
Cred_4884 vdd.$2755.Metal2 vout.$1034.Metal3 0.00767457f
Cred_4885 vdd.$2755.Metal2 vout.$1072.Metal3 0.00451756f
Cred_4886 vdd.$2755.Metal2 vout.$1074.Metal3 0.00344268f
Cred_4887 vdd.$2755.Metal2 vout.$1112.Metal3 0.00534241f
Cred_4888 vdd.$2755.Metal2 vout.$1114.Metal3 0.00459659f
Cred_4889 vdd.$2755.Metal2 vout.$1152.Metal3 0.0125329f
Cred_4890 vdd.$2755.Metal2 vout.$1154.Metal3 0.0109281f
Cred_4891 vdd.$2755.Metal2 vout.$1328.Metal4 0.00242549f
Cred_4892 vdd.$2755.Metal2 vout.$1329.Metal4 0.0022243f
Cred_4893 vdd.$2755.Metal2 vout.$1368.Metal4 0.00713915f
Cred_4894 vdd.$2755.Metal2 vout.$1369.Metal4 0.016084f
Cred_4895 vdd.$2755.Metal2 vout.$1408.Metal4 0.01184f
Cred_4896 vdd.$2755.Metal2 vout.$156.Metal1 0.024194f
Cred_4897 vdd.$2755.Metal2 vout.$157.Metal1 0.0241748f
Cred_4898 vdd.$2755.Metal2 vout.$206.Metal1 0.0221841f
Cred_4899 vdd.$2755.Metal2 vout.$207.Metal1 0.0221525f
Cred_4900 vdd.$2755.Metal2 vout.$226.Metal1 0.0165601f
Cred_4901 vdd.$2755.Metal2 vout.$227.Metal1 0.0171892f
Cred_4902 vdd.$2755.Metal2 vout.$266.Metal1 0.0172829f
Cred_4903 vdd.$2755.Metal2 vout.$267.Metal1 0.017341f
Cred_4904 vdd.$2755.Metal2 vout.$286.Metal1 0.0175688f
Cred_4905 vdd.$2755.Metal2 vout.$287.Metal1 0.0176765f
Cred_4906 vdd.$2755.Metal2 vout.$326.Metal1 0.0181989f
Cred_4907 vdd.$2755.Metal2 vout.$327.Metal1 0.0178569f
Cred_4908 vdd.$2755.Metal2 vout.$346.Metal1 0.0249157f
Cred_4909 vdd.$2755.Metal2 vout.$347.Metal1 0.024454f
Cred_4910 vdd.$2755.Metal2 vout.$396.Metal1 0.0279509f
Cred_4911 vdd.$2755.Metal2 vout.$397.Metal1 0.0275311f
Cred_4912 vdd.$2755.Metal2 vout.$584.Metal2 0.0391641f
Cred_4913 vdd.$2755.Metal2 vout.$586.Metal2 0.0384888f
Cred_4914 vdd.$2755.Metal2 vout.$604.Metal2 0.0319874f
Cred_4915 vdd.$2755.Metal2 vout.$606.Metal2 0.0319949f
Cred_4916 vdd.$2755.Metal2 vout.$644.Metal2 0.0320754f
Cred_4917 vdd.$2755.Metal2 vout.$646.Metal2 0.0331871f
Cred_4918 vdd.$2755.Metal2 vout.$664.Metal2 0.023349f
Cred_4919 vdd.$2755.Metal2 vout.$666.Metal2 0.0222163f
Cred_4920 vdd.$2755.Metal2 vout.$684.Metal2 0.0246039f
Cred_4921 vdd.$2755.Metal2 vout.$686.Metal2 0.0243472f
Cred_4922 vdd.$2755.Metal2 vout.$704.Metal2 0.026602f
Cred_4923 vdd.$2755.Metal2 vout.$706.Metal2 0.0260513f
Cred_4924 vdd.$2755.Metal2 vout.$724.Metal2 0.0415623f
Cred_4925 vdd.$2755.Metal2 vout.$726.Metal2 0.0407058f
Cred_4926 vdd.$2755.Metal2 vout.$764.Metal2 0.0443247f
Cred_4927 vdd.$2755.Metal2 vout.$766.Metal2 0.0433997f
Cred_4928 vdd.$2755.Metal2 vout.$784.Metal2 0.0606982f
Cred_4929 vdd.$2755.Metal2 vout.$786.Metal2 0.0599099f
Cred_4930 vdd.$2755.Metal2 vout.P0.pSD 0.00131739f
Cred_4931 vdd.$2755.Metal2 vout.P2.pSD 0.00194996f
Cred_4932 vdd.$2755.Metal2 vss 0.00980091f
Cred_4933 vdd.$2755.Metal2 vss.$1211.Metal5 0.00122456f
Cred_4934 vdd.$2755.Metal2 vss.$1229.Metal5 0.00122456f
Cred_4935 vdd.$2755.Metal2 vss.$1281.Metal5 0.00468737f
Cred_4936 vdd.$2755.Metal2 vss.$1299.Metal5 0.00468737f
Cred_4937 vdd.$2759.Metal2 vout.$1034.Metal3 0.0050688f
Cred_4938 vdd.$2759.Metal2 vout.$1036.Metal3 0.00601486f
Cred_4939 vdd.$2759.Metal2 vout.$1074.Metal3 0.00318525f
Cred_4940 vdd.$2759.Metal2 vout.$1076.Metal3 0.00270071f
Cred_4941 vdd.$2759.Metal2 vout.$1114.Metal3 0.0035802f
Cred_4942 vdd.$2759.Metal2 vout.$1116.Metal3 0.00360594f
Cred_4943 vdd.$2759.Metal2 vout.$1154.Metal3 0.00874427f
Cred_4944 vdd.$2759.Metal2 vout.$1156.Metal3 0.00854401f
Cred_4945 vdd.$2759.Metal2 vout.$1329.Metal4 0.00169253f
Cred_4946 vdd.$2759.Metal2 vout.$1330.Metal4 0.00174424f
Cred_4947 vdd.$2759.Metal2 vout.$1369.Metal4 0.0131074f
Cred_4948 vdd.$2759.Metal2 vout.$1370.Metal4 0.0109574f
Cred_4949 vdd.$2759.Metal2 vout.$157.Metal1 0.0189792f
Cred_4950 vdd.$2759.Metal2 vout.$158.Metal1 0.0187586f
Cred_4951 vdd.$2759.Metal2 vout.$207.Metal1 0.017403f
Cred_4952 vdd.$2759.Metal2 vout.$208.Metal1 0.0169967f
Cred_4953 vdd.$2759.Metal2 vout.$227.Metal1 0.0129911f
Cred_4954 vdd.$2759.Metal2 vout.$228.Metal1 0.0132343f
Cred_4955 vdd.$2759.Metal2 vout.$267.Metal1 0.0132296f
Cred_4956 vdd.$2759.Metal2 vout.$268.Metal1 0.0135728f
Cred_4957 vdd.$2759.Metal2 vout.$287.Metal1 0.0137824f
Cred_4958 vdd.$2759.Metal2 vout.$288.Metal1 0.0138669f
Cred_4959 vdd.$2759.Metal2 vout.$327.Metal1 0.0142767f
Cred_4960 vdd.$2759.Metal2 vout.$328.Metal1 0.0140084f
Cred_4961 vdd.$2759.Metal2 vout.$347.Metal1 0.0195459f
Cred_4962 vdd.$2759.Metal2 vout.$348.Metal1 0.0191837f
Cred_4963 vdd.$2759.Metal2 vout.$397.Metal1 0.0219499f
Cred_4964 vdd.$2759.Metal2 vout.$398.Metal1 0.0215734f
Cred_4965 vdd.$2759.Metal2 vout.$586.Metal2 0.0306802f
Cred_4966 vdd.$2759.Metal2 vout.$588.Metal2 0.0298362f
Cred_4967 vdd.$2759.Metal2 vout.$606.Metal2 0.025085f
Cred_4968 vdd.$2759.Metal2 vout.$608.Metal2 0.0250977f
Cred_4969 vdd.$2759.Metal2 vout.$646.Metal2 0.0251669f
Cred_4970 vdd.$2759.Metal2 vout.$648.Metal2 0.0255986f
Cred_4971 vdd.$2759.Metal2 vout.$666.Metal2 0.0183169f
Cred_4972 vdd.$2759.Metal2 vout.$668.Metal2 0.0174278f
Cred_4973 vdd.$2759.Metal2 vout.$686.Metal2 0.0193013f
Cred_4974 vdd.$2759.Metal2 vout.$688.Metal2 0.0190999f
Cred_4975 vdd.$2759.Metal2 vout.$706.Metal2 0.0208688f
Cred_4976 vdd.$2759.Metal2 vout.$708.Metal2 0.0204367f
Cred_4977 vdd.$2759.Metal2 vout.$726.Metal2 0.0326042f
Cred_4978 vdd.$2759.Metal2 vout.$728.Metal2 0.0319329f
Cred_4979 vdd.$2759.Metal2 vout.$766.Metal2 0.0347628f
Cred_4980 vdd.$2759.Metal2 vout.$768.Metal2 0.0340457f
Cred_4981 vdd.$2759.Metal2 vout.$786.Metal2 0.0487499f
Cred_4982 vdd.$2759.Metal2 vout.$788.Metal2 0.0452004f
Cred_4983 vdd.$2759.Metal2 vout.P2.pSD 0.00181768f
Cred_4984 vdd.$2759.Metal2 vout.P4.pSD 0.000494554f
Cred_4985 vdd.$2759.Metal2 vss 0.00748813f
Cred_4986 vdd.$2759.Metal2 vss.$1211.Metal5 0.000947044f
Cred_4987 vdd.$2759.Metal2 vss.$1229.Metal5 0.000947044f
Cred_4988 vdd.$2759.Metal2 vss.$1281.Metal5 0.00362509f
Cred_4989 vdd.$2759.Metal2 vss.$1299.Metal5 0.00362509f
Cred_4990 vdd.$2761.Metal2 vout.$1034.Metal3 0.00209744f
Cred_4991 vdd.$2761.Metal2 vout.$1036.Metal3 0.00326718f
Cred_4992 vdd.$2761.Metal2 vout.$1038.Metal3 0.000890038f
Cred_4993 vdd.$2761.Metal2 vout.$1074.Metal3 0.00131803f
Cred_4994 vdd.$2761.Metal2 vout.$1076.Metal3 0.00160611f
Cred_4995 vdd.$2761.Metal2 vout.$1078.Metal3 0.000518809f
Cred_4996 vdd.$2761.Metal2 vout.$1114.Metal3 0.00148146f
Cred_4997 vdd.$2761.Metal2 vout.$1116.Metal3 0.00204127f
Cred_4998 vdd.$2761.Metal2 vout.$1118.Metal3 0.0005531f
Cred_4999 vdd.$2761.Metal2 vout.$1154.Metal3 0.00360311f
Cred_5000 vdd.$2761.Metal2 vout.$1156.Metal3 0.00493478f
Cred_5001 vdd.$2761.Metal2 vout.$1158.Metal3 0.00131053f
Cred_5002 vdd.$2761.Metal2 vout.$1329.Metal4 0.000700357f
Cred_5003 vdd.$2761.Metal2 vout.$1330.Metal4 0.000981461f
Cred_5004 vdd.$2761.Metal2 vout.$1331.Metal4 0.000267971f
Cred_5005 vdd.$2761.Metal2 vout.$1369.Metal4 0.00446981f
Cred_5006 vdd.$2761.Metal2 vout.$1370.Metal4 0.00908227f
Cred_5007 vdd.$2761.Metal2 vout.$1371.Metal4 0.00165626f
Cred_5008 vdd.$2761.Metal2 vout.$157.Metal1 0.00785348f
Cred_5009 vdd.$2761.Metal2 vout.$158.Metal1 0.0107048f
Cred_5010 vdd.$2761.Metal2 vout.$159.Metal1 0.00290891f
Cred_5011 vdd.$2761.Metal2 vout.$207.Metal1 0.00720126f
Cred_5012 vdd.$2761.Metal2 vout.$208.Metal1 0.00976101f
Cred_5013 vdd.$2761.Metal2 vout.$209.Metal1 0.00266557f
Cred_5014 vdd.$2761.Metal2 vout.$227.Metal1 0.00537562f
Cred_5015 vdd.$2761.Metal2 vout.$228.Metal1 0.00750815f
Cred_5016 vdd.$2761.Metal2 vout.$229.Metal1 0.00206912f
Cred_5017 vdd.$2761.Metal2 vout.$267.Metal1 0.00547433f
Cred_5018 vdd.$2761.Metal2 vout.$268.Metal1 0.00765264f
Cred_5019 vdd.$2761.Metal2 vout.$269.Metal1 0.00208694f
Cred_5020 vdd.$2761.Metal2 vout.$287.Metal1 0.00570307f
Cred_5021 vdd.$2761.Metal2 vout.$288.Metal1 0.00785204f
Cred_5022 vdd.$2761.Metal2 vout.$289.Metal1 0.00212721f
Cred_5023 vdd.$2761.Metal2 vout.$327.Metal1 0.00590761f
Cred_5024 vdd.$2761.Metal2 vout.$328.Metal1 0.00798643f
Cred_5025 vdd.$2761.Metal2 vout.$329.Metal1 0.00214869f
Cred_5026 vdd.$2761.Metal2 vout.$347.Metal1 0.00808797f
Cred_5027 vdd.$2761.Metal2 vout.$348.Metal1 0.0109362f
Cred_5028 vdd.$2761.Metal2 vout.$349.Metal1 0.00294251f
Cred_5029 vdd.$2761.Metal2 vout.$397.Metal1 0.00906383f
Cred_5030 vdd.$2761.Metal2 vout.$398.Metal1 0.0123706f
Cred_5031 vdd.$2761.Metal2 vout.$399.Metal1 0.00330728f
Cred_5032 vdd.$2761.Metal2 vout.$586.Metal2 0.0126953f
Cred_5033 vdd.$2761.Metal2 vout.$588.Metal2 0.0171018f
Cred_5034 vdd.$2761.Metal2 vout.$590.Metal2 0.00463129f
Cred_5035 vdd.$2761.Metal2 vout.$606.Metal2 0.01038f
Cred_5036 vdd.$2761.Metal2 vout.$608.Metal2 0.0142332f
Cred_5037 vdd.$2761.Metal2 vout.$610.Metal2 0.00384989f
Cred_5038 vdd.$2761.Metal2 vout.$646.Metal2 0.0104139f
Cred_5039 vdd.$2761.Metal2 vout.$648.Metal2 0.0145864f
Cred_5040 vdd.$2761.Metal2 vout.$650.Metal2 0.00392731f
Cred_5041 vdd.$2761.Metal2 vout.$666.Metal2 0.00757939f
Cred_5042 vdd.$2761.Metal2 vout.$668.Metal2 0.0100211f
Cred_5043 vdd.$2761.Metal2 vout.$670.Metal2 0.00274146f
Cred_5044 vdd.$2761.Metal2 vout.$686.Metal2 0.00798673f
Cred_5045 vdd.$2761.Metal2 vout.$688.Metal2 0.010864f
Cred_5046 vdd.$2761.Metal2 vout.$690.Metal2 0.00292966f
Cred_5047 vdd.$2761.Metal2 vout.$706.Metal2 0.00863536f
Cred_5048 vdd.$2761.Metal2 vout.$708.Metal2 0.0116575f
Cred_5049 vdd.$2761.Metal2 vout.$710.Metal2 0.0031347f
Cred_5050 vdd.$2761.Metal2 vout.$726.Metal2 0.0134914f
Cred_5051 vdd.$2761.Metal2 vout.$728.Metal2 0.0182147f
Cred_5052 vdd.$2761.Metal2 vout.$730.Metal2 0.00489806f
Cred_5053 vdd.$2761.Metal2 vout.$766.Metal2 0.0143843f
Cred_5054 vdd.$2761.Metal2 vout.$768.Metal2 0.0194211f
Cred_5055 vdd.$2761.Metal2 vout.$770.Metal2 0.00522212f
Cred_5056 vdd.$2761.Metal2 vout.$786.Metal2 0.019224f
Cred_5057 vdd.$2761.Metal2 vout.$788.Metal2 0.0291193f
Cred_5058 vdd.$2761.Metal2 vout.$790.Metal2 0.00693308f
Cred_5059 vdd.$2761.Metal2 vout.P2.pSD 0.000207635f
Cred_5060 vdd.$2761.Metal2 vout.P4.pSD 0.00234622f
Cred_5061 vdd.$2761.Metal2 vout.P6.pSD 7.62963e-05f
Cred_5062 vdd.$2761.Metal2 vss 0.00618703f
Cred_5063 vdd.$2761.Metal2 vss.$1211.Metal5 0.000657484f
Cred_5064 vdd.$2761.Metal2 vss.$1229.Metal5 0.000657484f
Cred_5065 vdd.$2761.Metal2 vss.$1281.Metal5 0.00251671f
Cred_5066 vdd.$2761.Metal2 vss.$1299.Metal5 0.00251671f
Cred_5067 vdd.$2765.Metal2 vout.$1036.Metal3 0.00637795f
Cred_5068 vdd.$2765.Metal2 vout.$1038.Metal3 0.00729382f
Cred_5069 vdd.$2765.Metal2 vout.$1076.Metal3 0.00400383f
Cred_5070 vdd.$2765.Metal2 vout.$1078.Metal3 0.00425162f
Cred_5071 vdd.$2765.Metal2 vout.$1116.Metal3 0.00450027f
Cred_5072 vdd.$2765.Metal2 vout.$1118.Metal3 0.00453263f
Cred_5073 vdd.$2765.Metal2 vout.$1156.Metal3 0.0109663f
Cred_5074 vdd.$2765.Metal2 vout.$1158.Metal3 0.0107765f
Cred_5075 vdd.$2765.Metal2 vout.$1330.Metal4 0.00212827f
Cred_5076 vdd.$2765.Metal2 vout.$1331.Metal4 0.00219601f
Cred_5077 vdd.$2765.Metal2 vout.$1370.Metal4 0.0147692f
Cred_5078 vdd.$2765.Metal2 vout.$1371.Metal4 0.0156476f
Cred_5079 vdd.$2765.Metal2 vout.$158.Metal1 0.0241149f
Cred_5080 vdd.$2765.Metal2 vout.$159.Metal1 0.0238384f
Cred_5081 vdd.$2765.Metal2 vout.$208.Metal1 0.022355f
Cred_5082 vdd.$2765.Metal2 vout.$209.Metal1 0.0218442f
Cred_5083 vdd.$2765.Metal2 vout.$228.Metal1 0.0166514f
Cred_5084 vdd.$2765.Metal2 vout.$229.Metal1 0.0169563f
Cred_5085 vdd.$2765.Metal2 vout.$268.Metal1 0.0166875f
Cred_5086 vdd.$2765.Metal2 vout.$269.Metal1 0.0171024f
Cred_5087 vdd.$2765.Metal2 vout.$288.Metal1 0.0173244f
Cred_5088 vdd.$2765.Metal2 vout.$289.Metal1 0.0174324f
Cred_5089 vdd.$2765.Metal2 vout.$328.Metal1 0.0179457f
Cred_5090 vdd.$2765.Metal2 vout.$329.Metal1 0.0176084f
Cred_5091 vdd.$2765.Metal2 vout.$348.Metal1 0.0245691f
Cred_5092 vdd.$2765.Metal2 vout.$349.Metal1 0.0241138f
Cred_5093 vdd.$2765.Metal2 vout.$398.Metal1 0.0275596f
Cred_5094 vdd.$2765.Metal2 vout.$399.Metal1 0.0271487f
Cred_5095 vdd.$2765.Metal2 vout.$588.Metal2 0.0389733f
Cred_5096 vdd.$2765.Metal2 vout.$590.Metal2 0.0379532f
Cred_5097 vdd.$2765.Metal2 vout.$608.Metal2 0.0315337f
Cred_5098 vdd.$2765.Metal2 vout.$610.Metal2 0.0315497f
Cred_5099 vdd.$2765.Metal2 vout.$648.Metal2 0.0327295f
Cred_5100 vdd.$2765.Metal2 vout.$650.Metal2 0.0321842f
Cred_5101 vdd.$2765.Metal2 vout.$668.Metal2 0.0230248f
Cred_5102 vdd.$2765.Metal2 vout.$670.Metal2 0.0224661f
Cred_5103 vdd.$2765.Metal2 vout.$688.Metal2 0.0242615f
Cred_5104 vdd.$2765.Metal2 vout.$690.Metal2 0.0240084f
Cred_5105 vdd.$2765.Metal2 vout.$708.Metal2 0.0262319f
Cred_5106 vdd.$2765.Metal2 vout.$710.Metal2 0.0256888f
Cred_5107 vdd.$2765.Metal2 vout.$728.Metal2 0.0409832f
Cred_5108 vdd.$2765.Metal2 vout.$730.Metal2 0.0401394f
Cred_5109 vdd.$2765.Metal2 vout.$768.Metal2 0.043696f
Cred_5110 vdd.$2765.Metal2 vout.$770.Metal2 0.0427958f
Cred_5111 vdd.$2765.Metal2 vout.$788.Metal2 0.059712f
Cred_5112 vdd.$2765.Metal2 vout.$790.Metal2 0.0591082f
Cred_5113 vdd.$2765.Metal2 vout.P4.pSD 0.001312f
Cred_5114 vdd.$2765.Metal2 vout.P6.pSD 0.00198359f
Cred_5115 vdd.$2765.Metal2 vss 0.00970022f
Cred_5116 vdd.$2765.Metal2 vss.$1211.Metal5 0.00114581f
Cred_5117 vdd.$2765.Metal2 vss.$1229.Metal5 0.00114581f
Cred_5118 vdd.$2765.Metal2 vss.$1281.Metal5 0.00438593f
Cred_5119 vdd.$2765.Metal2 vss.$1299.Metal5 0.00438593f
Cred_5120 vdd.$2769.Metal2 vout.$1038.Metal3 0.00546975f
Cred_5121 vdd.$2769.Metal2 vout.$1040.Metal3 0.00550747f
Cred_5122 vdd.$2769.Metal2 vout.$1078.Metal3 0.00259024f
Cred_5123 vdd.$2769.Metal2 vout.$1080.Metal3 0.00224073f
Cred_5124 vdd.$2769.Metal2 vout.$1100.Metal3 0.00386027f
Cred_5125 vdd.$2769.Metal2 vout.$1118.Metal3 0.00370412f
Cred_5126 vdd.$2769.Metal2 vout.$1158.Metal3 0.00904568f
Cred_5127 vdd.$2769.Metal2 vout.$1160.Metal3 0.00999711f
Cred_5128 vdd.$2769.Metal2 vout.$1331.Metal4 0.00174893f
Cred_5129 vdd.$2769.Metal2 vout.$1332.Metal4 0.0017779f
Cred_5130 vdd.$2769.Metal2 vout.$1371.Metal4 0.0133981f
Cred_5131 vdd.$2769.Metal2 vout.$1372.Metal4 0.0114301f
Cred_5132 vdd.$2769.Metal2 vout.$159.Metal1 0.0196362f
Cred_5133 vdd.$2769.Metal2 vout.$160.Metal1 0.0193164f
Cred_5134 vdd.$2769.Metal2 vout.$209.Metal1 0.0180054f
Cred_5135 vdd.$2769.Metal2 vout.$210.Metal1 0.0176905f
Cred_5136 vdd.$2769.Metal2 vout.$229.Metal1 0.0134466f
Cred_5137 vdd.$2769.Metal2 vout.$230.Metal1 0.0138635f
Cred_5138 vdd.$2769.Metal2 vout.$269.Metal1 0.0137034f
Cred_5139 vdd.$2769.Metal2 vout.$270.Metal1 0.0136351f
Cred_5140 vdd.$2769.Metal2 vout.$289.Metal1 0.0142595f
Cred_5141 vdd.$2769.Metal2 vout.$290.Metal1 0.0144436f
Cred_5142 vdd.$2769.Metal2 vout.$329.Metal1 0.0147709f
Cred_5143 vdd.$2769.Metal2 vout.$330.Metal1 0.0144933f
Cred_5144 vdd.$2769.Metal2 vout.$349.Metal1 0.0202225f
Cred_5145 vdd.$2769.Metal2 vout.$350.Metal1 0.0198478f
Cred_5146 vdd.$2769.Metal2 vout.$399.Metal1 0.0227081f
Cred_5147 vdd.$2769.Metal2 vout.$400.Metal1 0.0223086f
Cred_5148 vdd.$2769.Metal2 vout.$590.Metal2 0.0317422f
Cred_5149 vdd.$2769.Metal2 vout.$592.Metal2 0.0313197f
Cred_5150 vdd.$2769.Metal2 vout.$610.Metal2 0.0259533f
Cred_5151 vdd.$2769.Metal2 vout.$612.Metal2 0.0259542f
Cred_5152 vdd.$2769.Metal2 vout.$650.Metal2 0.0264835f
Cred_5153 vdd.$2769.Metal2 vout.$652.Metal2 0.0264877f
Cred_5154 vdd.$2769.Metal2 vout.$670.Metal2 0.0184909f
Cred_5155 vdd.$2769.Metal2 vout.$672.Metal2 0.0284116f
Cred_5156 vdd.$2769.Metal2 vout.$690.Metal2 0.0199694f
Cred_5157 vdd.$2769.Metal2 vout.$710.Metal2 0.0215912f
Cred_5158 vdd.$2769.Metal2 vout.$712.Metal2 0.030858f
Cred_5159 vdd.$2769.Metal2 vout.$730.Metal2 0.0337328f
Cred_5160 vdd.$2769.Metal2 vout.$732.Metal2 0.0330558f
Cred_5161 vdd.$2769.Metal2 vout.$770.Metal2 0.0359661f
Cred_5162 vdd.$2769.Metal2 vout.$772.Metal2 0.0352299f
Cred_5163 vdd.$2769.Metal2 vout.$790.Metal2 0.050358f
Cred_5164 vdd.$2769.Metal2 vout.$792.Metal2 0.0467954f
Cred_5165 vdd.$2769.Metal2 vout.P6.pSD 0.00187757f
Cred_5166 vdd.$2769.Metal2 vout.P8.pSD 0.000506928f
Cred_5167 vdd.$2769.Metal2 vss 0.00630002f
Cred_5168 vdd.$2769.Metal2 vss.$1211.Metal5 0.000984475f
Cred_5169 vdd.$2769.Metal2 vss.$1229.Metal5 0.000984475f
Cred_5170 vdd.$2769.Metal2 vss.$1281.Metal5 0.00376837f
Cred_5171 vdd.$2769.Metal2 vss.$1299.Metal5 0.00376837f
Cred_5172 vdd.$2771.Metal2 vout.$1038.Metal3 0.00200558f
Cred_5173 vdd.$2771.Metal2 vout.$1040.Metal3 0.0020194f
Cred_5174 vdd.$2771.Metal2 vout.$1078.Metal3 0.000949756f
Cred_5175 vdd.$2771.Metal2 vout.$1080.Metal3 0.000821602f
Cred_5176 vdd.$2771.Metal2 vout.$1100.Metal3 0.00141543f
Cred_5177 vdd.$2771.Metal2 vout.$1118.Metal3 0.00135818f
Cred_5178 vdd.$2771.Metal2 vout.$1158.Metal3 0.00330327f
Cred_5179 vdd.$2771.Metal2 vout.$1160.Metal3 0.0037132f
Cred_5180 vdd.$2771.Metal2 vout.$1331.Metal4 0.000641275f
Cred_5181 vdd.$2771.Metal2 vout.$1332.Metal4 0.000651898f
Cred_5182 vdd.$2771.Metal2 vout.$1371.Metal4 0.00409704f
Cred_5183 vdd.$2771.Metal2 vout.$1372.Metal4 0.00610074f
Cred_5184 vdd.$2771.Metal2 vout.$159.Metal1 0.00719994f
Cred_5185 vdd.$2771.Metal2 vout.$160.Metal1 0.00708268f
Cred_5186 vdd.$2771.Metal2 vout.$209.Metal1 0.00660199f
Cred_5187 vdd.$2771.Metal2 vout.$210.Metal1 0.00648653f
Cred_5188 vdd.$2771.Metal2 vout.$229.Metal1 0.00493041f
Cred_5189 vdd.$2771.Metal2 vout.$230.Metal1 0.00508328f
Cred_5190 vdd.$2771.Metal2 vout.$269.Metal1 0.00502457f
Cred_5191 vdd.$2771.Metal2 vout.$270.Metal1 0.00499954f
Cred_5192 vdd.$2771.Metal2 vout.$289.Metal1 0.00522848f
Cred_5193 vdd.$2771.Metal2 vout.$290.Metal1 0.00529598f
Cred_5194 vdd.$2771.Metal2 vout.$329.Metal1 0.005416f
Cred_5195 vdd.$2771.Metal2 vout.$330.Metal1 0.00531421f
Cred_5196 vdd.$2771.Metal2 vout.$349.Metal1 0.00741492f
Cred_5197 vdd.$2771.Metal2 vout.$350.Metal1 0.00727751f
Cred_5198 vdd.$2771.Metal2 vout.$399.Metal1 0.00830957f
Cred_5199 vdd.$2771.Metal2 vout.$400.Metal1 0.00822368f
Cred_5200 vdd.$2771.Metal2 vout.$590.Metal2 0.0116388f
Cred_5201 vdd.$2771.Metal2 vout.$592.Metal2 0.0114839f
Cred_5202 vdd.$2771.Metal2 vout.$610.Metal2 0.0095162f
Cred_5203 vdd.$2771.Metal2 vout.$612.Metal2 0.00951656f
Cred_5204 vdd.$2771.Metal2 vout.$650.Metal2 0.00971061f
Cred_5205 vdd.$2771.Metal2 vout.$652.Metal2 0.00971217f
Cred_5206 vdd.$2771.Metal2 vout.$670.Metal2 0.00677999f
Cred_5207 vdd.$2771.Metal2 vout.$672.Metal2 0.0104176f
Cred_5208 vdd.$2771.Metal2 vout.$690.Metal2 0.00732211f
Cred_5209 vdd.$2771.Metal2 vout.$710.Metal2 0.00791676f
Cred_5210 vdd.$2771.Metal2 vout.$712.Metal2 0.0113146f
Cred_5211 vdd.$2771.Metal2 vout.$730.Metal2 0.0123687f
Cred_5212 vdd.$2771.Metal2 vout.$732.Metal2 0.0121204f
Cred_5213 vdd.$2771.Metal2 vout.$770.Metal2 0.0131873f
Cred_5214 vdd.$2771.Metal2 vout.$772.Metal2 0.0129186f
Cred_5215 vdd.$2771.Metal2 vout.$790.Metal2 0.0176243f
Cred_5216 vdd.$2771.Metal2 vout.$792.Metal2 0.0193625f
Cred_5217 vdd.$2771.Metal2 vout.P6.pSD 0.00019038f
Cred_5218 vdd.$2771.Metal2 vout.P8.pSD 0.00157105f
Cred_5219 vdd.$2771.Metal2 vss 0.00363304f
Cred_5220 vdd.$2771.Metal2 vss.$1211.Metal5 0.000448808f
Cred_5221 vdd.$2771.Metal2 vss.$1229.Metal5 0.000448808f
Cred_5222 vdd.$2771.Metal2 vss.$1281.Metal5 0.00171795f
Cred_5223 vdd.$2771.Metal2 vss.$1299.Metal5 0.00171795f
Cred_5224 vdd.$2773.Metal2 vout.$1040.Metal3 0.00174478f
Cred_5225 vdd.$2773.Metal2 vout.$1080.Metal3 0.000622652f
Cred_5226 vdd.$2773.Metal2 vout.$1100.Metal3 0.00119429f
Cred_5227 vdd.$2773.Metal2 vout.$1122.Metal3 0.000243879f
Cred_5228 vdd.$2773.Metal2 vout.$1160.Metal3 0.00333984f
Cred_5229 vdd.$2773.Metal2 vout.$1162.Metal3 0.00060499f
Cred_5230 vdd.$2773.Metal2 vout.$1332.Metal4 0.000582762f
Cred_5231 vdd.$2773.Metal2 vout.$1372.Metal4 0.0104375f
Cred_5232 vdd.$2773.Metal2 vout.$1383.Metal4 2.87873e-05f
Cred_5233 vdd.$2773.Metal2 vout.$160.Metal1 0.00645651f
Cred_5234 vdd.$2773.Metal2 vout.$210.Metal1 0.00589909f
Cred_5235 vdd.$2773.Metal2 vout.$230.Metal1 0.00444913f
Cred_5236 vdd.$2773.Metal2 vout.$270.Metal1 0.00469743f
Cred_5237 vdd.$2773.Metal2 vout.$290.Metal1 0.0046952f
Cred_5238 vdd.$2773.Metal2 vout.$330.Metal1 0.00477349f
Cred_5239 vdd.$2773.Metal2 vout.$331.Metal1 1.05974e-06f
Cred_5240 vdd.$2773.Metal2 vout.$350.Metal1 0.0065359f
Cred_5241 vdd.$2773.Metal2 vout.$351.Metal1 8.61038e-06f
Cred_5242 vdd.$2773.Metal2 vout.$400.Metal1 0.00745808f
Cred_5243 vdd.$2773.Metal2 vout.$401.Metal1 1.88414e-05f
Cred_5244 vdd.$2773.Metal2 vout.$592.Metal2 0.0103555f
Cred_5245 vdd.$2773.Metal2 vout.$612.Metal2 0.00854438f
Cred_5246 vdd.$2773.Metal2 vout.$652.Metal2 0.00871824f
Cred_5247 vdd.$2773.Metal2 vout.$672.Metal2 0.0095022f
Cred_5248 vdd.$2773.Metal2 vout.$694.Metal2 0.000876114f
Cred_5249 vdd.$2773.Metal2 vout.$712.Metal2 0.0103961f
Cred_5250 vdd.$2773.Metal2 vout.$714.Metal2 0.000913879f
Cred_5251 vdd.$2773.Metal2 vout.$732.Metal2 0.0110577f
Cred_5252 vdd.$2773.Metal2 vout.$734.Metal2 0.00143242f
Cred_5253 vdd.$2773.Metal2 vout.$772.Metal2 0.0117834f
Cred_5254 vdd.$2773.Metal2 vout.$774.Metal2 0.00152123f
Cred_5255 vdd.$2773.Metal2 vout.$792.Metal2 0.0184126f
Cred_5256 vdd.$2773.Metal2 vout.$794.Metal2 0.00203842f
Cred_5257 vdd.$2773.Metal2 vout.P8.pSD 0.00145871f
Cred_5258 vdd.$2773.Metal2 vref 0.0151659f
Cred_5259 vdd.$2773.Metal2 vref.P0.GatPoly 0.000591386f
Cred_5260 vdd.$2773.Metal2 vref.P0.nSD 0.00339022f
Cred_5261 vdd.$2773.Metal2 vref.P0.pSD 0.0672177f
Cred_5262 vdd.$2773.Metal2 vss 0.00252847f
Cred_5263 vdd.$2773.Metal2 vss.$1211.Metal5 0.000356574f
Cred_5264 vdd.$2773.Metal2 vss.$1229.Metal5 0.000356574f
Cred_5265 vdd.$2773.Metal2 vss.$1281.Metal5 0.00136489f
Cred_5266 vdd.$2773.Metal2 vss.$1299.Metal5 0.00136489f
Cred_5267 vdd.$2775.Metal2 vout.$1040.Metal3 0.00540881f
Cred_5268 vdd.$2775.Metal2 vout.$1080.Metal3 0.00193022f
Cred_5269 vdd.$2775.Metal2 vout.$1100.Metal3 0.00370229f
Cred_5270 vdd.$2775.Metal2 vout.$1122.Metal3 0.000756024f
Cred_5271 vdd.$2775.Metal2 vout.$1160.Metal3 0.0102324f
Cred_5272 vdd.$2775.Metal2 vout.$1162.Metal3 0.00187547f
Cred_5273 vdd.$2775.Metal2 vout.$1332.Metal4 0.00180656f
Cred_5274 vdd.$2775.Metal2 vout.$1372.Metal4 0.0291154f
Cred_5275 vdd.$2775.Metal2 vout.$1383.Metal4 0.000870212f
Cred_5276 vdd.$2775.Metal2 vout.$160.Metal1 0.0200152f
Cred_5277 vdd.$2775.Metal2 vout.$210.Metal1 0.0182872f
Cred_5278 vdd.$2775.Metal2 vout.$230.Metal1 0.0137923f
Cred_5279 vdd.$2775.Metal2 vout.$270.Metal1 0.014562f
Cred_5280 vdd.$2775.Metal2 vout.$290.Metal1 0.0145551f
Cred_5281 vdd.$2775.Metal2 vout.$330.Metal1 0.0147978f
Cred_5282 vdd.$2775.Metal2 vout.$331.Metal1 3.28519e-06f
Cred_5283 vdd.$2775.Metal2 vout.$350.Metal1 0.0202613f
Cred_5284 vdd.$2775.Metal2 vout.$351.Metal1 2.66922e-05f
Cred_5285 vdd.$2775.Metal2 vout.$400.Metal1 0.0229022f
Cred_5286 vdd.$2775.Metal2 vout.$401.Metal1 5.84084e-05f
Cred_5287 vdd.$2775.Metal2 vout.$592.Metal2 0.032102f
Cred_5288 vdd.$2775.Metal2 vout.$612.Metal2 0.0264876f
Cred_5289 vdd.$2775.Metal2 vout.$652.Metal2 0.0270266f
Cred_5290 vdd.$2775.Metal2 vout.$672.Metal2 0.0294568f
Cred_5291 vdd.$2775.Metal2 vout.$694.Metal2 0.00271595f
Cred_5292 vdd.$2775.Metal2 vout.$712.Metal2 0.0322279f
Cred_5293 vdd.$2775.Metal2 vout.$714.Metal2 0.00283303f
Cred_5294 vdd.$2775.Metal2 vout.$732.Metal2 0.0342789f
Cred_5295 vdd.$2775.Metal2 vout.$734.Metal2 0.00444049f
Cred_5296 vdd.$2775.Metal2 vout.$772.Metal2 0.036526f
Cred_5297 vdd.$2775.Metal2 vout.$774.Metal2 0.00471582f
Cred_5298 vdd.$2775.Metal2 vout.$792.Metal2 0.0495308f
Cred_5299 vdd.$2775.Metal2 vout.$794.Metal2 0.00631911f
Cred_5300 vdd.$2775.Metal2 vout.P8.pSD 0.000527741f
Cred_5301 vdd.$2775.Metal2 vref 0.0472901f
Cred_5302 vdd.$2775.Metal2 vref.P0.GatPoly 0.00184405f
Cred_5303 vdd.$2775.Metal2 vref.P0.nSD 0.0105713f
Cred_5304 vdd.$2775.Metal2 vref.P0.pSD 0.211188f
Cred_5305 vdd.$2775.Metal2 vss 0.00197316f
Cred_5306 vdd.$2775.Metal2 vss.$1211.Metal5 0.000718297f
Cred_5307 vdd.$2775.Metal2 vss.$1229.Metal5 0.000718297f
Cred_5308 vdd.$2775.Metal2 vss.$1281.Metal5 0.0027495f
Cred_5309 vdd.$2775.Metal2 vss.$1299.Metal5 0.0027495f
Cred_5310 vdd.$2779.Metal2 vout.$1002.Metal3 0.00339299f
Cred_5311 vdd.$2779.Metal2 vout.$1042.Metal3 0.00312426f
Cred_5312 vdd.$2779.Metal2 vout.$1082.Metal3 0.00265464f
Cred_5313 vdd.$2779.Metal2 vout.$1100.Metal3 0.000514471f
Cred_5314 vdd.$2779.Metal2 vout.$1122.Metal3 0.00364488f
Cred_5315 vdd.$2779.Metal2 vout.$1160.Metal3 0.00211457f
Cred_5316 vdd.$2779.Metal2 vout.$1162.Metal3 0.00948429f
Cred_5317 vdd.$2779.Metal2 vout.$1313.Metal4 2.78228e-05f
Cred_5318 vdd.$2779.Metal2 vout.$1323.Metal4 0.000435279f
Cred_5319 vdd.$2779.Metal2 vout.$1333.Metal4 0.000456849f
Cred_5320 vdd.$2779.Metal2 vout.$1343.Metal4 0.000448459f
Cred_5321 vdd.$2779.Metal2 vout.$1353.Metal4 0.00047159f
Cred_5322 vdd.$2779.Metal2 vout.$1363.Metal4 0.000473054f
Cred_5323 vdd.$2779.Metal2 vout.$1372.Metal4 0.00918034f
Cred_5324 vdd.$2779.Metal2 vout.$1373.Metal4 0.00743233f
Cred_5325 vdd.$2779.Metal2 vout.$1383.Metal4 0.0170892f
Cred_5326 vdd.$2779.Metal2 vout.$161.Metal1 0.0208478f
Cred_5327 vdd.$2779.Metal2 vout.$211.Metal1 0.0232963f
Cred_5328 vdd.$2779.Metal2 vout.$251.Metal1 0.0190714f
Cred_5329 vdd.$2779.Metal2 vout.$270.Metal1 1.34545e-05f
Cred_5330 vdd.$2779.Metal2 vout.$290.Metal1 1.30909e-05f
Cred_5331 vdd.$2779.Metal2 vout.$291.Metal1 0.0202841f
Cred_5332 vdd.$2779.Metal2 vout.$330.Metal1 3.28519e-06f
Cred_5333 vdd.$2779.Metal2 vout.$331.Metal1 0.0157584f
Cred_5334 vdd.$2779.Metal2 vout.$350.Metal1 2.66922e-05f
Cred_5335 vdd.$2779.Metal2 vout.$351.Metal1 0.0215682f
Cred_5336 vdd.$2779.Metal2 vout.$400.Metal1 5.84084e-05f
Cred_5337 vdd.$2779.Metal2 vout.$401.Metal1 0.0241758f
Cred_5338 vdd.$2779.Metal2 vout.$594.Metal2 0.0328405f
Cred_5339 vdd.$2779.Metal2 vout.$614.Metal2 0.0181578f
Cred_5340 vdd.$2779.Metal2 vout.$634.Metal2 0.0182844f
Cred_5341 vdd.$2779.Metal2 vout.$654.Metal2 0.0188119f
Cred_5342 vdd.$2779.Metal2 vout.$672.Metal2 0.00133136f
Cred_5343 vdd.$2779.Metal2 vout.$674.Metal2 0.019394f
Cred_5344 vdd.$2779.Metal2 vout.$694.Metal2 0.0212052f
Cred_5345 vdd.$2779.Metal2 vout.$712.Metal2 0.00417416f
Cred_5346 vdd.$2779.Metal2 vout.$714.Metal2 0.0222406f
Cred_5347 vdd.$2779.Metal2 vout.$732.Metal2 0.00444528f
Cred_5348 vdd.$2779.Metal2 vout.$734.Metal2 0.0347481f
Cred_5349 vdd.$2779.Metal2 vout.$772.Metal2 0.00471582f
Cred_5350 vdd.$2779.Metal2 vout.$774.Metal2 0.0370579f
Cred_5351 vdd.$2779.Metal2 vout.$792.Metal2 0.00631911f
Cred_5352 vdd.$2779.Metal2 vout.$794.Metal2 0.0495415f
Cred_5353 vdd.$2779.Metal2 vout.P10.pSD 0.000607416f
Cred_5354 vdd.$2779.Metal2 vref 0.0444002f
Cred_5355 vdd.$2779.Metal2 vref.P0.GatPoly 0.00173136f
Cred_5356 vdd.$2779.Metal2 vref.P0.nSD 0.00992531f
Cred_5357 vdd.$2779.Metal2 vref.P0.pSD 0.199006f
Cred_5358 vdd.$2779.Metal2 vss 0.00206829f
Cred_5359 vdd.$2779.Metal2 vss.$1211.Metal5 0.000753011f
Cred_5360 vdd.$2779.Metal2 vss.$1229.Metal5 0.000753011f
Cred_5361 vdd.$2779.Metal2 vss.$1281.Metal5 0.00288237f
Cred_5362 vdd.$2779.Metal2 vss.$1299.Metal5 0.00288237f
Cred_5363 vdd.$2781.Metal2 vout.$1002.Metal3 0.00109451f
Cred_5364 vdd.$2781.Metal2 vout.$1042.Metal3 0.00100782f
Cred_5365 vdd.$2781.Metal2 vout.$1082.Metal3 0.000856336f
Cred_5366 vdd.$2781.Metal2 vout.$1100.Metal3 0.000165958f
Cred_5367 vdd.$2781.Metal2 vout.$1122.Metal3 0.00117577f
Cred_5368 vdd.$2781.Metal2 vout.$1160.Metal3 0.000682119f
Cred_5369 vdd.$2781.Metal2 vout.$1162.Metal3 0.00309851f
Cred_5370 vdd.$2781.Metal2 vout.$1313.Metal4 8.9751e-06f
Cred_5371 vdd.$2781.Metal2 vout.$1323.Metal4 0.000140412f
Cred_5372 vdd.$2781.Metal2 vout.$1333.Metal4 0.000147371f
Cred_5373 vdd.$2781.Metal2 vout.$1343.Metal4 0.000144664f
Cred_5374 vdd.$2781.Metal2 vout.$1353.Metal4 0.000152126f
Cred_5375 vdd.$2781.Metal2 vout.$1363.Metal4 0.000152598f
Cred_5376 vdd.$2781.Metal2 vout.$1372.Metal4 0.00270947f
Cred_5377 vdd.$2781.Metal2 vout.$1373.Metal4 0.00239753f
Cred_5378 vdd.$2781.Metal2 vout.$1383.Metal4 0.0065581f
Cred_5379 vdd.$2781.Metal2 vout.$161.Metal1 0.00672509f
Cred_5380 vdd.$2781.Metal2 vout.$211.Metal1 0.00751493f
Cred_5381 vdd.$2781.Metal2 vout.$251.Metal1 0.00615207f
Cred_5382 vdd.$2781.Metal2 vout.$270.Metal1 4.34017e-06f
Cred_5383 vdd.$2781.Metal2 vout.$290.Metal1 4.22287e-06f
Cred_5384 vdd.$2781.Metal2 vout.$291.Metal1 0.00654326f
Cred_5385 vdd.$2781.Metal2 vout.$330.Metal1 1.05974e-06f
Cred_5386 vdd.$2781.Metal2 vout.$331.Metal1 0.00508334f
Cred_5387 vdd.$2781.Metal2 vout.$350.Metal1 8.61038e-06f
Cred_5388 vdd.$2781.Metal2 vout.$351.Metal1 0.00695748f
Cred_5389 vdd.$2781.Metal2 vout.$400.Metal1 1.88414e-05f
Cred_5390 vdd.$2781.Metal2 vout.$401.Metal1 0.00786891f
Cred_5391 vdd.$2781.Metal2 vout.$594.Metal2 0.0105937f
Cred_5392 vdd.$2781.Metal2 vout.$614.Metal2 0.00585736f
Cred_5393 vdd.$2781.Metal2 vout.$634.Metal2 0.0058982f
Cred_5394 vdd.$2781.Metal2 vout.$654.Metal2 0.00606834f
Cred_5395 vdd.$2781.Metal2 vout.$672.Metal2 0.000429471f
Cred_5396 vdd.$2781.Metal2 vout.$674.Metal2 0.00625612f
Cred_5397 vdd.$2781.Metal2 vout.$694.Metal2 0.00684038f
Cred_5398 vdd.$2781.Metal2 vout.$712.Metal2 0.0013465f
Cred_5399 vdd.$2781.Metal2 vout.$714.Metal2 0.00717438f
Cred_5400 vdd.$2781.Metal2 vout.$732.Metal2 0.00143396f
Cred_5401 vdd.$2781.Metal2 vout.$734.Metal2 0.0112091f
Cred_5402 vdd.$2781.Metal2 vout.$772.Metal2 0.00152123f
Cred_5403 vdd.$2781.Metal2 vout.$774.Metal2 0.011955f
Cred_5404 vdd.$2781.Metal2 vout.$792.Metal2 0.00203842f
Cred_5405 vdd.$2781.Metal2 vout.$794.Metal2 0.0184161f
Cred_5406 vdd.$2781.Metal2 vout.P10.pSD 0.00148441f
Cred_5407 vdd.$2781.Metal2 vref 0.0142337f
Cred_5408 vdd.$2781.Metal2 vref.P0.GatPoly 0.000555035f
Cred_5409 vdd.$2781.Metal2 vref.P0.nSD 0.00318183f
Cred_5410 vdd.$2781.Metal2 vref.P0.pSD 0.0632878f
Cred_5411 vdd.$2781.Metal2 vss 0.00255916f
Cred_5412 vdd.$2781.Metal2 vss.$1211.Metal5 0.000367772f
Cred_5413 vdd.$2781.Metal2 vss.$1229.Metal5 0.000367772f
Cred_5414 vdd.$2781.Metal2 vss.$1281.Metal5 0.00140775f
Cred_5415 vdd.$2781.Metal2 vss.$1299.Metal5 0.00140775f
Cred_5416 vdd.$2783.Metal2 vout 0.000287237f
Cred_5417 vdd.$2783.Metal2 vout.$1002.Metal3 0.0012342f
Cred_5418 vdd.$2783.Metal2 vout.$1004.Metal3 0.00124593f
Cred_5419 vdd.$2783.Metal2 vout.$1042.Metal3 0.00094577f
Cred_5420 vdd.$2783.Metal2 vout.$1044.Metal3 0.00117136f
Cred_5421 vdd.$2783.Metal2 vout.$1082.Metal3 0.00127856f
Cred_5422 vdd.$2783.Metal2 vout.$1084.Metal3 0.000941836f
Cred_5423 vdd.$2783.Metal2 vout.$1122.Metal3 0.00143634f
Cred_5424 vdd.$2783.Metal2 vout.$1124.Metal3 0.00129316f
Cred_5425 vdd.$2783.Metal2 vout.$1162.Metal3 0.00335086f
Cred_5426 vdd.$2783.Metal2 vout.$1164.Metal3 0.00324125f
Cred_5427 vdd.$2783.Metal2 vout.$1299.Metal4 3.45881e-09f
Cred_5428 vdd.$2783.Metal2 vout.$1313.Metal4 0.000610123f
Cred_5429 vdd.$2783.Metal2 vout.$1323.Metal4 0.000581912f
Cred_5430 vdd.$2783.Metal2 vout.$1333.Metal4 0.000598893f
Cred_5431 vdd.$2783.Metal2 vout.$1343.Metal4 0.000599533f
Cred_5432 vdd.$2783.Metal2 vout.$1353.Metal4 0.00137264f
Cred_5433 vdd.$2783.Metal2 vout.$1363.Metal4 0.00140313f
Cred_5434 vdd.$2783.Metal2 vout.$1373.Metal4 0.00335147f
Cred_5435 vdd.$2783.Metal2 vout.$1383.Metal4 0.00320778f
Cred_5436 vdd.$2783.Metal2 vout.$1384.Metal4 0.000370634f
Cred_5437 vdd.$2783.Metal2 vout.$1394.Metal4 0.00282821f
Cred_5438 vdd.$2783.Metal2 vout.$161.Metal1 0.00728369f
Cred_5439 vdd.$2783.Metal2 vout.$162.Metal1 0.00719362f
Cred_5440 vdd.$2783.Metal2 vout.$211.Metal1 0.00855058f
Cred_5441 vdd.$2783.Metal2 vout.$212.Metal1 0.00659258f
Cred_5442 vdd.$2783.Metal2 vout.$232.Metal1 0.00502029f
Cred_5443 vdd.$2783.Metal2 vout.$251.Metal1 0.00695128f
Cred_5444 vdd.$2783.Metal2 vout.$272.Metal1 0.00533163f
Cred_5445 vdd.$2783.Metal2 vout.$291.Metal1 0.00682474f
Cred_5446 vdd.$2783.Metal2 vout.$292.Metal1 0.00527184f
Cred_5447 vdd.$2783.Metal2 vout.$331.Metal1 0.005416f
Cred_5448 vdd.$2783.Metal2 vout.$332.Metal1 0.00531421f
Cred_5449 vdd.$2783.Metal2 vout.$351.Metal1 0.00741492f
Cred_5450 vdd.$2783.Metal2 vout.$352.Metal1 0.00727751f
Cred_5451 vdd.$2783.Metal2 vout.$401.Metal1 0.00835343f
Cred_5452 vdd.$2783.Metal2 vout.$402.Metal1 0.00817968f
Cred_5453 vdd.$2783.Metal2 vout.$594.Metal2 0.0113238f
Cred_5454 vdd.$2783.Metal2 vout.$596.Metal2 0.011369f
Cred_5455 vdd.$2783.Metal2 vout.$614.Metal2 0.00636088f
Cred_5456 vdd.$2783.Metal2 vout.$616.Metal2 0.00949954f
Cred_5457 vdd.$2783.Metal2 vout.$634.Metal2 0.00640673f
Cred_5458 vdd.$2783.Metal2 vout.$654.Metal2 0.0064301f
Cred_5459 vdd.$2783.Metal2 vout.$656.Metal2 0.00987598f
Cred_5460 vdd.$2783.Metal2 vout.$674.Metal2 0.00677036f
Cred_5461 vdd.$2783.Metal2 vout.$676.Metal2 0.0067801f
Cred_5462 vdd.$2783.Metal2 vout.$694.Metal2 0.00747846f
Cred_5463 vdd.$2783.Metal2 vout.$696.Metal2 0.00724541f
Cred_5464 vdd.$2783.Metal2 vout.$714.Metal2 0.00791676f
Cred_5465 vdd.$2783.Metal2 vout.$716.Metal2 0.00775285f
Cred_5466 vdd.$2783.Metal2 vout.$734.Metal2 0.0123687f
Cred_5467 vdd.$2783.Metal2 vout.$736.Metal2 0.012114f
Cred_5468 vdd.$2783.Metal2 vout.$774.Metal2 0.0131882f
Cred_5469 vdd.$2783.Metal2 vout.$776.Metal2 0.0129155f
Cred_5470 vdd.$2783.Metal2 vout.$794.Metal2 0.0198284f
Cred_5471 vdd.$2783.Metal2 vout.$796.Metal2 0.0171471f
Cred_5472 vdd.$2783.Metal2 vout.P0.GatPoly 4.50578e-08f
Cred_5473 vdd.$2783.Metal2 vout.P10.pSD 0.00159418f
Cred_5474 vdd.$2783.Metal2 vout.P12.pSD 0.000188565f
Cred_5475 vdd.$2783.Metal2 vss 0.00316764f
Cred_5476 vdd.$2783.Metal2 vss.$1211.Metal5 0.000278985f
Cred_5477 vdd.$2783.Metal2 vss.$1229.Metal5 0.000278985f
Cred_5478 vdd.$2783.Metal2 vss.$1281.Metal5 0.0010679f
Cred_5479 vdd.$2783.Metal2 vss.$1299.Metal5 0.0010679f
Cred_5480 vdd.$2785.Metal2 vout 0.000783373f
Cred_5481 vdd.$2785.Metal2 vout.$1002.Metal3 0.003366f
Cred_5482 vdd.$2785.Metal2 vout.$1004.Metal3 0.00339799f
Cred_5483 vdd.$2785.Metal2 vout.$1042.Metal3 0.00257937f
Cred_5484 vdd.$2785.Metal2 vout.$1044.Metal3 0.00319463f
Cred_5485 vdd.$2785.Metal2 vout.$1082.Metal3 0.00348699f
Cred_5486 vdd.$2785.Metal2 vout.$1084.Metal3 0.00256864f
Cred_5487 vdd.$2785.Metal2 vout.$1122.Metal3 0.0039173f
Cred_5488 vdd.$2785.Metal2 vout.$1124.Metal3 0.00352681f
Cred_5489 vdd.$2785.Metal2 vout.$1162.Metal3 0.00900891f
Cred_5490 vdd.$2785.Metal2 vout.$1164.Metal3 0.00887653f
Cred_5491 vdd.$2785.Metal2 vout.$1299.Metal4 9.43312e-09f
Cred_5492 vdd.$2785.Metal2 vout.$1313.Metal4 0.00166397f
Cred_5493 vdd.$2785.Metal2 vout.$1323.Metal4 0.00158703f
Cred_5494 vdd.$2785.Metal2 vout.$1333.Metal4 0.00163334f
Cred_5495 vdd.$2785.Metal2 vout.$1343.Metal4 0.00163509f
Cred_5496 vdd.$2785.Metal2 vout.$1353.Metal4 0.00374355f
Cred_5497 vdd.$2785.Metal2 vout.$1363.Metal4 0.00382673f
Cred_5498 vdd.$2785.Metal2 vout.$1373.Metal4 0.00500745f
Cred_5499 vdd.$2785.Metal2 vout.$1383.Metal4 0.00873237f
Cred_5500 vdd.$2785.Metal2 vout.$1384.Metal4 0.00101082f
Cred_5501 vdd.$2785.Metal2 vout.$1394.Metal4 0.00771788f
Cred_5502 vdd.$2785.Metal2 vout.$161.Metal1 0.0198646f
Cred_5503 vdd.$2785.Metal2 vout.$162.Metal1 0.019619f
Cred_5504 vdd.$2785.Metal2 vout.$211.Metal1 0.0233198f
Cred_5505 vdd.$2785.Metal2 vout.$212.Metal1 0.0179798f
Cred_5506 vdd.$2785.Metal2 vout.$232.Metal1 0.0136917f
Cred_5507 vdd.$2785.Metal2 vout.$251.Metal1 0.018958f
Cred_5508 vdd.$2785.Metal2 vout.$272.Metal1 0.0145408f
Cred_5509 vdd.$2785.Metal2 vout.$291.Metal1 0.0186129f
Cred_5510 vdd.$2785.Metal2 vout.$292.Metal1 0.0143777f
Cred_5511 vdd.$2785.Metal2 vout.$331.Metal1 0.0147709f
Cred_5512 vdd.$2785.Metal2 vout.$332.Metal1 0.0144933f
Cred_5513 vdd.$2785.Metal2 vout.$351.Metal1 0.0202225f
Cred_5514 vdd.$2785.Metal2 vout.$352.Metal1 0.0198478f
Cred_5515 vdd.$2785.Metal2 vout.$401.Metal1 0.0226625f
Cred_5516 vdd.$2785.Metal2 vout.$402.Metal1 0.0223538f
Cred_5517 vdd.$2785.Metal2 vout.$594.Metal2 0.0308832f
Cred_5518 vdd.$2785.Metal2 vout.$596.Metal2 0.0310063f
Cred_5519 vdd.$2785.Metal2 vout.$614.Metal2 0.0173479f
Cred_5520 vdd.$2785.Metal2 vout.$616.Metal2 0.0259078f
Cred_5521 vdd.$2785.Metal2 vout.$634.Metal2 0.0174729f
Cred_5522 vdd.$2785.Metal2 vout.$654.Metal2 0.0175366f
Cred_5523 vdd.$2785.Metal2 vout.$656.Metal2 0.0269345f
Cred_5524 vdd.$2785.Metal2 vout.$674.Metal2 0.0184646f
Cred_5525 vdd.$2785.Metal2 vout.$676.Metal2 0.0184912f
Cred_5526 vdd.$2785.Metal2 vout.$694.Metal2 0.0203958f
Cred_5527 vdd.$2785.Metal2 vout.$696.Metal2 0.0197602f
Cred_5528 vdd.$2785.Metal2 vout.$714.Metal2 0.0215912f
Cred_5529 vdd.$2785.Metal2 vout.$716.Metal2 0.0211441f
Cred_5530 vdd.$2785.Metal2 vout.$734.Metal2 0.0337328f
Cred_5531 vdd.$2785.Metal2 vout.$736.Metal2 0.0330383f
Cred_5532 vdd.$2785.Metal2 vout.$774.Metal2 0.0359653f
Cred_5533 vdd.$2785.Metal2 vout.$776.Metal2 0.0352249f
Cred_5534 vdd.$2785.Metal2 vout.$794.Metal2 0.0480661f
Cred_5535 vdd.$2785.Metal2 vout.$796.Metal2 0.0490567f
Cred_5536 vdd.$2785.Metal2 vout.P0.GatPoly 1.22885e-07f
Cred_5537 vdd.$2785.Metal2 vout.P10.pSD 0.000576252f
Cred_5538 vdd.$2785.Metal2 vout.P12.pSD 0.00187262f
Cred_5539 vdd.$2785.Metal2 vss 0.00500209f
Cred_5540 vdd.$2785.Metal2 vss.$1211.Metal5 0.000520594f
Cred_5541 vdd.$2785.Metal2 vss.$1229.Metal5 0.000520594f
Cred_5542 vdd.$2785.Metal2 vss.$1281.Metal5 0.00199273f
Cred_5543 vdd.$2785.Metal2 vss.$1299.Metal5 0.00199273f
Cred_5544 vdd.$2789.Metal2 vout 0.000951748f
Cred_5545 vdd.$2789.Metal2 vout.$1004.Metal3 0.00408948f
Cred_5546 vdd.$2789.Metal2 vout.$1006.Metal3 0.00412834f
Cred_5547 vdd.$2789.Metal2 vout.$1044.Metal3 0.00334224f
Cred_5548 vdd.$2789.Metal2 vout.$1046.Metal3 0.00315807f
Cred_5549 vdd.$2789.Metal2 vout.$1066.Metal3 0.00250483f
Cred_5550 vdd.$2789.Metal2 vout.$1084.Metal3 0.00423647f
Cred_5551 vdd.$2789.Metal2 vout.$1106.Metal3 0.00305174f
Cred_5552 vdd.$2789.Metal2 vout.$1124.Metal3 0.00475927f
Cred_5553 vdd.$2789.Metal2 vout.$1126.Metal3 0.00340699f
Cred_5554 vdd.$2789.Metal2 vout.$1164.Metal3 0.010982f
Cred_5555 vdd.$2789.Metal2 vout.$1166.Metal3 0.0107608f
Cred_5556 vdd.$2789.Metal2 vout.$1299.Metal4 1.14606e-08f
Cred_5557 vdd.$2789.Metal2 vout.$1313.Metal4 0.00202162f
Cred_5558 vdd.$2789.Metal2 vout.$1323.Metal4 0.00427797f
Cred_5559 vdd.$2789.Metal2 vout.$1333.Metal4 0.00198441f
Cred_5560 vdd.$2789.Metal2 vout.$1343.Metal4 0.00440751f
Cred_5561 vdd.$2789.Metal2 vout.$1353.Metal4 0.0020544f
Cred_5562 vdd.$2789.Metal2 vout.$1363.Metal4 0.00211611f
Cred_5563 vdd.$2789.Metal2 vout.$1373.Metal4 0.00644365f
Cred_5564 vdd.$2789.Metal2 vout.$1384.Metal4 0.00420605f
Cred_5565 vdd.$2789.Metal2 vout.$1394.Metal4 0.00938576f
Cred_5566 vdd.$2789.Metal2 vout.$1395.Metal4 0.001299f
Cred_5567 vdd.$2789.Metal2 vout.$1405.Metal4 0.0013253f
Cred_5568 vdd.$2789.Metal2 vout.$1415.Metal4 0.00674949f
Cred_5569 vdd.$2789.Metal2 vout.$162.Metal1 0.0241342f
Cred_5570 vdd.$2789.Metal2 vout.$163.Metal1 0.0232075f
Cred_5571 vdd.$2789.Metal2 vout.$212.Metal1 0.0223625f
Cred_5572 vdd.$2789.Metal2 vout.$213.Metal1 0.0210617f
Cred_5573 vdd.$2789.Metal2 vout.$232.Metal1 0.0170321f
Cred_5574 vdd.$2789.Metal2 vout.$233.Metal1 0.0161726f
Cred_5575 vdd.$2789.Metal2 vout.$272.Metal1 0.0164351f
Cred_5576 vdd.$2789.Metal2 vout.$273.Metal1 0.0170885f
Cred_5577 vdd.$2789.Metal2 vout.$292.Metal1 0.0173244f
Cred_5578 vdd.$2789.Metal2 vout.$293.Metal1 0.0175815f
Cred_5579 vdd.$2789.Metal2 vout.$332.Metal1 0.0179457f
Cred_5580 vdd.$2789.Metal2 vout.$333.Metal1 0.0176084f
Cred_5581 vdd.$2789.Metal2 vout.$352.Metal1 0.0245691f
Cred_5582 vdd.$2789.Metal2 vout.$353.Metal1 0.0241138f
Cred_5583 vdd.$2789.Metal2 vout.$402.Metal1 0.0275791f
Cred_5584 vdd.$2789.Metal2 vout.$403.Metal1 0.0271292f
Cred_5585 vdd.$2789.Metal2 vout.$596.Metal2 0.037521f
Cred_5586 vdd.$2789.Metal2 vout.$598.Metal2 0.0376666f
Cred_5587 vdd.$2789.Metal2 vout.$616.Metal2 0.0314766f
Cred_5588 vdd.$2789.Metal2 vout.$618.Metal2 0.0314663f
Cred_5589 vdd.$2789.Metal2 vout.$656.Metal2 0.031637f
Cred_5590 vdd.$2789.Metal2 vout.$658.Metal2 0.0327069f
Cred_5591 vdd.$2789.Metal2 vout.$676.Metal2 0.022468f
Cred_5592 vdd.$2789.Metal2 vout.$678.Metal2 0.0340256f
Cred_5593 vdd.$2789.Metal2 vout.$696.Metal2 0.0247226f
Cred_5594 vdd.$2789.Metal2 vout.$716.Metal2 0.0262319f
Cred_5595 vdd.$2789.Metal2 vout.$718.Metal2 0.0372319f
Cred_5596 vdd.$2789.Metal2 vout.$736.Metal2 0.0409832f
Cred_5597 vdd.$2789.Metal2 vout.$738.Metal2 0.0401394f
Cred_5598 vdd.$2789.Metal2 vout.$776.Metal2 0.0436963f
Cred_5599 vdd.$2789.Metal2 vout.$778.Metal2 0.0427955f
Cred_5600 vdd.$2789.Metal2 vout.$796.Metal2 0.0606891f
Cred_5601 vdd.$2789.Metal2 vout.$798.Metal2 0.0581311f
Cred_5602 vdd.$2789.Metal2 vout.P0.GatPoly 1.49297e-07f
Cred_5603 vdd.$2789.Metal2 vout.P12.pSD 0.00199631f
Cred_5604 vdd.$2789.Metal2 vout.P14.pSD 0.00129298f
Cred_5605 vdd.$2789.Metal2 vss 0.0065964f
Cred_5606 vdd.$2789.Metal2 vss.$1211.Metal5 0.000666788f
Cred_5607 vdd.$2789.Metal2 vss.$1229.Metal5 0.000666788f
Cred_5608 vdd.$2789.Metal2 vss.$1281.Metal5 0.00255233f
Cred_5609 vdd.$2789.Metal2 vss.$1299.Metal5 0.00255233f
Cred_5610 vdd.$2793.Metal2 vout 0.000429447f
Cred_5611 vdd.$2793.Metal2 vout.$1004.Metal3 0.000499024f
Cred_5612 vdd.$2793.Metal2 vout.$1006.Metal3 0.00185f
Cred_5613 vdd.$2793.Metal2 vout.$1008.Metal3 0.00135902f
Cred_5614 vdd.$2793.Metal2 vout.$1044.Metal3 0.000407841f
Cred_5615 vdd.$2793.Metal2 vout.$1046.Metal3 0.0011566f
Cred_5616 vdd.$2793.Metal2 vout.$1048.Metal3 0.00127769f
Cred_5617 vdd.$2793.Metal2 vout.$1066.Metal3 0.00122208f
Cred_5618 vdd.$2793.Metal2 vout.$1084.Metal3 0.000516961f
Cred_5619 vdd.$2793.Metal2 vout.$1088.Metal3 0.00121842f
Cred_5620 vdd.$2793.Metal2 vout.$1106.Metal3 0.00146244f
Cred_5621 vdd.$2793.Metal2 vout.$1124.Metal3 0.000580756f
Cred_5622 vdd.$2793.Metal2 vout.$1126.Metal3 0.00160822f
Cred_5623 vdd.$2793.Metal2 vout.$1128.Metal3 0.00141054f
Cred_5624 vdd.$2793.Metal2 vout.$1164.Metal3 0.00133561f
Cred_5625 vdd.$2793.Metal2 vout.$1166.Metal3 0.00497735f
Cred_5626 vdd.$2793.Metal2 vout.$1168.Metal3 0.00173006f
Cred_5627 vdd.$2793.Metal2 vout.$1208.Metal3 0.0021975f
Cred_5628 vdd.$2793.Metal2 vout.$1299.Metal4 5.17127e-09f
Cred_5629 vdd.$2793.Metal2 vout.$1313.Metal4 0.000912195f
Cred_5630 vdd.$2793.Metal2 vout.$1323.Metal4 0.00115676f
Cred_5631 vdd.$2793.Metal2 vout.$1333.Metal4 0.000895405f
Cred_5632 vdd.$2793.Metal2 vout.$1343.Metal4 0.00119178f
Cred_5633 vdd.$2793.Metal2 vout.$1353.Metal4 0.000925163f
Cred_5634 vdd.$2793.Metal2 vout.$1363.Metal4 0.000952952f
Cred_5635 vdd.$2793.Metal2 vout.$1373.Metal4 0.00502565f
Cred_5636 vdd.$2793.Metal2 vout.$1384.Metal4 0.0013218f
Cred_5637 vdd.$2793.Metal2 vout.$1394.Metal4 0.00114475f
Cred_5638 vdd.$2793.Metal2 vout.$1395.Metal4 0.00151353f
Cred_5639 vdd.$2793.Metal2 vout.$1405.Metal4 0.00103428f
Cred_5640 vdd.$2793.Metal2 vout.$1415.Metal4 0.00459989f
Cred_5641 vdd.$2793.Metal2 vout.$1416.Metal4 0.000465395f
Cred_5642 vdd.$2793.Metal2 vout.$162.Metal1 0.00294501f
Cred_5643 vdd.$2793.Metal2 vout.$163.Metal1 0.0109836f
Cred_5644 vdd.$2793.Metal2 vout.$164.Metal1 0.00784658f
Cred_5645 vdd.$2793.Metal2 vout.$212.Metal1 0.00272881f
Cred_5646 vdd.$2793.Metal2 vout.$213.Metal1 0.0101893f
Cred_5647 vdd.$2793.Metal2 vout.$214.Metal1 0.00719099f
Cred_5648 vdd.$2793.Metal2 vout.$232.Metal1 0.00207836f
Cred_5649 vdd.$2793.Metal2 vout.$233.Metal1 0.00772802f
Cred_5650 vdd.$2793.Metal2 vout.$234.Metal1 0.00547599f
Cred_5651 vdd.$2793.Metal2 vout.$272.Metal1 0.00200552f
Cred_5652 vdd.$2793.Metal2 vout.$273.Metal1 0.00802558f
Cred_5653 vdd.$2793.Metal2 vout.$274.Metal1 0.00554787f
Cred_5654 vdd.$2793.Metal2 vout.$292.Metal1 0.00211403f
Cred_5655 vdd.$2793.Metal2 vout.$293.Metal1 0.00796664f
Cred_5656 vdd.$2793.Metal2 vout.$294.Metal1 0.00567144f
Cred_5657 vdd.$2793.Metal2 vout.$332.Metal1 0.00218985f
Cred_5658 vdd.$2793.Metal2 vout.$333.Metal1 0.0080563f
Cred_5659 vdd.$2793.Metal2 vout.$334.Metal1 0.00579658f
Cred_5660 vdd.$2793.Metal2 vout.$352.Metal1 0.00299807f
Cred_5661 vdd.$2793.Metal2 vout.$353.Metal1 0.0110305f
Cred_5662 vdd.$2793.Metal2 vout.$354.Metal1 0.00793809f
Cred_5663 vdd.$2793.Metal2 vout.$402.Metal1 0.0033598f
Cred_5664 vdd.$2793.Metal2 vout.$403.Metal1 0.0124514f
Cred_5665 vdd.$2793.Metal2 vout.$404.Metal1 0.0089208f
Cred_5666 vdd.$2793.Metal2 vout.$596.Metal2 0.00457855f
Cred_5667 vdd.$2793.Metal2 vout.$598.Metal2 0.0169493f
Cred_5668 vdd.$2793.Metal2 vout.$600.Metal2 0.0124009f
Cred_5669 vdd.$2793.Metal2 vout.$616.Metal2 0.00384097f
Cred_5670 vdd.$2793.Metal2 vout.$618.Metal2 0.0142049f
Cred_5671 vdd.$2793.Metal2 vout.$620.Metal2 0.0103618f
Cred_5672 vdd.$2793.Metal2 vout.$656.Metal2 0.00386054f
Cred_5673 vdd.$2793.Metal2 vout.$658.Metal2 0.0143999f
Cred_5674 vdd.$2793.Metal2 vout.$660.Metal2 0.0107724f
Cred_5675 vdd.$2793.Metal2 vout.$676.Metal2 0.00274169f
Cred_5676 vdd.$2793.Metal2 vout.$678.Metal2 0.015612f
Cred_5677 vdd.$2793.Metal2 vout.$680.Metal2 0.00739553f
Cred_5678 vdd.$2793.Metal2 vout.$696.Metal2 0.00301681f
Cred_5679 vdd.$2793.Metal2 vout.$700.Metal2 0.00790223f
Cred_5680 vdd.$2793.Metal2 vout.$716.Metal2 0.00320098f
Cred_5681 vdd.$2793.Metal2 vout.$718.Metal2 0.0172362f
Cred_5682 vdd.$2793.Metal2 vout.$720.Metal2 0.00845657f
Cred_5683 vdd.$2793.Metal2 vout.$736.Metal2 0.00500103f
Cred_5684 vdd.$2793.Metal2 vout.$738.Metal2 0.0183895f
Cred_5685 vdd.$2793.Metal2 vout.$740.Metal2 0.0132136f
Cred_5686 vdd.$2793.Metal2 vout.$776.Metal2 0.00533201f
Cred_5687 vdd.$2793.Metal2 vout.$778.Metal2 0.0196077f
Cred_5688 vdd.$2793.Metal2 vout.$780.Metal2 0.0140517f
Cred_5689 vdd.$2793.Metal2 vout.$796.Metal2 0.007126f
Cred_5690 vdd.$2793.Metal2 vout.$798.Metal2 0.0294468f
Cred_5691 vdd.$2793.Metal2 vout.$800.Metal2 0.0185618f
Cred_5692 vdd.$2793.Metal2 vout.P0.GatPoly 6.73659e-08f
Cred_5693 vdd.$2793.Metal2 vout.P12.pSD 7.78474e-05f
Cred_5694 vdd.$2793.Metal2 vout.P14.pSD 0.00235004f
Cred_5695 vdd.$2793.Metal2 vout.P16.pSD 0.000205681f
Cred_5696 vdd.$2793.Metal2 vss 0.00474877f
Cred_5697 vdd.$2793.Metal2 vss.$1211.Metal5 0.000417957f
Cred_5698 vdd.$2793.Metal2 vss.$1229.Metal5 0.000417957f
Cred_5699 vdd.$2793.Metal2 vss.$1281.Metal5 0.00159986f
Cred_5700 vdd.$2793.Metal2 vss.$1299.Metal5 0.00159986f
Cred_5701 vdd.$2795.Metal2 vout 0.000757164f
Cred_5702 vdd.$2795.Metal2 vout.$1006.Metal3 0.00325339f
Cred_5703 vdd.$2795.Metal2 vout.$1008.Metal3 0.0032843f
Cred_5704 vdd.$2795.Metal2 vout.$1046.Metal3 0.00186382f
Cred_5705 vdd.$2795.Metal2 vout.$1048.Metal3 0.00308775f
Cred_5706 vdd.$2795.Metal2 vout.$1066.Metal3 0.0022147f
Cred_5707 vdd.$2795.Metal2 vout.$1088.Metal3 0.00294452f
Cred_5708 vdd.$2795.Metal2 vout.$1106.Metal3 0.00263428f
Cred_5709 vdd.$2795.Metal2 vout.$1126.Metal3 0.00288181f
Cred_5710 vdd.$2795.Metal2 vout.$1128.Metal3 0.00340881f
Cred_5711 vdd.$2795.Metal2 vout.$1166.Metal3 0.00870751f
Cred_5712 vdd.$2795.Metal2 vout.$1168.Metal3 0.00418097f
Cred_5713 vdd.$2795.Metal2 vout.$1208.Metal3 0.00535475f
Cred_5714 vdd.$2795.Metal2 vout.$1299.Metal4 9.11752e-09f
Cred_5715 vdd.$2795.Metal2 vout.$1313.Metal4 0.0016083f
Cred_5716 vdd.$2795.Metal2 vout.$1323.Metal4 0.00153394f
Cred_5717 vdd.$2795.Metal2 vout.$1333.Metal4 0.0015787f
Cred_5718 vdd.$2795.Metal2 vout.$1343.Metal4 0.00158038f
Cred_5719 vdd.$2795.Metal2 vout.$1353.Metal4 0.00162997f
Cred_5720 vdd.$2795.Metal2 vout.$1363.Metal4 0.00167893f
Cred_5721 vdd.$2795.Metal2 vout.$1373.Metal4 0.00505662f
Cred_5722 vdd.$2795.Metal2 vout.$1384.Metal4 0.001954f
Cred_5723 vdd.$2795.Metal2 vout.$1395.Metal4 0.00327462f
Cred_5724 vdd.$2795.Metal2 vout.$1405.Metal4 0.00210869f
Cred_5725 vdd.$2795.Metal2 vout.$1415.Metal4 0.00910849f
Cred_5726 vdd.$2795.Metal2 vout.$1416.Metal4 0.0011247f
Cred_5727 vdd.$2795.Metal2 vout.$163.Metal1 0.0196999f
Cred_5728 vdd.$2795.Metal2 vout.$164.Metal1 0.0189626f
Cred_5729 vdd.$2795.Metal2 vout.$213.Metal1 0.0184131f
Cred_5730 vdd.$2795.Metal2 vout.$214.Metal1 0.0173782f
Cred_5731 vdd.$2795.Metal2 vout.$233.Metal1 0.0139068f
Cred_5732 vdd.$2795.Metal2 vout.$234.Metal1 0.0132336f
Cred_5733 vdd.$2795.Metal2 vout.$273.Metal1 0.0143558f
Cred_5734 vdd.$2795.Metal2 vout.$274.Metal1 0.0134074f
Cred_5735 vdd.$2795.Metal2 vout.$293.Metal1 0.014068f
Cred_5736 vdd.$2795.Metal2 vout.$294.Metal1 0.013706f
Cred_5737 vdd.$2795.Metal2 vout.$333.Metal1 0.0142767f
Cred_5738 vdd.$2795.Metal2 vout.$334.Metal1 0.0140084f
Cred_5739 vdd.$2795.Metal2 vout.$353.Metal1 0.0195459f
Cred_5740 vdd.$2795.Metal2 vout.$354.Metal1 0.0191837f
Cred_5741 vdd.$2795.Metal2 vout.$403.Metal1 0.0219116f
Cred_5742 vdd.$2795.Metal2 vout.$404.Metal1 0.0216042f
Cred_5743 vdd.$2795.Metal2 vout.$598.Metal2 0.0298531f
Cred_5744 vdd.$2795.Metal2 vout.$600.Metal2 0.0299689f
Cred_5745 vdd.$2795.Metal2 vout.$618.Metal2 0.0250492f
Cred_5746 vdd.$2795.Metal2 vout.$620.Metal2 0.025041f
Cred_5747 vdd.$2795.Metal2 vout.$658.Metal2 0.0251547f
Cred_5748 vdd.$2795.Metal2 vout.$660.Metal2 0.0260334f
Cred_5749 vdd.$2795.Metal2 vout.$678.Metal2 0.027695f
Cred_5750 vdd.$2795.Metal2 vout.$680.Metal2 0.0178725f
Cred_5751 vdd.$2795.Metal2 vout.$700.Metal2 0.0190971f
Cred_5752 vdd.$2795.Metal2 vout.$718.Metal2 0.0306746f
Cred_5753 vdd.$2795.Metal2 vout.$720.Metal2 0.0204367f
Cred_5754 vdd.$2795.Metal2 vout.$738.Metal2 0.0326042f
Cred_5755 vdd.$2795.Metal2 vout.$740.Metal2 0.0319329f
Cred_5756 vdd.$2795.Metal2 vout.$778.Metal2 0.0347621f
Cred_5757 vdd.$2795.Metal2 vout.$780.Metal2 0.0339582f
Cred_5758 vdd.$2795.Metal2 vout.$798.Metal2 0.0464581f
Cred_5759 vdd.$2795.Metal2 vout.$800.Metal2 0.0471465f
Cred_5760 vdd.$2795.Metal2 vout.P0.GatPoly 1.18774e-07f
Cred_5761 vdd.$2795.Metal2 vout.P14.pSD 0.000514947f
Cred_5762 vdd.$2795.Metal2 vout.P16.pSD 0.00181296f
Cred_5763 vdd.$2795.Metal2 vss 0.00499395f
Cred_5764 vdd.$2795.Metal2 vss.$1211.Metal5 0.000513695f
Cred_5765 vdd.$2795.Metal2 vss.$1229.Metal5 0.000513695f
Cred_5766 vdd.$2795.Metal2 vss.$1281.Metal5 0.00196632f
Cred_5767 vdd.$2795.Metal2 vss.$1299.Metal5 0.00196632f
Cred_5768 vdd.$2799.Metal2 vout 0.000965178f
Cred_5769 vdd.$2799.Metal2 vout.$1008.Metal3 0.00414718f
Cred_5770 vdd.$2799.Metal2 vout.$1010.Metal3 0.00500818f
Cred_5771 vdd.$2799.Metal2 vout.$1048.Metal3 0.0033894f
Cred_5772 vdd.$2799.Metal2 vout.$1050.Metal3 0.00421479f
Cred_5773 vdd.$2799.Metal2 vout.$1070.Metal3 0.00289343f
Cred_5774 vdd.$2799.Metal2 vout.$1088.Metal3 0.00370757f
Cred_5775 vdd.$2799.Metal2 vout.$1110.Metal3 0.00450206f
Cred_5776 vdd.$2799.Metal2 vout.$1128.Metal3 0.00482643f
Cred_5777 vdd.$2799.Metal2 vout.$1150.Metal3 0.00556984f
Cred_5778 vdd.$2799.Metal2 vout.$1168.Metal3 0.00534344f
Cred_5779 vdd.$2799.Metal2 vout.$1190.Metal3 0.00976809f
Cred_5780 vdd.$2799.Metal2 vout.$1208.Metal3 0.00704717f
Cred_5781 vdd.$2799.Metal2 vout.$1299.Metal4 1.16224e-08f
Cred_5782 vdd.$2799.Metal2 vout.$1313.Metal4 0.00206002f
Cred_5783 vdd.$2799.Metal2 vout.$1323.Metal4 0.00195535f
Cred_5784 vdd.$2799.Metal2 vout.$1333.Metal4 0.0049851f
Cred_5785 vdd.$2799.Metal2 vout.$1343.Metal4 0.00201456f
Cred_5786 vdd.$2799.Metal2 vout.$1353.Metal4 0.00208339f
Cred_5787 vdd.$2799.Metal2 vout.$1363.Metal4 0.00215305f
Cred_5788 vdd.$2799.Metal2 vout.$1373.Metal4 0.00633739f
Cred_5789 vdd.$2799.Metal2 vout.$1384.Metal4 0.00251186f
Cred_5790 vdd.$2799.Metal2 vout.$1395.Metal4 0.00260381f
Cred_5791 vdd.$2799.Metal2 vout.$1405.Metal4 0.00431821f
Cred_5792 vdd.$2799.Metal2 vout.$1415.Metal4 0.00475394f
Cred_5793 vdd.$2799.Metal2 vout.$1416.Metal4 0.0101671f
Cred_5794 vdd.$2799.Metal2 vout.$164.Metal1 0.0244748f
Cred_5795 vdd.$2799.Metal2 vout.$165.Metal1 0.0241723f
Cred_5796 vdd.$2799.Metal2 vout.$214.Metal1 0.022678f
Cred_5797 vdd.$2799.Metal2 vout.$215.Metal1 0.0221525f
Cred_5798 vdd.$2799.Metal2 vout.$234.Metal1 0.0172589f
Cred_5799 vdd.$2799.Metal2 vout.$235.Metal1 0.0168693f
Cred_5800 vdd.$2799.Metal2 vout.$274.Metal1 0.0174693f
Cred_5801 vdd.$2799.Metal2 vout.$275.Metal1 0.0172112f
Cred_5802 vdd.$2799.Metal2 vout.$294.Metal1 0.0178099f
Cred_5803 vdd.$2799.Metal2 vout.$295.Metal1 0.0175886f
Cred_5804 vdd.$2799.Metal2 vout.$334.Metal1 0.0181989f
Cred_5805 vdd.$2799.Metal2 vout.$335.Metal1 0.0178268f
Cred_5806 vdd.$2799.Metal2 vout.$354.Metal1 0.0249157f
Cred_5807 vdd.$2799.Metal2 vout.$355.Metal1 0.0242095f
Cred_5808 vdd.$2799.Metal2 vout.$404.Metal1 0.0279632f
Cred_5809 vdd.$2799.Metal2 vout.$405.Metal1 0.0275116f
Cred_5810 vdd.$2799.Metal2 vout.$600.Metal2 0.0380505f
Cred_5811 vdd.$2799.Metal2 vout.$602.Metal2 0.0382117f
Cred_5812 vdd.$2799.Metal2 vout.$620.Metal2 0.0319208f
Cred_5813 vdd.$2799.Metal2 vout.$622.Metal2 0.0319271f
Cred_5814 vdd.$2799.Metal2 vout.$660.Metal2 0.0320834f
Cred_5815 vdd.$2799.Metal2 vout.$662.Metal2 0.0331707f
Cred_5816 vdd.$2799.Metal2 vout.$680.Metal2 0.0227849f
Cred_5817 vdd.$2799.Metal2 vout.$682.Metal2 0.0347351f
Cred_5818 vdd.$2799.Metal2 vout.$700.Metal2 0.0250741f
Cred_5819 vdd.$2799.Metal2 vout.$720.Metal2 0.026602f
Cred_5820 vdd.$2799.Metal2 vout.$722.Metal2 0.0379968f
Cred_5821 vdd.$2799.Metal2 vout.$740.Metal2 0.0415615f
Cred_5822 vdd.$2799.Metal2 vout.$742.Metal2 0.0269477f
Cred_5823 vdd.$2799.Metal2 vout.$762.Metal2 0.0280362f
Cred_5824 vdd.$2799.Metal2 vout.$780.Metal2 0.0441968f
Cred_5825 vdd.$2799.Metal2 vout.$782.Metal2 0.029527f
Cred_5826 vdd.$2799.Metal2 vout.$800.Metal2 0.0610581f
Cred_5827 vdd.$2799.Metal2 vout.$802.Metal2 0.0587997f
Cred_5828 vdd.$2799.Metal2 vout.P0.GatPoly 1.51404e-07f
Cred_5829 vdd.$2799.Metal2 vout.P16.pSD 0.00196277f
Cred_5830 vdd.$2799.Metal2 vout.P18.pSD 0.00131137f
Cred_5831 vdd.$2799.Metal2 vss 0.00667454f
Cred_5832 vdd.$2799.Metal2 vss.$1211.Metal5 0.000695204f
Cred_5833 vdd.$2799.Metal2 vss.$1229.Metal5 0.000695204f
Cred_5834 vdd.$2799.Metal2 vss.$1281.Metal5 0.0026611f
Cred_5835 vdd.$2799.Metal2 vss.$1299.Metal5 0.0026611f
Cred_5836 vdd.$2803.Metal2 vout 0.000103258f
Cred_5837 vdd.$2803.Metal2 vout.$1008.Metal3 0.000443679f
Cred_5838 vdd.$2803.Metal2 vout.$1010.Metal3 0.00222906f
Cred_5839 vdd.$2803.Metal2 vout.$1048.Metal3 0.000362608f
Cred_5840 vdd.$2803.Metal2 vout.$1050.Metal3 0.00128538f
Cred_5841 vdd.$2803.Metal2 vout.$1070.Metal3 0.00154824f
Cred_5842 vdd.$2803.Metal2 vout.$1088.Metal3 0.000396647f
Cred_5843 vdd.$2803.Metal2 vout.$1110.Metal3 0.00246871f
Cred_5844 vdd.$2803.Metal2 vout.$1128.Metal3 0.000516346f
Cred_5845 vdd.$2803.Metal2 vout.$1150.Metal3 0.00254746f
Cred_5846 vdd.$2803.Metal2 vout.$1168.Metal3 0.000571657f
Cred_5847 vdd.$2803.Metal2 vout.$1190.Metal3 0.00467387f
Cred_5848 vdd.$2803.Metal2 vout.$1208.Metal3 0.000749207f
Cred_5849 vdd.$2803.Metal2 vout.$1299.Metal4 1.2434e-09f
Cred_5850 vdd.$2803.Metal2 vout.$1313.Metal4 0.000230884f
Cred_5851 vdd.$2803.Metal2 vout.$1323.Metal4 0.000391656f
Cred_5852 vdd.$2803.Metal2 vout.$1333.Metal4 0.000722936f
Cred_5853 vdd.$2803.Metal2 vout.$1343.Metal4 0.000403515f
Cred_5854 vdd.$2803.Metal2 vout.$1353.Metal4 0.000415406f
Cred_5855 vdd.$2803.Metal2 vout.$1363.Metal4 0.000433966f
Cred_5856 vdd.$2803.Metal2 vout.$1373.Metal4 0.00171298f
Cred_5857 vdd.$2803.Metal2 vout.$1384.Metal4 0.000555511f
Cred_5858 vdd.$2803.Metal2 vout.$1395.Metal4 0.000564144f
Cred_5859 vdd.$2803.Metal2 vout.$1405.Metal4 0.000771463f
Cred_5860 vdd.$2803.Metal2 vout.$1415.Metal4 0.000508498f
Cred_5861 vdd.$2803.Metal2 vout.$1416.Metal4 0.00211669f
Cred_5862 vdd.$2803.Metal2 vout.$164.Metal1 0.00261839f
Cred_5863 vdd.$2803.Metal2 vout.$165.Metal1 0.0108533f
Cred_5864 vdd.$2803.Metal2 vout.$214.Metal1 0.00242616f
Cred_5865 vdd.$2803.Metal2 vout.$215.Metal1 0.00992164f
Cred_5866 vdd.$2803.Metal2 vout.$234.Metal1 0.00184641f
Cred_5867 vdd.$2803.Metal2 vout.$235.Metal1 0.00754985f
Cred_5868 vdd.$2803.Metal2 vout.$274.Metal1 0.00186892f
Cred_5869 vdd.$2803.Metal2 vout.$275.Metal1 0.00770007f
Cred_5870 vdd.$2803.Metal2 vout.$294.Metal1 0.00190536f
Cred_5871 vdd.$2803.Metal2 vout.$295.Metal1 0.00786882f
Cred_5872 vdd.$2803.Metal2 vout.$334.Metal1 0.00194698f
Cred_5873 vdd.$2803.Metal2 vout.$335.Metal1 0.00797424f
Cred_5874 vdd.$2803.Metal2 vout.$354.Metal1 0.00266556f
Cred_5875 vdd.$2803.Metal2 vout.$355.Metal1 0.0108293f
Cred_5876 vdd.$2803.Metal2 vout.$404.Metal1 0.00298672f
Cred_5877 vdd.$2803.Metal2 vout.$405.Metal1 0.0124143f
Cred_5878 vdd.$2803.Metal2 vout.$600.Metal2 0.00407076f
Cred_5879 vdd.$2803.Metal2 vout.$602.Metal2 0.0174671f
Cred_5880 vdd.$2803.Metal2 vout.$620.Metal2 0.00341498f
Cred_5881 vdd.$2803.Metal2 vout.$622.Metal2 0.0144951f
Cred_5882 vdd.$2803.Metal2 vout.$660.Metal2 0.00343238f
Cred_5883 vdd.$2803.Metal2 vout.$662.Metal2 0.0148727f
Cred_5884 vdd.$2803.Metal2 vout.$680.Metal2 0.0024376f
Cred_5885 vdd.$2803.Metal2 vout.$682.Metal2 0.0158056f
Cred_5886 vdd.$2803.Metal2 vout.$700.Metal2 0.0026825f
Cred_5887 vdd.$2803.Metal2 vout.$720.Metal2 0.00284597f
Cred_5888 vdd.$2803.Metal2 vout.$722.Metal2 0.0174422f
Cred_5889 vdd.$2803.Metal2 vout.$740.Metal2 0.00444638f
Cred_5890 vdd.$2803.Metal2 vout.$742.Metal2 0.012391f
Cred_5891 vdd.$2803.Metal2 vout.$762.Metal2 0.0128962f
Cred_5892 vdd.$2803.Metal2 vout.$780.Metal2 0.00472831f
Cred_5893 vdd.$2803.Metal2 vout.$782.Metal2 0.0135745f
Cred_5894 vdd.$2803.Metal2 vout.$800.Metal2 0.0062873f
Cred_5895 vdd.$2803.Metal2 vout.$802.Metal2 0.0297763f
Cred_5896 vdd.$2803.Metal2 vout.P0.GatPoly 1.61977e-08f
Cred_5897 vdd.$2803.Metal2 vout.P16.pSD 6.92041e-05f
Cred_5898 vdd.$2803.Metal2 vout.P18.pSD 0.00234546f
Cred_5899 vdd.$2803.Metal2 vss 0.00682972f
Cred_5900 vdd.$2803.Metal2 vss.$1211.Metal5 0.00117726f
Cred_5901 vdd.$2803.Metal2 vss.$1229.Metal5 0.00117726f
Cred_5902 vdd.$2803.Metal2 vss.$1281.Metal5 0.00450632f
Cred_5903 vdd.$2803.Metal2 vss.$1299.Metal5 0.00450632f
Cred_5904 vdd.$2805.Metal2 vout.$1010.Metal3 0.0037906f
Cred_5905 vdd.$2805.Metal2 vout.$1050.Metal3 0.00189237f
Cred_5906 vdd.$2805.Metal2 vout.$1070.Metal3 0.00276264f
Cred_5907 vdd.$2805.Metal2 vout.$1110.Metal3 0.00443722f
Cred_5908 vdd.$2805.Metal2 vout.$1150.Metal3 0.00438898f
Cred_5909 vdd.$2805.Metal2 vout.$1190.Metal3 0.00802043f
Cred_5910 vdd.$2805.Metal2 vout.$1313.Metal4 0.000256735f
Cred_5911 vdd.$2805.Metal2 vout.$1323.Metal4 0.000393005f
Cred_5912 vdd.$2805.Metal2 vout.$1333.Metal4 0.000408994f
Cred_5913 vdd.$2805.Metal2 vout.$1343.Metal4 0.000404905f
Cred_5914 vdd.$2805.Metal2 vout.$1353.Metal4 0.000414656f
Cred_5915 vdd.$2805.Metal2 vout.$1363.Metal4 0.000439215f
Cred_5916 vdd.$2805.Metal2 vout.$1373.Metal4 0.000556613f
Cred_5917 vdd.$2805.Metal2 vout.$1384.Metal4 0.000674477f
Cred_5918 vdd.$2805.Metal2 vout.$1395.Metal4 0.000673042f
Cred_5919 vdd.$2805.Metal2 vout.$1405.Metal4 0.000727873f
Cred_5920 vdd.$2805.Metal2 vout.$1416.Metal4 0.00240497f
Cred_5921 vdd.$2805.Metal2 vout.$165.Metal1 0.0178124f
Cred_5922 vdd.$2805.Metal2 vout.$215.Metal1 0.0162688f
Cred_5923 vdd.$2805.Metal2 vout.$235.Metal1 0.0123745f
Cred_5924 vdd.$2805.Metal2 vout.$275.Metal1 0.0126209f
Cred_5925 vdd.$2805.Metal2 vout.$295.Metal1 0.0128974f
Cred_5926 vdd.$2805.Metal2 vout.$335.Metal1 0.0130675f
Cred_5927 vdd.$2805.Metal2 vout.$355.Metal1 0.0177463f
Cred_5928 vdd.$2805.Metal2 vout.$405.Metal1 0.0202569f
Cred_5929 vdd.$2805.Metal2 vout.$602.Metal2 0.0295111f
Cred_5930 vdd.$2805.Metal2 vout.$622.Metal2 0.0244685f
Cred_5931 vdd.$2805.Metal2 vout.$662.Metal2 0.0250118f
Cred_5932 vdd.$2805.Metal2 vout.$682.Metal2 0.0266757f
Cred_5933 vdd.$2805.Metal2 vout.$722.Metal2 0.0294507f
Cred_5934 vdd.$2805.Metal2 vout.$742.Metal2 0.0209292f
Cred_5935 vdd.$2805.Metal2 vout.$762.Metal2 0.0217859f
Cred_5936 vdd.$2805.Metal2 vout.$782.Metal2 0.0229237f
Cred_5937 vdd.$2805.Metal2 vout.$802.Metal2 0.0450547f
Cred_5938 vdd.$2805.Metal2 vout.P18.pSD 0.000464724f
Cred_5939 vdd.$2805.Metal2 vss 0.00848069f
Cred_5940 vdd.$2805.Metal2 vss.$1211.Metal5 0.00221615f
Cred_5941 vdd.$2805.Metal2 vss.$1229.Metal5 0.00221615f
Cred_5942 vdd.$2805.Metal2 vss.$1281.Metal5 0.00848298f
Cred_5943 vdd.$2805.Metal2 vss.$1299.Metal5 0.00848298f
Cred_5944 vdd.$2807.Metal2 vout.$1010.Metal3 0.00181843f
Cred_5945 vdd.$2807.Metal2 vout.$1050.Metal3 0.00120392f
Cred_5946 vdd.$2807.Metal2 vout.$1070.Metal3 0.00119925f
Cred_5947 vdd.$2807.Metal2 vout.$1110.Metal3 0.0019935f
Cred_5948 vdd.$2807.Metal2 vout.$1150.Metal3 0.00235071f
Cred_5949 vdd.$2807.Metal2 vout.$1190.Metal3 0.00435418f
Cred_5950 vdd.$2807.Metal2 vout.$1313.Metal4 0.00296561f
Cred_5951 vdd.$2807.Metal2 vout.$1333.Metal4 7.50999e-06f
Cred_5952 vdd.$2807.Metal2 vout.$1363.Metal4 8.06491e-06f
Cred_5953 vdd.$2807.Metal2 vout.$1373.Metal4 0.000606958f
Cred_5954 vdd.$2807.Metal2 vout.$1384.Metal4 0.0007193f
Cred_5955 vdd.$2807.Metal2 vout.$1395.Metal4 0.000733986f
Cred_5956 vdd.$2807.Metal2 vout.$1405.Metal4 0.000776245f
Cred_5957 vdd.$2807.Metal2 vout.$1416.Metal4 0.00249657f
Cred_5958 vdd.$2807.Metal2 vout.$165.Metal1 7.46774e-05f
Cred_5959 vdd.$2807.Metal2 vout.$215.Metal1 4.6112e-05f
Cred_5960 vdd.$2807.Metal2 vout.$235.Metal1 4.89067e-06f
Cred_5961 vdd.$2807.Metal2 vout.$275.Metal1 2.59734e-05f
Cred_5962 vdd.$2807.Metal2 vout.$295.Metal1 2.52714e-05f
Cred_5963 vdd.$2807.Metal2 vout.$405.Metal1 0.000113671f
Cred_5964 vdd.$2807.Metal2 vout.$602.Metal2 0.00879703f
Cred_5965 vdd.$2807.Metal2 vout.$622.Metal2 0.00766486f
Cred_5966 vdd.$2807.Metal2 vout.$662.Metal2 0.00787483f
Cred_5967 vdd.$2807.Metal2 vout.$682.Metal2 0.00806383f
Cred_5968 vdd.$2807.Metal2 vout.$722.Metal2 0.00808355f
Cred_5969 vdd.$2807.Metal2 vout.$742.Metal2 0.00570361f
Cred_5970 vdd.$2807.Metal2 vout.$762.Metal2 0.0059499f
Cred_5971 vdd.$2807.Metal2 vout.$782.Metal2 0.0062074f
Cred_5972 vdd.$2807.Metal2 vout.$802.Metal2 0.0122723f
Cred_5973 vdd.$2807.Metal2 vss 0.0202641f
Cred_5974 vdd.$2807.Metal2 vss.$1211.Metal5 0.0065174f
Cred_5975 vdd.$2807.Metal2 vss.$1229.Metal5 0.0065174f
Cred_5976 vdd.$2807.Metal2 vss.$1281.Metal5 0.0249473f
Cred_5977 vdd.$2807.Metal2 vss.$1299.Metal5 0.0249473f
Cred_5978 vdd.$2809.Metal2 vss 0.00848082f
Cred_5979 vdd.$2809.Metal2 vss.$1211.Metal5 0.00120017f
Cred_5980 vdd.$2809.Metal2 vss.$1229.Metal5 0.00120017f
Cred_5981 vdd.$2809.Metal2 vss.$1281.Metal5 0.004594f
Cred_5982 vdd.$2809.Metal2 vss.$1299.Metal5 0.004594f
Cred_5983 vdd.$2979.Metal3 vss 0.0135682f
Cred_5984 vdd.$2979.Metal3 vss.$1211.Metal5 0.00176508f
Cred_5985 vdd.$2979.Metal3 vss.$1229.Metal5 0.00176508f
Cred_5986 vdd.$2979.Metal3 vss.$1281.Metal5 0.00675635f
Cred_5987 vdd.$2979.Metal3 vss.$1299.Metal5 0.00675635f
Cred_5988 vdd.$2983.Metal3 vout.$1152.Metal3 0.000820096f
Cred_5989 vdd.$2983.Metal3 vout.$1408.Metal4 0.000101952f
Cred_5990 vdd.$2983.Metal3 vout.$396.Metal1 9.95454e-07f
Cred_5991 vdd.$2983.Metal3 vout.$764.Metal2 1.64384e-05f
Cred_5992 vdd.$2983.Metal3 vout.$784.Metal2 8.3516e-05f
Cred_5993 vdd.$2983.Metal3 vout.P0.pSD 0.00135069f
Cred_5994 vdd.$2983.Metal3 vss 0.0132811f
Cred_5995 vdd.$2983.Metal3 vss.$1211.Metal5 0.000938533f
Cred_5996 vdd.$2983.Metal3 vss.$1229.Metal5 0.000938533f
Cred_5997 vdd.$2983.Metal3 vss.$1281.Metal5 0.00359251f
Cred_5998 vdd.$2983.Metal3 vss.$1299.Metal5 0.00359251f
Cred_5999 vdd.$2987.Metal3 vout.$1032.Metal3 8.49086e-06f
Cred_6000 vdd.$2987.Metal3 vout.$1034.Metal3 9.68087e-06f
Cred_6001 vdd.$2987.Metal3 vout.$1072.Metal3 5.69854e-06f
Cred_6002 vdd.$2987.Metal3 vout.$1074.Metal3 4.34266e-06f
Cred_6003 vdd.$2987.Metal3 vout.$1112.Metal3 1.34143e-05f
Cred_6004 vdd.$2987.Metal3 vout.$1114.Metal3 5.79824e-06f
Cred_6005 vdd.$2987.Metal3 vout.$1152.Metal3 0.00488792f
Cred_6006 vdd.$2987.Metal3 vout.$1154.Metal3 1.37385e-05f
Cred_6007 vdd.$2987.Metal3 vout.$1328.Metal4 3.05957e-06f
Cred_6008 vdd.$2987.Metal3 vout.$1329.Metal4 2.80578e-06f
Cred_6009 vdd.$2987.Metal3 vout.$1368.Metal4 0.000154826f
Cred_6010 vdd.$2987.Metal3 vout.$1369.Metal4 0.00102748f
Cred_6011 vdd.$2987.Metal3 vout.$1408.Metal4 0.00256768f
Cred_6012 vdd.$2987.Metal3 vout.$156.Metal1 3.05189e-05f
Cred_6013 vdd.$2987.Metal3 vout.$157.Metal1 3.04946e-05f
Cred_6014 vdd.$2987.Metal3 vout.$206.Metal1 2.79835e-05f
Cred_6015 vdd.$2987.Metal3 vout.$207.Metal1 2.79436e-05f
Cred_6016 vdd.$2987.Metal3 vout.$226.Metal1 2.08893e-05f
Cred_6017 vdd.$2987.Metal3 vout.$227.Metal1 2.16828e-05f
Cred_6018 vdd.$2987.Metal3 vout.$266.Metal1 2.1801e-05f
Cred_6019 vdd.$2987.Metal3 vout.$267.Metal1 2.18743e-05f
Cred_6020 vdd.$2987.Metal3 vout.$286.Metal1 2.21617e-05f
Cred_6021 vdd.$2987.Metal3 vout.$287.Metal1 2.22975e-05f
Cred_6022 vdd.$2987.Metal3 vout.$326.Metal1 2.29565e-05f
Cred_6023 vdd.$2987.Metal3 vout.$327.Metal1 2.25251e-05f
Cred_6024 vdd.$2987.Metal3 vout.$346.Metal1 3.14292e-05f
Cred_6025 vdd.$2987.Metal3 vout.$347.Metal1 3.08468e-05f
Cred_6026 vdd.$2987.Metal3 vout.$396.Metal1 4.14524e-05f
Cred_6027 vdd.$2987.Metal3 vout.$397.Metal1 3.46708e-05f
Cred_6028 vdd.$2987.Metal3 vout.$584.Metal2 4.94024e-05f
Cred_6029 vdd.$2987.Metal3 vout.$586.Metal2 4.85505e-05f
Cred_6030 vdd.$2987.Metal3 vout.$604.Metal2 4.03495e-05f
Cred_6031 vdd.$2987.Metal3 vout.$606.Metal2 4.03591e-05f
Cred_6032 vdd.$2987.Metal3 vout.$644.Metal2 4.04606e-05f
Cred_6033 vdd.$2987.Metal3 vout.$646.Metal2 4.1863e-05f
Cred_6034 vdd.$2987.Metal3 vout.$664.Metal2 2.9453e-05f
Cred_6035 vdd.$2987.Metal3 vout.$666.Metal2 2.80241e-05f
Cred_6036 vdd.$2987.Metal3 vout.$684.Metal2 3.10358e-05f
Cred_6037 vdd.$2987.Metal3 vout.$686.Metal2 3.07121e-05f
Cred_6038 vdd.$2987.Metal3 vout.$704.Metal2 3.35564e-05f
Cred_6039 vdd.$2987.Metal3 vout.$706.Metal2 3.28616e-05f
Cred_6040 vdd.$2987.Metal3 vout.$724.Metal2 5.24975e-05f
Cred_6041 vdd.$2987.Metal3 vout.$726.Metal2 5.13472e-05f
Cred_6042 vdd.$2987.Metal3 vout.$764.Metal2 0.000153254f
Cred_6043 vdd.$2987.Metal3 vout.$766.Metal2 5.47443e-05f
Cred_6044 vdd.$2987.Metal3 vout.$784.Metal2 0.000586175f
Cred_6045 vdd.$2987.Metal3 vout.$786.Metal2 7.26806e-05f
Cred_6046 vdd.$2987.Metal3 vout.P0.pSD 0.00282266f
Cred_6047 vdd.$2987.Metal3 vout.P2.pSD 7.99816e-07f
Cred_6048 vdd.$2987.Metal3 vss 0.00884398f
Cred_6049 vdd.$2987.Metal3 vss.$1211.Metal5 0.000623559f
Cred_6050 vdd.$2987.Metal3 vss.$1229.Metal5 0.000623559f
Cred_6051 vdd.$2987.Metal3 vss.$1281.Metal5 0.00238686f
Cred_6052 vdd.$2987.Metal3 vss.$1299.Metal5 0.00238686f
Cred_6053 vdd.$2991.Metal3 vout.$1154.Metal3 0.00497165f
Cred_6054 vdd.$2991.Metal3 vout.$1369.Metal4 0.00304842f
Cred_6055 vdd.$2991.Metal3 vout.$397.Metal1 6.57204e-06f
Cred_6056 vdd.$2991.Metal3 vout.$766.Metal2 9.96539e-05f
Cred_6057 vdd.$2991.Metal3 vout.$786.Metal2 0.000533275f
Cred_6058 vdd.$2991.Metal3 vout.P2.pSD 0.00347646f
Cred_6059 vdd.$2991.Metal3 vss 0.00585129f
Cred_6060 vdd.$2991.Metal3 vss.$1211.Metal5 0.00042512f
Cred_6061 vdd.$2991.Metal3 vss.$1229.Metal5 0.00042512f
Cred_6062 vdd.$2991.Metal3 vss.$1281.Metal5 0.00162727f
Cred_6063 vdd.$2991.Metal3 vss.$1299.Metal5 0.00162727f
Cred_6064 vdd.$2993.Metal3 vout.$1156.Metal3 0.000929444f
Cred_6065 vdd.$2993.Metal3 vout.$1369.Metal4 0.00239774f
Cred_6066 vdd.$2993.Metal3 vout.$1370.Metal4 0.00125039f
Cred_6067 vdd.$2993.Metal3 vout.$398.Metal1 1.12818e-06f
Cred_6068 vdd.$2993.Metal3 vout.$768.Metal2 1.86302e-05f
Cred_6069 vdd.$2993.Metal3 vout.$788.Metal2 9.46516e-05f
Cred_6070 vdd.$2993.Metal3 vout.P4.pSD 0.000917744f
Cred_6071 vdd.$2993.Metal3 vss 0.00603235f
Cred_6072 vdd.$2993.Metal3 vss.$1211.Metal5 0.000482456f
Cred_6073 vdd.$2993.Metal3 vss.$1229.Metal5 0.000482456f
Cred_6074 vdd.$2993.Metal3 vss.$1281.Metal5 0.00184674f
Cred_6075 vdd.$2993.Metal3 vss.$1299.Metal5 0.00184674f
Cred_6076 vdd.$2997.Metal3 vout.$1036.Metal3 9.17655e-06f
Cred_6077 vdd.$2997.Metal3 vout.$1038.Metal3 1.04943e-05f
Cred_6078 vdd.$2997.Metal3 vout.$1076.Metal3 5.76068e-06f
Cred_6079 vdd.$2997.Metal3 vout.$1078.Metal3 6.1172e-06f
Cred_6080 vdd.$2997.Metal3 vout.$1116.Metal3 6.47496e-06f
Cred_6081 vdd.$2997.Metal3 vout.$1118.Metal3 6.52152e-06f
Cred_6082 vdd.$2997.Metal3 vout.$1156.Metal3 0.00403585f
Cred_6083 vdd.$2997.Metal3 vout.$1158.Metal3 1.54523e-05f
Cred_6084 vdd.$2997.Metal3 vout.$1330.Metal4 3.06214e-06f
Cred_6085 vdd.$2997.Metal3 vout.$1331.Metal4 3.1596e-06f
Cred_6086 vdd.$2997.Metal3 vout.$1370.Metal4 0.00381781f
Cred_6087 vdd.$2997.Metal3 vout.$1371.Metal4 0.00106595f
Cred_6088 vdd.$2997.Metal3 vout.$158.Metal1 3.46964e-05f
Cred_6089 vdd.$2997.Metal3 vout.$159.Metal1 3.42986e-05f
Cred_6090 vdd.$2997.Metal3 vout.$208.Metal1 3.21643e-05f
Cred_6091 vdd.$2997.Metal3 vout.$209.Metal1 3.14294e-05f
Cred_6092 vdd.$2997.Metal3 vout.$228.Metal1 2.3958e-05f
Cred_6093 vdd.$2997.Metal3 vout.$229.Metal1 2.43966e-05f
Cred_6094 vdd.$2997.Metal3 vout.$268.Metal1 2.40099e-05f
Cred_6095 vdd.$2997.Metal3 vout.$269.Metal1 2.46068e-05f
Cred_6096 vdd.$2997.Metal3 vout.$288.Metal1 2.49262e-05f
Cred_6097 vdd.$2997.Metal3 vout.$289.Metal1 2.50816e-05f
Cred_6098 vdd.$2997.Metal3 vout.$328.Metal1 2.58202e-05f
Cred_6099 vdd.$2997.Metal3 vout.$329.Metal1 2.53349e-05f
Cred_6100 vdd.$2997.Metal3 vout.$348.Metal1 3.53498e-05f
Cred_6101 vdd.$2997.Metal3 vout.$349.Metal1 3.46947e-05f
Cred_6102 vdd.$2997.Metal3 vout.$398.Metal1 4.48035e-05f
Cred_6103 vdd.$2997.Metal3 vout.$399.Metal1 3.89957e-05f
Cred_6104 vdd.$2997.Metal3 vout.$588.Metal2 5.60745e-05f
Cred_6105 vdd.$2997.Metal3 vout.$590.Metal2 5.46068e-05f
Cred_6106 vdd.$2997.Metal3 vout.$608.Metal2 4.53705e-05f
Cred_6107 vdd.$2997.Metal3 vout.$610.Metal2 4.53935e-05f
Cred_6108 vdd.$2997.Metal3 vout.$648.Metal2 4.70909e-05f
Cred_6109 vdd.$2997.Metal3 vout.$650.Metal2 4.63064e-05f
Cred_6110 vdd.$2997.Metal3 vout.$668.Metal2 3.31279e-05f
Cred_6111 vdd.$2997.Metal3 vout.$670.Metal2 3.23241e-05f
Cred_6112 vdd.$2997.Metal3 vout.$688.Metal2 3.49073e-05f
Cred_6113 vdd.$2997.Metal3 vout.$690.Metal2 3.45432e-05f
Cred_6114 vdd.$2997.Metal3 vout.$708.Metal2 3.77422e-05f
Cred_6115 vdd.$2997.Metal3 vout.$710.Metal2 3.69608e-05f
Cred_6116 vdd.$2997.Metal3 vout.$728.Metal2 5.89664e-05f
Cred_6117 vdd.$2997.Metal3 vout.$730.Metal2 5.77523e-05f
Cred_6118 vdd.$2997.Metal3 vout.$768.Metal2 0.00014345f
Cred_6119 vdd.$2997.Metal3 vout.$770.Metal2 6.15732e-05f
Cred_6120 vdd.$2997.Metal3 vout.$788.Metal2 0.000508924f
Cred_6121 vdd.$2997.Metal3 vout.$790.Metal2 8.17469e-05f
Cred_6122 vdd.$2997.Metal3 vout.P4.pSD 0.00238982f
Cred_6123 vdd.$2997.Metal3 vout.P6.pSD 8.99599e-07f
Cred_6124 vdd.$2997.Metal3 vss 0.00776755f
Cred_6125 vdd.$2997.Metal3 vss.$1211.Metal5 0.000553611f
Cred_6126 vdd.$2997.Metal3 vss.$1229.Metal5 0.000553611f
Cred_6127 vdd.$2997.Metal3 vss.$1281.Metal5 0.00211911f
Cred_6128 vdd.$2997.Metal3 vss.$1299.Metal5 0.00211911f
Cred_6129 vdd.$3001.Metal3 vout.$1158.Metal3 0.00497165f
Cred_6130 vdd.$3001.Metal3 vout.$1371.Metal4 0.00308513f
Cred_6131 vdd.$3001.Metal3 vout.$399.Metal1 6.57204e-06f
Cred_6132 vdd.$3001.Metal3 vout.$770.Metal2 9.96539e-05f
Cred_6133 vdd.$3001.Metal3 vout.$790.Metal2 0.000533275f
Cred_6134 vdd.$3001.Metal3 vout.P6.pSD 0.00373027f
Cred_6135 vdd.$3001.Metal3 vss 0.00585517f
Cred_6136 vdd.$3001.Metal3 vss.$1211.Metal5 0.000426544f
Cred_6137 vdd.$3001.Metal3 vss.$1229.Metal5 0.000426544f
Cred_6138 vdd.$3001.Metal3 vss.$1281.Metal5 0.00163272f
Cred_6139 vdd.$3001.Metal3 vss.$1299.Metal5 0.00163272f
Cred_6140 vdd.$3003.Metal3 vout.$1160.Metal3 0.00103879f
Cred_6141 vdd.$3003.Metal3 vout.$1371.Metal4 0.00232168f
Cred_6142 vdd.$3003.Metal3 vout.$1372.Metal4 0.00122903f
Cred_6143 vdd.$3003.Metal3 vout.$400.Metal1 1.26091e-06f
Cred_6144 vdd.$3003.Metal3 vout.$772.Metal2 2.0822e-05f
Cred_6145 vdd.$3003.Metal3 vout.$792.Metal2 0.000105787f
Cred_6146 vdd.$3003.Metal3 vout.P8.pSD 0.000917744f
Cred_6147 vdd.$3003.Metal3 vss 0.00601863f
Cred_6148 vdd.$3003.Metal3 vss.$1211.Metal5 0.000530014f
Cred_6149 vdd.$3003.Metal3 vss.$1229.Metal5 0.000530014f
Cred_6150 vdd.$3003.Metal3 vss.$1281.Metal5 0.00202879f
Cred_6151 vdd.$3003.Metal3 vss.$1299.Metal5 0.00202879f
Cred_6152 vdd.$3007.Metal3 vout.$1160.Metal3 0.00336214f
Cred_6153 vdd.$3007.Metal3 vout.$1372.Metal4 0.00506694f
Cred_6154 vdd.$3007.Metal3 vout.$400.Metal1 4.08105e-06f
Cred_6155 vdd.$3007.Metal3 vout.$772.Metal2 6.73922e-05f
Cred_6156 vdd.$3007.Metal3 vout.$792.Metal2 0.000342389f
Cred_6157 vdd.$3007.Metal3 vout.P8.pSD 0.00228945f
Cred_6158 vdd.$3007.Metal3 vss 0.00466133f
Cred_6159 vdd.$3007.Metal3 vss.$1211.Metal5 0.000446286f
Cred_6160 vdd.$3007.Metal3 vss.$1229.Metal5 0.000446286f
Cred_6161 vdd.$3007.Metal3 vss.$1281.Metal5 0.00170829f
Cred_6162 vdd.$3007.Metal3 vss.$1299.Metal5 0.00170829f
Cred_6163 vdd.$3011.Metal3 vout.$1372.Metal4 0.0029445f
Cred_6164 vdd.$3011.Metal3 vout.$1383.Metal4 0.0029445f
Cred_6165 vdd.$3011.Metal3 vref 0.000959773f
Cred_6166 vdd.$3011.Metal3 vref.P0.GatPoly 3.74257e-05f
Cred_6167 vdd.$3011.Metal3 vref.P0.nSD 0.000214549f
Cred_6168 vdd.$3011.Metal3 vref.P0.pSD 0.00944234f
Cred_6169 vdd.$3011.Metal3 vss 0.000225023f
Cred_6170 vdd.$3011.Metal3 vss.$1211.Metal5 8.21096e-05f
Cred_6171 vdd.$3011.Metal3 vss.$1229.Metal5 8.21096e-05f
Cred_6172 vdd.$3011.Metal3 vss.$1281.Metal5 0.000314299f
Cred_6173 vdd.$3011.Metal3 vss.$1299.Metal5 0.000314299f
Cred_6174 vdd.$3015.Metal3 vout.$1162.Metal3 0.00336214f
Cred_6175 vdd.$3015.Metal3 vout.$1373.Metal4 0.00137596f
Cred_6176 vdd.$3015.Metal3 vout.$1383.Metal4 0.0039838f
Cred_6177 vdd.$3015.Metal3 vout.$401.Metal1 4.08105e-06f
Cred_6178 vdd.$3015.Metal3 vout.$774.Metal2 6.73922e-05f
Cred_6179 vdd.$3015.Metal3 vout.$794.Metal2 0.000342389f
Cred_6180 vdd.$3015.Metal3 vout.P10.pSD 0.00209476f
Cred_6181 vdd.$3015.Metal3 vss 0.00453986f
Cred_6182 vdd.$3015.Metal3 vss.$1211.Metal5 0.000401962f
Cred_6183 vdd.$3015.Metal3 vss.$1229.Metal5 0.000401962f
Cred_6184 vdd.$3015.Metal3 vss.$1281.Metal5 0.00153863f
Cred_6185 vdd.$3015.Metal3 vss.$1299.Metal5 0.00153863f
Cred_6186 vdd.$3019.Metal3 vout.$1162.Metal3 0.00103879f
Cred_6187 vdd.$3019.Metal3 vout.$1373.Metal4 0.00515138f
Cred_6188 vdd.$3019.Metal3 vout.$1383.Metal4 0.000145894f
Cred_6189 vdd.$3019.Metal3 vout.$1394.Metal4 5.55552e-05f
Cred_6190 vdd.$3019.Metal3 vout.$401.Metal1 1.26091e-06f
Cred_6191 vdd.$3019.Metal3 vout.$774.Metal2 2.0822e-05f
Cred_6192 vdd.$3019.Metal3 vout.$794.Metal2 0.000105787f
Cred_6193 vdd.$3019.Metal3 vout.P10.pSD 0.000723055f
Cred_6194 vdd.$3019.Metal3 vss 0.00550298f
Cred_6195 vdd.$3019.Metal3 vss.$1211.Metal5 0.000363554f
Cred_6196 vdd.$3019.Metal3 vss.$1229.Metal5 0.000363554f
Cred_6197 vdd.$3019.Metal3 vss.$1281.Metal5 0.00139161f
Cred_6198 vdd.$3019.Metal3 vss.$1299.Metal5 0.00139161f
Cred_6199 vdd.$3021.Metal3 vout.$1164.Metal3 0.00497165f
Cred_6200 vdd.$3021.Metal3 vout.$1373.Metal4 0.00364823f
Cred_6201 vdd.$3021.Metal3 vout.$1394.Metal4 0.000618059f
Cred_6202 vdd.$3021.Metal3 vout.$402.Metal1 6.57204e-06f
Cred_6203 vdd.$3021.Metal3 vout.$776.Metal2 9.96539e-05f
Cred_6204 vdd.$3021.Metal3 vout.$796.Metal2 0.000533275f
Cred_6205 vdd.$3021.Metal3 vout.P12.pSD 0.00294233f
Cred_6206 vdd.$3021.Metal3 vss 0.00550234f
Cred_6207 vdd.$3021.Metal3 vss.$1211.Metal5 0.000363512f
Cred_6208 vdd.$3021.Metal3 vss.$1229.Metal5 0.000363512f
Cred_6209 vdd.$3021.Metal3 vss.$1281.Metal5 0.00139145f
Cred_6210 vdd.$3021.Metal3 vss.$1299.Metal5 0.00139145f
Cred_6211 vdd.$3025.Metal3 vout 1.36937e-06f
Cred_6212 vdd.$3025.Metal3 vout.$1004.Metal3 5.88391e-06f
Cred_6213 vdd.$3025.Metal3 vout.$1006.Metal3 5.93982e-06f
Cred_6214 vdd.$3025.Metal3 vout.$1044.Metal3 4.80879e-06f
Cred_6215 vdd.$3025.Metal3 vout.$1046.Metal3 4.54381e-06f
Cred_6216 vdd.$3025.Metal3 vout.$1066.Metal3 3.60393e-06f
Cred_6217 vdd.$3025.Metal3 vout.$1084.Metal3 6.09541e-06f
Cred_6218 vdd.$3025.Metal3 vout.$1106.Metal3 4.39082e-06f
Cred_6219 vdd.$3025.Metal3 vout.$1124.Metal3 6.8476e-06f
Cred_6220 vdd.$3025.Metal3 vout.$1126.Metal3 4.90195e-06f
Cred_6221 vdd.$3025.Metal3 vout.$1164.Metal3 1.5748e-05f
Cred_6222 vdd.$3025.Metal3 vout.$1166.Metal3 0.00403555f
Cred_6223 vdd.$3025.Metal3 vout.$1299.Metal4 1.64895e-11f
Cred_6224 vdd.$3025.Metal3 vout.$1313.Metal4 2.90869e-06f
Cred_6225 vdd.$3025.Metal3 vout.$1323.Metal4 6.15512e-06f
Cred_6226 vdd.$3025.Metal3 vout.$1333.Metal4 2.85515e-06f
Cred_6227 vdd.$3025.Metal3 vout.$1343.Metal4 6.3415e-06f
Cred_6228 vdd.$3025.Metal3 vout.$1353.Metal4 2.95586e-06f
Cred_6229 vdd.$3025.Metal3 vout.$1363.Metal4 3.04464e-06f
Cred_6230 vdd.$3025.Metal3 vout.$1373.Metal4 0.00592586f
Cred_6231 vdd.$3025.Metal3 vout.$1384.Metal4 6.05164e-06f
Cred_6232 vdd.$3025.Metal3 vout.$1394.Metal4 1.34976e-05f
Cred_6233 vdd.$3025.Metal3 vout.$1395.Metal4 1.869e-06f
Cred_6234 vdd.$3025.Metal3 vout.$1405.Metal4 1.90684e-06f
Cred_6235 vdd.$3025.Metal3 vout.$1415.Metal4 0.000581783f
Cred_6236 vdd.$3025.Metal3 vout.$162.Metal1 3.47241e-05f
Cred_6237 vdd.$3025.Metal3 vout.$163.Metal1 3.33907e-05f
Cred_6238 vdd.$3025.Metal3 vout.$212.Metal1 3.21749e-05f
Cred_6239 vdd.$3025.Metal3 vout.$213.Metal1 3.03034e-05f
Cred_6240 vdd.$3025.Metal3 vout.$232.Metal1 2.45057e-05f
Cred_6241 vdd.$3025.Metal3 vout.$233.Metal1 2.3269e-05f
Cred_6242 vdd.$3025.Metal3 vout.$272.Metal1 2.36468e-05f
Cred_6243 vdd.$3025.Metal3 vout.$273.Metal1 2.45868e-05f
Cred_6244 vdd.$3025.Metal3 vout.$292.Metal1 2.49262e-05f
Cred_6245 vdd.$3025.Metal3 vout.$293.Metal1 2.52962e-05f
Cred_6246 vdd.$3025.Metal3 vout.$332.Metal1 2.58202e-05f
Cred_6247 vdd.$3025.Metal3 vout.$333.Metal1 2.53349e-05f
Cred_6248 vdd.$3025.Metal3 vout.$352.Metal1 3.53498e-05f
Cred_6249 vdd.$3025.Metal3 vout.$353.Metal1 3.46947e-05f
Cred_6250 vdd.$3025.Metal3 vout.$402.Metal1 3.96149e-05f
Cred_6251 vdd.$3025.Metal3 vout.$403.Metal1 4.41843e-05f
Cred_6252 vdd.$3025.Metal3 vout.$596.Metal2 5.3985e-05f
Cred_6253 vdd.$3025.Metal3 vout.$598.Metal2 5.41944e-05f
Cred_6254 vdd.$3025.Metal3 vout.$616.Metal2 4.52883e-05f
Cred_6255 vdd.$3025.Metal3 vout.$618.Metal2 4.52735e-05f
Cred_6256 vdd.$3025.Metal3 vout.$656.Metal2 4.55191e-05f
Cred_6257 vdd.$3025.Metal3 vout.$658.Metal2 4.70584e-05f
Cred_6258 vdd.$3025.Metal3 vout.$676.Metal2 3.23268e-05f
Cred_6259 vdd.$3025.Metal3 vout.$678.Metal2 4.89559e-05f
Cred_6260 vdd.$3025.Metal3 vout.$696.Metal2 3.55708e-05f
Cred_6261 vdd.$3025.Metal3 vout.$716.Metal2 3.77422e-05f
Cred_6262 vdd.$3025.Metal3 vout.$718.Metal2 5.3569e-05f
Cred_6263 vdd.$3025.Metal3 vout.$736.Metal2 5.89664e-05f
Cred_6264 vdd.$3025.Metal3 vout.$738.Metal2 5.77523e-05f
Cred_6265 vdd.$3025.Metal3 vout.$776.Metal2 6.28689e-05f
Cred_6266 vdd.$3025.Metal3 vout.$778.Metal2 0.000142154f
Cred_6267 vdd.$3025.Metal3 vout.$796.Metal2 8.40216e-05f
Cred_6268 vdd.$3025.Metal3 vout.$798.Metal2 0.00050665f
Cred_6269 vdd.$3025.Metal3 vout.P0.GatPoly 2.14808e-10f
Cred_6270 vdd.$3025.Metal3 vout.P12.pSD 9.17887e-07f
Cred_6271 vdd.$3025.Metal3 vout.P14.pSD 0.00219511f
Cred_6272 vdd.$3025.Metal3 vss 0.00733525f
Cred_6273 vdd.$3025.Metal3 vss.$1211.Metal5 0.000484936f
Cred_6274 vdd.$3025.Metal3 vss.$1229.Metal5 0.000484936f
Cred_6275 vdd.$3025.Metal3 vss.$1281.Metal5 0.00185623f
Cred_6276 vdd.$3025.Metal3 vss.$1299.Metal5 0.00185623f
Cred_6277 vdd.$3029.Metal3 vout.$1166.Metal3 0.000929444f
Cred_6278 vdd.$3029.Metal3 vout.$1208.Metal3 1.14389e-06f
Cred_6279 vdd.$3029.Metal3 vout.$1373.Metal4 0.00528947f
Cred_6280 vdd.$3029.Metal3 vout.$1415.Metal4 0.0001867f
Cred_6281 vdd.$3029.Metal3 vout.$403.Metal1 1.12818e-06f
Cred_6282 vdd.$3029.Metal3 vout.$404.Metal1 2.15286e-10f
Cred_6283 vdd.$3029.Metal3 vout.$778.Metal2 1.86302e-05f
Cred_6284 vdd.$3029.Metal3 vout.$798.Metal2 9.46516e-05f
Cred_6285 vdd.$3029.Metal3 vout.$800.Metal2 1.08092e-08f
Cred_6286 vdd.$3029.Metal3 vout.P14.pSD 0.000723055f
Cred_6287 vdd.$3029.Metal3 vss 0.00550298f
Cred_6288 vdd.$3029.Metal3 vss.$1211.Metal5 0.000363554f
Cred_6289 vdd.$3029.Metal3 vss.$1229.Metal5 0.000363554f
Cred_6290 vdd.$3029.Metal3 vss.$1281.Metal5 0.00139161f
Cred_6291 vdd.$3029.Metal3 vss.$1299.Metal5 0.00139161f
Cred_6292 vdd.$3031.Metal3 vout.$1208.Metal3 0.00596726f
Cred_6293 vdd.$3031.Metal3 vout.$1373.Metal4 0.00364823f
Cred_6294 vdd.$3031.Metal3 vout.$1415.Metal4 0.000117153f
Cred_6295 vdd.$3031.Metal3 vout.$404.Metal1 2.8276e-06f
Cred_6296 vdd.$3031.Metal3 vout.$800.Metal2 0.00014197f
Cred_6297 vdd.$3031.Metal3 vout.P16.pSD 0.00338501f
Cred_6298 vdd.$3031.Metal3 vss 0.00550234f
Cred_6299 vdd.$3031.Metal3 vss.$1211.Metal5 0.000363512f
Cred_6300 vdd.$3031.Metal3 vss.$1229.Metal5 0.000363512f
Cred_6301 vdd.$3031.Metal3 vss.$1281.Metal5 0.00139145f
Cred_6302 vdd.$3031.Metal3 vss.$1299.Metal5 0.00139145f
Cred_6303 vdd.$3035.Metal3 vout 1.2175e-06f
Cred_6304 vdd.$3035.Metal3 vout.$1008.Metal3 5.23135e-06f
Cred_6305 vdd.$3035.Metal3 vout.$1010.Metal3 6.31743e-06f
Cred_6306 vdd.$3035.Metal3 vout.$1048.Metal3 4.27546e-06f
Cred_6307 vdd.$3035.Metal3 vout.$1050.Metal3 5.31662e-06f
Cred_6308 vdd.$3035.Metal3 vout.$1070.Metal3 3.64983e-06f
Cred_6309 vdd.$3035.Metal3 vout.$1088.Metal3 4.67681e-06f
Cred_6310 vdd.$3035.Metal3 vout.$1110.Metal3 5.67899e-06f
Cred_6311 vdd.$3035.Metal3 vout.$1128.Metal3 6.08816e-06f
Cred_6312 vdd.$3035.Metal3 vout.$1150.Metal3 7.02592e-06f
Cred_6313 vdd.$3035.Metal3 vout.$1168.Metal3 6.74032e-06f
Cred_6314 vdd.$3035.Metal3 vout.$1190.Metal3 0.00542046f
Cred_6315 vdd.$3035.Metal3 vout.$1208.Metal3 8.83379e-06f
Cred_6316 vdd.$3035.Metal3 vout.$1299.Metal4 1.46607e-11f
Cred_6317 vdd.$3035.Metal3 vout.$1313.Metal4 2.59855e-06f
Cred_6318 vdd.$3035.Metal3 vout.$1323.Metal4 2.46652e-06f
Cred_6319 vdd.$3035.Metal3 vout.$1333.Metal4 6.28831e-06f
Cred_6320 vdd.$3035.Metal3 vout.$1343.Metal4 2.54121e-06f
Cred_6321 vdd.$3035.Metal3 vout.$1353.Metal4 2.62803e-06f
Cred_6322 vdd.$3035.Metal3 vout.$1363.Metal4 2.7159e-06f
Cred_6323 vdd.$3035.Metal3 vout.$1373.Metal4 0.00440821f
Cred_6324 vdd.$3035.Metal3 vout.$1384.Metal4 3.16851e-06f
Cred_6325 vdd.$3035.Metal3 vout.$1395.Metal4 3.2845e-06f
Cred_6326 vdd.$3035.Metal3 vout.$1405.Metal4 5.44708e-06f
Cred_6327 vdd.$3035.Metal3 vout.$1415.Metal4 5.99563e-06f
Cred_6328 vdd.$3035.Metal3 vout.$1416.Metal4 0.000421657f
Cred_6329 vdd.$3035.Metal3 vout.$164.Metal1 3.0873e-05f
Cred_6330 vdd.$3035.Metal3 vout.$165.Metal1 3.04915e-05f
Cred_6331 vdd.$3035.Metal3 vout.$214.Metal1 2.86065e-05f
Cred_6332 vdd.$3035.Metal3 vout.$215.Metal1 2.79436e-05f
Cred_6333 vdd.$3035.Metal3 vout.$234.Metal1 2.17708e-05f
Cred_6334 vdd.$3035.Metal3 vout.$235.Metal1 2.12793e-05f
Cred_6335 vdd.$3035.Metal3 vout.$274.Metal1 2.20362e-05f
Cred_6336 vdd.$3035.Metal3 vout.$275.Metal1 2.17106e-05f
Cred_6337 vdd.$3035.Metal3 vout.$294.Metal1 2.24658e-05f
Cred_6338 vdd.$3035.Metal3 vout.$295.Metal1 2.21867e-05f
Cred_6339 vdd.$3035.Metal3 vout.$334.Metal1 2.29565e-05f
Cred_6340 vdd.$3035.Metal3 vout.$335.Metal1 2.24871e-05f
Cred_6341 vdd.$3035.Metal3 vout.$354.Metal1 3.14292e-05f
Cred_6342 vdd.$3035.Metal3 vout.$355.Metal1 3.05383e-05f
Cred_6343 vdd.$3035.Metal3 vout.$404.Metal1 3.52159e-05f
Cred_6344 vdd.$3035.Metal3 vout.$405.Metal1 3.92385e-05f
Cred_6345 vdd.$3035.Metal3 vout.$600.Metal2 4.79977e-05f
Cred_6346 vdd.$3035.Metal3 vout.$602.Metal2 4.8201e-05f
Cred_6347 vdd.$3035.Metal3 vout.$620.Metal2 4.02655e-05f
Cred_6348 vdd.$3035.Metal3 vout.$622.Metal2 4.02735e-05f
Cred_6349 vdd.$3035.Metal3 vout.$660.Metal2 4.04706e-05f
Cred_6350 vdd.$3035.Metal3 vout.$662.Metal2 4.18423e-05f
Cred_6351 vdd.$3035.Metal3 vout.$680.Metal2 2.87414e-05f
Cred_6352 vdd.$3035.Metal3 vout.$682.Metal2 4.38156e-05f
Cred_6353 vdd.$3035.Metal3 vout.$700.Metal2 3.1629e-05f
Cred_6354 vdd.$3035.Metal3 vout.$720.Metal2 3.35564e-05f
Cred_6355 vdd.$3035.Metal3 vout.$722.Metal2 4.79299e-05f
Cred_6356 vdd.$3035.Metal3 vout.$740.Metal2 5.24266e-05f
Cred_6357 vdd.$3035.Metal3 vout.$742.Metal2 3.39924e-05f
Cred_6358 vdd.$3035.Metal3 vout.$762.Metal2 3.53654e-05f
Cred_6359 vdd.$3035.Metal3 vout.$780.Metal2 5.57508e-05f
Cred_6360 vdd.$3035.Metal3 vout.$782.Metal2 3.7246e-05f
Cred_6361 vdd.$3035.Metal3 vout.$800.Metal2 7.41327e-05f
Cred_6362 vdd.$3035.Metal3 vout.$802.Metal2 0.00041026f
Cred_6363 vdd.$3035.Metal3 vout.P0.GatPoly 1.90984e-10f
Cred_6364 vdd.$3035.Metal3 vout.P16.pSD 8.15975e-07f
Cred_6365 vdd.$3035.Metal3 vout.P18.pSD 0.00346509f
Cred_6366 vdd.$3035.Metal3 vss 0.00781461f
Cred_6367 vdd.$3035.Metal3 vss.$1211.Metal5 0.00065985f
Cred_6368 vdd.$3035.Metal3 vss.$1229.Metal5 0.00065985f
Cred_6369 vdd.$3035.Metal3 vss.$1281.Metal5 0.00252577f
Cred_6370 vdd.$3035.Metal3 vss.$1299.Metal5 0.00252577f
Cred_6371 vdd.$3039.Metal3 vout.$1190.Metal3 0.0009131f
Cred_6372 vdd.$3039.Metal3 vout.$1416.Metal4 5.49801e-05f
Cred_6373 vdd.$3039.Metal3 vout.$405.Metal1 7.1503e-07f
Cred_6374 vdd.$3039.Metal3 vout.$802.Metal2 5.42032e-05f
Cred_6375 vdd.$3039.Metal3 vout.P18.pSD 0.000723055f
Cred_6376 vdd.$3039.Metal3 vss 0.00967257f
Cred_6377 vdd.$3039.Metal3 vss.$1211.Metal5 0.00134288f
Cred_6378 vdd.$3039.Metal3 vss.$1229.Metal5 0.00134288f
Cred_6379 vdd.$3039.Metal3 vss.$1281.Metal5 0.00514027f
Cred_6380 vdd.$3039.Metal3 vss.$1299.Metal5 0.00514027f
Cred_6381 vdd.$3043.Metal3 vss 0.0128384f
Cred_6382 vdd.$3043.Metal3 vss.$1211.Metal5 0.00184066f
Cred_6383 vdd.$3043.Metal3 vss.$1229.Metal5 0.00184066f
Cred_6384 vdd.$3043.Metal3 vss.$1281.Metal5 0.00704565f
Cred_6385 vdd.$3043.Metal3 vss.$1299.Metal5 0.00704565f
Cred_6386 vdd.$3213.Metal4 vss 0.00843087f
Cred_6387 vdd.$3213.Metal4 vss.$1211.Metal5 0.00118365f
Cred_6388 vdd.$3213.Metal4 vss.$1229.Metal5 0.00118365f
Cred_6389 vdd.$3213.Metal4 vss.$1281.Metal5 0.00453075f
Cred_6390 vdd.$3213.Metal4 vss.$1299.Metal5 0.00453075f
Cred_6391 vdd.$3215.Metal4 vss 0.00827173f
Cred_6392 vdd.$3215.Metal4 vss.$1211.Metal5 0.000646446f
Cred_6393 vdd.$3215.Metal4 vss.$1229.Metal5 0.000646446f
Cred_6394 vdd.$3215.Metal4 vss.$1281.Metal5 0.00247446f
Cred_6395 vdd.$3215.Metal4 vss.$1299.Metal5 0.00247446f
Cred_6396 vdd.$3219.Metal4 vout.$1152.Metal3 9.66963e-06f
Cred_6397 vdd.$3219.Metal4 vout.$1408.Metal4 0.0109261f
Cred_6398 vdd.$3219.Metal4 vout.$396.Metal1 1.17372e-08f
Cred_6399 vdd.$3219.Metal4 vout.$764.Metal2 1.93822e-07f
Cred_6400 vdd.$3219.Metal4 vout.$784.Metal2 9.84725e-07f
Cred_6401 vdd.$3219.Metal4 vout.P0.pSD 0.00145865f
Cred_6402 vdd.$3219.Metal4 vss 0.0085848f
Cred_6403 vdd.$3219.Metal4 vss.$1211.Metal5 0.000782726f
Cred_6404 vdd.$3219.Metal4 vss.$1229.Metal5 0.000782726f
Cred_6405 vdd.$3219.Metal4 vss.$1281.Metal5 0.00299612f
Cred_6406 vdd.$3219.Metal4 vss.$1299.Metal5 0.00299612f
Cred_6407 vdd.$3223.Metal4 vout.$1369.Metal4 0.00863841f
Cred_6408 vdd.$3223.Metal4 vout.$1408.Metal4 0.0124383f
Cred_6409 vdd.$3223.Metal4 vss 0.00495904f
Cred_6410 vdd.$3223.Metal4 vss.$1211.Metal5 0.000328073f
Cred_6411 vdd.$3223.Metal4 vss.$1229.Metal5 0.000328073f
Cred_6412 vdd.$3223.Metal4 vss.$1281.Metal5 0.0012558f
Cred_6413 vdd.$3223.Metal4 vss.$1299.Metal5 0.0012558f
Cred_6414 vdd.$3225.Metal4 vout.$1369.Metal4 0.02058f
Cred_6415 vdd.$3225.Metal4 vout.$1370.Metal4 0.00127141f
Cred_6416 vdd.$3225.Metal4 vss 0.0048056f
Cred_6417 vdd.$3225.Metal4 vss.$1211.Metal5 0.000317481f
Cred_6418 vdd.$3225.Metal4 vss.$1229.Metal5 0.000317481f
Cred_6419 vdd.$3225.Metal4 vss.$1281.Metal5 0.00121525f
Cred_6420 vdd.$3225.Metal4 vss.$1299.Metal5 0.00121525f
Cred_6421 vdd.$3229.Metal4 vout.$1156.Metal3 1.09589e-05f
Cred_6422 vdd.$3229.Metal4 vout.$1369.Metal4 0.0048613f
Cred_6423 vdd.$3229.Metal4 vout.$1370.Metal4 0.0210972f
Cred_6424 vdd.$3229.Metal4 vout.$398.Metal1 1.33022e-08f
Cred_6425 vdd.$3229.Metal4 vout.$768.Metal2 2.19666e-07f
Cred_6426 vdd.$3229.Metal4 vout.$788.Metal2 1.11602e-06f
Cred_6427 vdd.$3229.Metal4 vout.P4.pSD 1.0821e-05f
Cred_6428 vdd.$3229.Metal4 vss 0.00651386f
Cred_6429 vdd.$3229.Metal4 vss.$1211.Metal5 0.000430338f
Cred_6430 vdd.$3229.Metal4 vss.$1229.Metal5 0.000430338f
Cred_6431 vdd.$3229.Metal4 vss.$1281.Metal5 0.00164724f
Cred_6432 vdd.$3229.Metal4 vss.$1299.Metal5 0.00164724f
Cred_6433 vdd.$3233.Metal4 vout.$1370.Metal4 0.0108821f
Cred_6434 vdd.$3233.Metal4 vout.$1371.Metal4 0.00894152f
Cred_6435 vdd.$3233.Metal4 vss 0.00485586f
Cred_6436 vdd.$3233.Metal4 vss.$1211.Metal5 0.00032127f
Cred_6437 vdd.$3233.Metal4 vss.$1229.Metal5 0.00032127f
Cred_6438 vdd.$3233.Metal4 vss.$1281.Metal5 0.00122976f
Cred_6439 vdd.$3233.Metal4 vss.$1299.Metal5 0.00122976f
Cred_6440 vdd.$3235.Metal4 vout.$1371.Metal4 0.0206657f
Cred_6441 vdd.$3235.Metal4 vout.$1372.Metal4 0.001421f
Cred_6442 vdd.$3235.Metal4 vss 0.00483922f
Cred_6443 vdd.$3235.Metal4 vss.$1211.Metal5 0.000319703f
Cred_6444 vdd.$3235.Metal4 vss.$1229.Metal5 0.000319703f
Cred_6445 vdd.$3235.Metal4 vss.$1281.Metal5 0.00122376f
Cred_6446 vdd.$3235.Metal4 vss.$1299.Metal5 0.00122376f
Cred_6447 vdd.$3239.Metal4 vout.$1160.Metal3 1.22482e-05f
Cred_6448 vdd.$3239.Metal4 vout.$1371.Metal4 0.00471172f
Cred_6449 vdd.$3239.Metal4 vout.$1372.Metal4 0.019978f
Cred_6450 vdd.$3239.Metal4 vout.$400.Metal1 1.48672e-08f
Cred_6451 vdd.$3239.Metal4 vout.$772.Metal2 2.45509e-07f
Cred_6452 vdd.$3239.Metal4 vout.$792.Metal2 1.24732e-06f
Cred_6453 vdd.$3239.Metal4 vout.P8.pSD 1.0821e-05f
Cred_6454 vdd.$3239.Metal4 vss 0.00562338f
Cred_6455 vdd.$3239.Metal4 vss.$1211.Metal5 0.000377579f
Cred_6456 vdd.$3239.Metal4 vss.$1229.Metal5 0.000377579f
Cred_6457 vdd.$3239.Metal4 vss.$1281.Metal5 0.00144529f
Cred_6458 vdd.$3239.Metal4 vss.$1299.Metal5 0.00144529f
Cred_6459 vdd.$3243.Metal4 vout.$1372.Metal4 0.0252415f
Cred_6460 vdd.$3243.Metal4 vout.$1383.Metal4 0.00306636f
Cred_6461 vdd.$3243.Metal4 vss 0.000983756f
Cred_6462 vdd.$3243.Metal4 vss.$1211.Metal5 7.05077e-05f
Cred_6463 vdd.$3243.Metal4 vss.$1229.Metal5 7.05077e-05f
Cred_6464 vdd.$3243.Metal4 vss.$1281.Metal5 0.000269889f
Cred_6465 vdd.$3243.Metal4 vss.$1299.Metal5 0.000269889f
Cred_6466 vdd.$3247.Metal4 vout.$1372.Metal4 0.00306636f
Cred_6467 vdd.$3247.Metal4 vout.$1383.Metal4 0.0216261f
Cred_6468 vdd.$3247.Metal4 vss 0.000983756f
Cred_6469 vdd.$3247.Metal4 vss.$1211.Metal5 7.05077e-05f
Cred_6470 vdd.$3247.Metal4 vss.$1229.Metal5 7.05077e-05f
Cred_6471 vdd.$3247.Metal4 vss.$1281.Metal5 0.000269889f
Cred_6472 vdd.$3247.Metal4 vss.$1299.Metal5 0.000269889f
Cred_6473 vdd.$3251.Metal4 vout.$1162.Metal3 1.22482e-05f
Cred_6474 vdd.$3251.Metal4 vout.$1373.Metal4 1.62238e-05f
Cred_6475 vdd.$3251.Metal4 vout.$1383.Metal4 0.0221017f
Cred_6476 vdd.$3251.Metal4 vout.$1394.Metal4 0.00471172f
Cred_6477 vdd.$3251.Metal4 vout.$401.Metal1 1.48672e-08f
Cred_6478 vdd.$3251.Metal4 vout.$774.Metal2 2.45509e-07f
Cred_6479 vdd.$3251.Metal4 vout.$794.Metal2 1.24732e-06f
Cred_6480 vdd.$3251.Metal4 vout.P10.pSD 8.52543e-06f
Cred_6481 vdd.$3251.Metal4 vss 0.0055761f
Cred_6482 vdd.$3251.Metal4 vss.$1211.Metal5 0.000374027f
Cred_6483 vdd.$3251.Metal4 vss.$1229.Metal5 0.000374027f
Cred_6484 vdd.$3251.Metal4 vss.$1281.Metal5 0.0014317f
Cred_6485 vdd.$3251.Metal4 vss.$1299.Metal5 0.0014317f
Cred_6486 vdd.$3255.Metal4 vout.$1383.Metal4 0.001421f
Cred_6487 vdd.$3255.Metal4 vout.$1394.Metal4 0.0179438f
Cred_6488 vdd.$3255.Metal4 vss 0.00458941f
Cred_6489 vdd.$3255.Metal4 vss.$1211.Metal5 0.000308841f
Cred_6490 vdd.$3255.Metal4 vss.$1229.Metal5 0.000308841f
Cred_6491 vdd.$3255.Metal4 vss.$1281.Metal5 0.00118218f
Cred_6492 vdd.$3255.Metal4 vss.$1299.Metal5 0.00118218f
Cred_6493 vdd.$3257.Metal4 vout.$1373.Metal4 2.17233e-05f
Cred_6494 vdd.$3257.Metal4 vout.$1394.Metal4 0.00892918f
Cred_6495 vdd.$3257.Metal4 vout.$1415.Metal4 0.00961356f
Cred_6496 vdd.$3257.Metal4 vss 0.00453705f
Cred_6497 vdd.$3257.Metal4 vss.$1211.Metal5 0.00029974f
Cred_6498 vdd.$3257.Metal4 vss.$1229.Metal5 0.00029974f
Cred_6499 vdd.$3257.Metal4 vss.$1281.Metal5 0.00114734f
Cred_6500 vdd.$3257.Metal4 vss.$1299.Metal5 0.00114734f
Cred_6501 vdd.$3261.Metal4 vout.$1166.Metal3 1.09589e-05f
Cred_6502 vdd.$3261.Metal4 vout.$1208.Metal3 9.70147e-05f
Cred_6503 vdd.$3261.Metal4 vout.$1373.Metal4 1.67737e-05f
Cred_6504 vdd.$3261.Metal4 vout.$1415.Metal4 0.0265644f
Cred_6505 vdd.$3261.Metal4 vout.$403.Metal1 1.33022e-08f
Cred_6506 vdd.$3261.Metal4 vout.$404.Metal1 1.82587e-08f
Cred_6507 vdd.$3261.Metal4 vout.$778.Metal2 2.19666e-07f
Cred_6508 vdd.$3261.Metal4 vout.$798.Metal2 1.11602e-06f
Cred_6509 vdd.$3261.Metal4 vout.$800.Metal2 9.16743e-07f
Cred_6510 vdd.$3261.Metal4 vout.P14.pSD 8.52543e-06f
Cred_6511 vdd.$3261.Metal4 vss 0.0061039f
Cred_6512 vdd.$3261.Metal4 vss.$1211.Metal5 0.000408868f
Cred_6513 vdd.$3261.Metal4 vss.$1229.Metal5 0.000408868f
Cred_6514 vdd.$3261.Metal4 vss.$1281.Metal5 0.00156506f
Cred_6515 vdd.$3261.Metal4 vss.$1299.Metal5 0.00156506f
Cred_6516 vdd.$3265.Metal4 vout.$1208.Metal3 0.000367959f
Cred_6517 vdd.$3265.Metal4 vout.$1415.Metal4 0.0193379f
Cred_6518 vdd.$3265.Metal4 vout.$404.Metal1 6.92519e-08f
Cred_6519 vdd.$3265.Metal4 vout.$800.Metal2 3.47704e-06f
Cred_6520 vdd.$3265.Metal4 vss 0.00451565f
Cred_6521 vdd.$3265.Metal4 vss.$1211.Metal5 0.000298327f
Cred_6522 vdd.$3265.Metal4 vss.$1229.Metal5 0.000298327f
Cred_6523 vdd.$3265.Metal4 vss.$1281.Metal5 0.00114193f
Cred_6524 vdd.$3265.Metal4 vss.$1299.Metal5 0.00114193f
Cred_6525 vdd.$3267.Metal4 vout.$1190.Metal3 0.000142052f
Cred_6526 vdd.$3267.Metal4 vout.$1208.Metal3 0.000172155f
Cred_6527 vdd.$3267.Metal4 vout.$1373.Metal4 2.17233e-05f
Cred_6528 vdd.$3267.Metal4 vout.$1415.Metal4 0.00845269f
Cred_6529 vdd.$3267.Metal4 vout.$1416.Metal4 0.0107931f
Cred_6530 vdd.$3267.Metal4 vout.$404.Metal1 3.24006e-08f
Cred_6531 vdd.$3267.Metal4 vout.$405.Metal1 9.75831e-08f
Cred_6532 vdd.$3267.Metal4 vout.$800.Metal2 1.62679e-06f
Cred_6533 vdd.$3267.Metal4 vout.$802.Metal2 7.74685e-06f
Cred_6534 vdd.$3267.Metal4 vss 0.0046108f
Cred_6535 vdd.$3267.Metal4 vss.$1211.Metal5 0.000310254f
Cred_6536 vdd.$3267.Metal4 vss.$1229.Metal5 0.000310254f
Cred_6537 vdd.$3267.Metal4 vss.$1281.Metal5 0.00118759f
Cred_6538 vdd.$3267.Metal4 vss.$1299.Metal5 0.00118759f
Cred_6539 vdd.$3271.Metal4 vout.$1190.Metal3 0.000133172f
Cred_6540 vdd.$3271.Metal4 vout.$1416.Metal4 0.00930105f
Cred_6541 vdd.$3271.Metal4 vout.$405.Metal1 9.25181e-08f
Cred_6542 vdd.$3271.Metal4 vout.$802.Metal2 7.31456e-06f
Cred_6543 vdd.$3271.Metal4 vout.P18.pSD 0.00145125f
Cred_6544 vdd.$3271.Metal4 vss 0.00741749f
Cred_6545 vdd.$3271.Metal4 vss.$1211.Metal5 0.000888117f
Cred_6546 vdd.$3271.Metal4 vss.$1229.Metal5 0.000888117f
Cred_6547 vdd.$3271.Metal4 vss.$1281.Metal5 0.00339953f
Cred_6548 vdd.$3271.Metal4 vss.$1299.Metal5 0.00339953f
Cred_6549 vdd.$3275.Metal4 vss 0.00615478f
Cred_6550 vdd.$3275.Metal4 vss.$1211.Metal5 0.000865691f
Cred_6551 vdd.$3275.Metal4 vss.$1229.Metal5 0.000865691f
Cred_6552 vdd.$3275.Metal4 vss.$1281.Metal5 0.00331369f
Cred_6553 vdd.$3275.Metal4 vss.$1299.Metal5 0.00331369f
Cred_6554 vdd.$3277.Metal4 vss 0.0083614f
Cred_6555 vdd.$3277.Metal4 vss.$1211.Metal5 0.00119084f
Cred_6556 vdd.$3277.Metal4 vss.$1229.Metal5 0.00119084f
Cred_6557 vdd.$3277.Metal4 vss.$1281.Metal5 0.00455829f
Cred_6558 vdd.$3277.Metal4 vss.$1299.Metal5 0.00455829f
Cred_6559 vdd.$3448.Metal5 vss 0.0407984f
Cred_6560 vdd.$3448.Metal5 vss.$1211.Metal5 0.00269536f
Cred_6561 vdd.$3448.Metal5 vss.$1229.Metal5 0.00269536f
Cred_6562 vdd.$3448.Metal5 vss.$1281.Metal5 0.0103173f
Cred_6563 vdd.$3448.Metal5 vss.$1299.Metal5 0.0103173f
Cred_6564 vdd.$3450.Metal5 vout.$1369.Metal4 3.73817e-07f
Cred_6565 vdd.$3450.Metal5 vout.$1408.Metal4 0.000102047f
Cred_6566 vdd.$3450.Metal5 vss 0.036396f
Cred_6567 vdd.$3450.Metal5 vss.$1211.Metal5 0.0024045f
Cred_6568 vdd.$3450.Metal5 vss.$1229.Metal5 0.0024045f
Cred_6569 vdd.$3450.Metal5 vss.$1281.Metal5 0.00920394f
Cred_6570 vdd.$3450.Metal5 vss.$1299.Metal5 0.00920394f
Cred_6571 vdd.$3452.Metal5 vout.$1369.Metal4 2.70514e-06f
Cred_6572 vdd.$3452.Metal5 vss 0.0273314f
Cred_6573 vdd.$3452.Metal5 vss.$1211.Metal5 0.00180565f
Cred_6574 vdd.$3452.Metal5 vss.$1229.Metal5 0.00180565f
Cred_6575 vdd.$3452.Metal5 vss.$1281.Metal5 0.00691165f
Cred_6576 vdd.$3452.Metal5 vss.$1299.Metal5 0.00691165f
Cred_6577 vdd.$3453.Metal5 vout.$1369.Metal4 5.73188e-05f
Cred_6578 vdd.$3453.Metal5 vout.$1370.Metal4 1.49911e-05f
Cred_6579 vdd.$3453.Metal5 vss 0.0272872f
Cred_6580 vdd.$3453.Metal5 vss.$1211.Metal5 0.00180273f
Cred_6581 vdd.$3453.Metal5 vss.$1229.Metal5 0.00180273f
Cred_6582 vdd.$3453.Metal5 vss.$1281.Metal5 0.00690047f
Cred_6583 vdd.$3453.Metal5 vss.$1299.Metal5 0.00690047f
Cred_6584 vdd.$3455.Metal5 vout.$1370.Metal4 8.72662e-05f
Cred_6585 vdd.$3455.Metal5 vss 0.0273138f
Cred_6586 vdd.$3455.Metal5 vss.$1211.Metal5 0.00180448f
Cred_6587 vdd.$3455.Metal5 vss.$1229.Metal5 0.00180448f
Cred_6588 vdd.$3455.Metal5 vss.$1281.Metal5 0.00690719f
Cred_6589 vdd.$3455.Metal5 vss.$1299.Metal5 0.00690719f
Cred_6590 vdd.$3456.Metal5 vss 0.027361f
Cred_6591 vdd.$3456.Metal5 vss.$1211.Metal5 0.0018076f
Cred_6592 vdd.$3456.Metal5 vss.$1229.Metal5 0.0018076f
Cred_6593 vdd.$3456.Metal5 vss.$1281.Metal5 0.00691913f
Cred_6594 vdd.$3456.Metal5 vss.$1299.Metal5 0.00691913f
Cred_6595 vdd.$3458.Metal5 vout.$1371.Metal4 5.55552e-05f
Cred_6596 vdd.$3458.Metal5 vout.$1372.Metal4 1.67547e-05f
Cred_6597 vdd.$3458.Metal5 vss 0.0314941f
Cred_6598 vdd.$3458.Metal5 vss.$1211.Metal5 0.00291606f
Cred_6599 vdd.$3458.Metal5 vss.$1229.Metal5 0.00291606f
Cred_6600 vdd.$3458.Metal5 vss.$1281.Metal5 0.0111621f
Cred_6601 vdd.$3458.Metal5 vss.$1299.Metal5 0.0111621f
Cred_6602 vdd.$3460.Metal5 vout.$1372.Metal4 7.23096e-05f
Cred_6603 vdd.$3460.Metal5 vss 0.0169889f
Cred_6604 vdd.$3460.Metal5 vss.$1211.Metal5 0.00299753f
Cred_6605 vdd.$3460.Metal5 vss.$1229.Metal5 0.00299753f
Cred_6606 vdd.$3460.Metal5 vss.$1281.Metal5 0.0114739f
Cred_6607 vdd.$3460.Metal5 vss.$1299.Metal5 0.0114739f
Cred_6608 vdd.$3462.Metal5 vout.$1372.Metal4 0.00182458f
Cred_6609 vdd.$3462.Metal5 vout.$1383.Metal4 0.00182458f
Cred_6610 vdd.$3462.Metal5 vss 0.00390515f
Cred_6611 vdd.$3462.Metal5 vss.$1211.Metal5 0.00142497f
Cred_6612 vdd.$3462.Metal5 vss.$1229.Metal5 0.00142497f
Cred_6613 vdd.$3462.Metal5 vss.$1281.Metal5 0.00545448f
Cred_6614 vdd.$3462.Metal5 vss.$1299.Metal5 0.00545448f
Cred_6615 vdd.$3464.Metal5 vout.$1383.Metal4 7.23096e-05f
Cred_6616 vdd.$3464.Metal5 vss 0.0169889f
Cred_6617 vdd.$3464.Metal5 vss.$1211.Metal5 0.00299753f
Cred_6618 vdd.$3464.Metal5 vss.$1229.Metal5 0.00299753f
Cred_6619 vdd.$3464.Metal5 vss.$1281.Metal5 0.0114739f
Cred_6620 vdd.$3464.Metal5 vss.$1299.Metal5 0.0114739f
Cred_6621 vdd.$3466.Metal5 vout.$1383.Metal4 1.67547e-05f
Cred_6622 vdd.$3466.Metal5 vout.$1394.Metal4 5.55552e-05f
Cred_6623 vdd.$3466.Metal5 vss 0.0251046f
Cred_6624 vdd.$3466.Metal5 vss.$1211.Metal5 0.00357771f
Cred_6625 vdd.$3466.Metal5 vss.$1229.Metal5 0.00357771f
Cred_6626 vdd.$3466.Metal5 vss.$1281.Metal5 0.0136947f
Cred_6627 vdd.$3466.Metal5 vss.$1299.Metal5 0.0136947f
Cred_6628 vdd.$3468.Metal5 vss 0.0188571f
Cred_6629 vdd.$3468.Metal5 vss.$1211.Metal5 0.00268832f
Cred_6630 vdd.$3468.Metal5 vss.$1229.Metal5 0.00268832f
Cred_6631 vdd.$3468.Metal5 vss.$1281.Metal5 0.0102903f
Cred_6632 vdd.$3468.Metal5 vss.$1299.Metal5 0.0102903f
Cred_6633 vdd.$3469.Metal5 vout.$1415.Metal4 7.23096e-05f
Cred_6634 vdd.$3469.Metal5 vss 0.0188291f
Cred_6635 vdd.$3469.Metal5 vss.$1211.Metal5 0.00268303f
Cred_6636 vdd.$3469.Metal5 vss.$1229.Metal5 0.00268303f
Cred_6637 vdd.$3469.Metal5 vss.$1281.Metal5 0.0102701f
Cred_6638 vdd.$3469.Metal5 vss.$1299.Metal5 0.0102701f
Cred_6639 vdd.$3471.Metal5 vout.$1208.Metal3 1.14389e-06f
Cred_6640 vdd.$3471.Metal5 vout.$1415.Metal4 7.1155e-05f
Cred_6641 vdd.$3471.Metal5 vout.$404.Metal1 2.15286e-10f
Cred_6642 vdd.$3471.Metal5 vout.$800.Metal2 1.08092e-08f
Cred_6643 vdd.$3471.Metal5 vss 0.0188106f
Cred_6644 vdd.$3471.Metal5 vss.$1211.Metal5 0.0026804f
Cred_6645 vdd.$3471.Metal5 vss.$1229.Metal5 0.0026804f
Cred_6646 vdd.$3471.Metal5 vss.$1281.Metal5 0.01026f
Cred_6647 vdd.$3471.Metal5 vss.$1299.Metal5 0.01026f
Cred_6648 vdd.$3472.Metal5 vout.$1208.Metal3 5.39854e-08f
Cred_6649 vdd.$3472.Metal5 vout.$1415.Metal4 2.65064e-06f
Cred_6650 vdd.$3472.Metal5 vout.$404.Metal1 1.01603e-11f
Cred_6651 vdd.$3472.Metal5 vout.$800.Metal2 5.10136e-10f
Cred_6652 vdd.$3472.Metal5 vss 0.0188368f
Cred_6653 vdd.$3472.Metal5 vss.$1211.Metal5 0.00268541f
Cred_6654 vdd.$3472.Metal5 vss.$1229.Metal5 0.00268541f
Cred_6655 vdd.$3472.Metal5 vss.$1281.Metal5 0.0102792f
Cred_6656 vdd.$3472.Metal5 vss.$1299.Metal5 0.0102792f
Cred_6657 vdd.$3474.Metal5 vout.$1190.Metal3 1.09581e-06f
Cred_6658 vdd.$3474.Metal5 vout.$1208.Metal3 7.4601e-09f
Cred_6659 vdd.$3474.Metal5 vout.$1415.Metal4 3.66285e-07f
Cred_6660 vdd.$3474.Metal5 vout.$1416.Metal4 8.32595e-05f
Cred_6661 vdd.$3474.Metal5 vout.$404.Metal1 1.40403e-12f
Cred_6662 vdd.$3474.Metal5 vout.$405.Metal1 7.5277e-10f
Cred_6663 vdd.$3474.Metal5 vout.$800.Metal2 7.04944e-11f
Cred_6664 vdd.$3474.Metal5 vout.$802.Metal2 5.97604e-08f
Cred_6665 vdd.$3474.Metal5 vss 0.0250885f
Cred_6666 vdd.$3474.Metal5 vss.$1211.Metal5 0.0035754f
Cred_6667 vdd.$3474.Metal5 vss.$1229.Metal5 0.0035754f
Cred_6668 vdd.$3474.Metal5 vss.$1281.Metal5 0.0136859f
Cred_6669 vdd.$3474.Metal5 vss.$1299.Metal5 0.0136859f
Cred_6670 vdd.$3476.Metal5 vss 0.0281182f
Cred_6671 vdd.$3476.Metal5 vss.$1211.Metal5 0.00400861f
Cred_6672 vdd.$3476.Metal5 vss.$1229.Metal5 0.00400861f
Cred_6673 vdd.$3476.Metal5 vss.$1281.Metal5 0.0153441f
Cred_6674 vdd.$3476.Metal5 vss.$1299.Metal5 0.0153441f
Cred_6675 vdd.$3480.Metal5 vss 0.0431185f
Cred_6676 vdd.$3480.Metal5 vss.$1211.Metal5 0.00322894f
Cred_6677 vdd.$3480.Metal5 vss.$1229.Metal5 0.00322894f
Cred_6678 vdd.$3480.Metal5 vss.$1281.Metal5 0.0123597f
Cred_6679 vdd.$3480.Metal5 vss.$1299.Metal5 0.0123597f
Cred_6680 vdd.$3496.Metal5 vss 0.0307634f
Cred_6681 vdd.$3496.Metal5 vss.$1211.Metal5 0.00450852f
Cred_6682 vdd.$3496.Metal5 vss.$1229.Metal5 0.00450852f
Cred_6683 vdd.$3496.Metal5 vss.$1281.Metal5 0.0172577f
Cred_6684 vdd.$3496.Metal5 vss.$1299.Metal5 0.0172577f
Cred_6685 vdd.$3615.TopMetal1 vout.$1369.Metal4 0.000738298f
Cred_6686 vdd.$3615.TopMetal1 vss 0.0231085f
Cred_6687 vdd.$3615.TopMetal1 vss.$1211.Metal5 0.00152666f
Cred_6688 vdd.$3615.TopMetal1 vss.$1229.Metal5 0.00152666f
Cred_6689 vdd.$3615.TopMetal1 vss.$1281.Metal5 0.00584374f
Cred_6690 vdd.$3615.TopMetal1 vss.$1299.Metal5 0.00584374f
Cred_6691 vdd.$3617.TopMetal1 vout.$1369.Metal4 0.000738298f
Cred_6692 vdd.$3617.TopMetal1 vout.$1370.Metal4 0.00115087f
Cred_6693 vdd.$3617.TopMetal1 vss 0.0271667f
Cred_6694 vdd.$3617.TopMetal1 vss.$1211.Metal5 0.00179477f
Cred_6695 vdd.$3617.TopMetal1 vss.$1229.Metal5 0.00179477f
Cred_6696 vdd.$3617.TopMetal1 vss.$1281.Metal5 0.00687f
Cred_6697 vdd.$3617.TopMetal1 vss.$1299.Metal5 0.00687f
Cred_6698 vdd.$3619.TopMetal1 vout.$1371.Metal4 0.00104126f
Cred_6699 vdd.$3619.TopMetal1 vss 0.0189133f
Cred_6700 vdd.$3619.TopMetal1 vss.$1211.Metal5 0.00171926f
Cred_6701 vdd.$3619.TopMetal1 vss.$1229.Metal5 0.00171926f
Cred_6702 vdd.$3619.TopMetal1 vss.$1281.Metal5 0.00658096f
Cred_6703 vdd.$3619.TopMetal1 vss.$1299.Metal5 0.00658096f
Cred_6704 vdd.$3620.TopMetal1 vout.$1372.Metal4 0.00485022f
Cred_6705 vdd.$3620.TopMetal1 vout.$1383.Metal4 0.00331573f
Cred_6706 vdd.$3620.TopMetal1 vss 0.0161175f
Cred_6707 vdd.$3620.TopMetal1 vss.$1211.Metal5 0.00253132f
Cred_6708 vdd.$3620.TopMetal1 vss.$1229.Metal5 0.00253132f
Cred_6709 vdd.$3620.TopMetal1 vss.$1281.Metal5 0.00968938f
Cred_6710 vdd.$3620.TopMetal1 vss.$1299.Metal5 0.00968938f
Cred_6711 vdd.$3622.TopMetal1 vout.$1372.Metal4 0.00331573f
Cred_6712 vdd.$3622.TopMetal1 vout.$1383.Metal4 0.00485022f
Cred_6713 vdd.$3622.TopMetal1 vss 0.0161175f
Cred_6714 vdd.$3622.TopMetal1 vss.$1211.Metal5 0.00253132f
Cred_6715 vdd.$3622.TopMetal1 vss.$1229.Metal5 0.00253132f
Cred_6716 vdd.$3622.TopMetal1 vss.$1281.Metal5 0.00968938f
Cred_6717 vdd.$3622.TopMetal1 vss.$1299.Metal5 0.00968938f
Cred_6718 vdd.$3623.TopMetal1 vout.$1394.Metal4 0.00104126f
Cred_6719 vdd.$3623.TopMetal1 vss 0.0155877f
Cred_6720 vdd.$3623.TopMetal1 vss.$1211.Metal5 0.00206368f
Cred_6721 vdd.$3623.TopMetal1 vss.$1229.Metal5 0.00206368f
Cred_6722 vdd.$3623.TopMetal1 vss.$1281.Metal5 0.00789933f
Cred_6723 vdd.$3623.TopMetal1 vss.$1299.Metal5 0.00789933f
Cred_6724 vdd.$3625.TopMetal1 vout.$1208.Metal3 1.47339e-05f
Cred_6725 vdd.$3625.TopMetal1 vout.$1415.Metal4 0.00187429f
Cred_6726 vdd.$3625.TopMetal1 vout.$404.Metal1 2.773e-09f
Cred_6727 vdd.$3625.TopMetal1 vout.$800.Metal2 1.39228e-07f
Cred_6728 vdd.$3625.TopMetal1 vss 0.0190229f
Cred_6729 vdd.$3625.TopMetal1 vss.$1211.Metal5 0.00263821f
Cred_6730 vdd.$3625.TopMetal1 vss.$1229.Metal5 0.00263821f
Cred_6731 vdd.$3625.TopMetal1 vss.$1281.Metal5 0.0100985f
Cred_6732 vdd.$3625.TopMetal1 vss.$1299.Metal5 0.0100985f
Cred_6733 vdd.$3627.TopMetal1 vout.$1208.Metal3 1.47339e-05f
Cred_6734 vdd.$3627.TopMetal1 vout.$1415.Metal4 0.000723422f
Cred_6735 vdd.$3627.TopMetal1 vout.$404.Metal1 2.773e-09f
Cred_6736 vdd.$3627.TopMetal1 vout.$800.Metal2 1.39228e-07f
Cred_6737 vdd.$3627.TopMetal1 vss 0.0170087f
Cred_6738 vdd.$3627.TopMetal1 vss.$1211.Metal5 0.0021584f
Cred_6739 vdd.$3627.TopMetal1 vss.$1229.Metal5 0.0021584f
Cred_6740 vdd.$3627.TopMetal1 vss.$1281.Metal5 0.0082619f
Cred_6741 vdd.$3627.TopMetal1 vss.$1299.Metal5 0.0082619f
Cred_6742 vdd.$3700.TopMetal1 vss 80.8957f
Cred_6743 vdd.$3700.TopMetal1 vss.$1211.Metal5 5.34568f
Cred_6744 vdd.$3700.TopMetal1 vss.$1229.Metal5 5.34568f
Cred_6745 vdd.$3700.TopMetal1 vss.$1281.Metal5 20.4622f
Cred_6746 vdd.$3700.TopMetal1 vss.$1299.Metal5 20.4622f
Cred_6747 vdd.$3707.TopMetal1 vss 80.8708f
Cred_6748 vdd.$3707.TopMetal1 vss.$1211.Metal5 5.34595f
Cred_6749 vdd.$3707.TopMetal1 vss.$1229.Metal5 5.34595f
Cred_6750 vdd.$3707.TopMetal1 vss.$1281.Metal5 20.4632f
Cred_6751 vdd.$3707.TopMetal1 vss.$1299.Metal5 20.4632f
Cred_6752 vdd.$4071.TopMetal1 vss 579.082f
Cred_6753 vdd.$4071.TopMetal1 vss.$1211.Metal5 43.0695f
Cred_6754 vdd.$4071.TopMetal1 vss.$1229.Metal5 43.0695f
Cred_6755 vdd.$4071.TopMetal1 vss.$1281.Metal5 164.861f
Cred_6756 vdd.$4071.TopMetal1 vss.$1299.Metal5 164.861f
Cred_6757 vdd.$4456.TopMetal1 vss 680.26f
Cred_6758 vdd.$4456.TopMetal1 vss.$1211.Metal5 24.7195f
Cred_6759 vdd.$4456.TopMetal1 vss.$1229.Metal5 24.7195f
Cred_6760 vdd.$4456.TopMetal1 vss.$1281.Metal5 94.6211f
Cred_6761 vdd.$4456.TopMetal1 vss.$1299.Metal5 94.6211f
Cred_6762 vdd.$4841.TopMetal1 vss 799.556f
Cred_6763 vdd.$4841.TopMetal1 vss.$1211.Metal5 12.3638f
Cred_6764 vdd.$4841.TopMetal1 vss.$1229.Metal5 12.3638f
Cred_6765 vdd.$4841.TopMetal1 vss.$1281.Metal5 47.326f
Cred_6766 vdd.$4841.TopMetal1 vss.$1299.Metal5 47.326f
Cred_6767 vdd.$5226.TopMetal1 vss 903.559f
Cred_6768 vdd.$5226.TopMetal1 vss.$1211.Metal5 1.47028f
Cred_6769 vdd.$5226.TopMetal1 vss.$1229.Metal5 1.47028f
Cred_6770 vdd.$5226.TopMetal1 vss.$1281.Metal5 5.62793f
Cred_6771 vdd.$5226.TopMetal1 vss.$1299.Metal5 5.62793f
Cred_6772 vdd.P0.GatPoly vss 0.122855f
Cred_6773 vdd.P0.GatPoly vss.$1211.Metal5 0.0163763f
Cred_6774 vdd.P0.GatPoly vss.$1229.Metal5 0.0163763f
Cred_6775 vdd.P0.GatPoly vss.$1281.Metal5 0.062685f
Cred_6776 vdd.P0.GatPoly vss.$1299.Metal5 0.062685f
Cred_6777 vdd.P0.nSD vout 0.0399548f
Cred_6778 vdd.P0.nSD vout.$1002.Metal3 3.94997e-07f
Cred_6779 vdd.P0.nSD vout.$1004.Metal3 3.32656e-07f
Cred_6780 vdd.P0.nSD vout.$1006.Metal3 4.17051e-07f
Cred_6781 vdd.P0.nSD vout.$1008.Metal3 4.06342e-07f
Cred_6782 vdd.P0.nSD vout.$1010.Metal3 4.12703e-07f
Cred_6783 vdd.P0.nSD vout.$1032.Metal3 3.60421e-07f
Cred_6784 vdd.P0.nSD vout.$1034.Metal3 3.4866e-07f
Cred_6785 vdd.P0.nSD vout.$1036.Metal3 3.15687e-07f
Cred_6786 vdd.P0.nSD vout.$1038.Metal3 3.13026e-07f
Cred_6787 vdd.P0.nSD vout.$1040.Metal3 3.51725e-07f
Cred_6788 vdd.P0.nSD vout.$1152.Metal3 4.30714e-10f
Cred_6789 vdd.P0.nSD vout.$1156.Metal3 7.52476e-10f
Cred_6790 vdd.P0.nSD vout.$1160.Metal3 7.92991e-10f
Cred_6791 vdd.P0.nSD vout.$1162.Metal3 7.92991e-10f
Cred_6792 vdd.P0.nSD vout.$1166.Metal3 4.8138e-10f
Cred_6793 vdd.P0.nSD vout.$1190.Metal3 4.79559e-10f
Cred_6794 vdd.P0.nSD vout.$1299.Metal4 7.93541e-05f
Cred_6795 vdd.P0.nSD vout.$1313.Metal4 0.0568793f
Cred_6796 vdd.P0.nSD vout.$1328.Metal4 4.29262e-08f
Cred_6797 vdd.P0.nSD vout.$1329.Metal4 4.15255e-08f
Cred_6798 vdd.P0.nSD vout.$1330.Metal4 3.75983e-08f
Cred_6799 vdd.P0.nSD vout.$1331.Metal4 3.72815e-08f
Cred_6800 vdd.P0.nSD vout.$1332.Metal4 4.18905e-08f
Cred_6801 vdd.P0.nSD vout.$1370.Metal4 3.82682e-06f
Cred_6802 vdd.P0.nSD vout.$1372.Metal4 3.38142e-06f
Cred_6803 vdd.P0.nSD vout.$1373.Metal4 1.97081e-05f
Cred_6804 vdd.P0.nSD vout.$1383.Metal4 3.38142e-06f
Cred_6805 vdd.P0.nSD vout.$1408.Metal4 5.35449e-11f
Cred_6806 vdd.P0.nSD vout.$1415.Metal4 5.98435e-11f
Cred_6807 vdd.P0.nSD vout.$1416.Metal4 2.88755e-11f
Cred_6808 vdd.P0.nSD vout.$156.Metal1 0.0036286f
Cred_6809 vdd.P0.nSD vout.$157.Metal1 0.00351019f
Cred_6810 vdd.P0.nSD vout.$158.Metal1 0.00317823f
Cred_6811 vdd.P0.nSD vout.$159.Metal1 0.00315145f
Cred_6812 vdd.P0.nSD vout.$160.Metal1 0.00354105f
Cred_6813 vdd.P0.nSD vout.$161.Metal1 0.00332855f
Cred_6814 vdd.P0.nSD vout.$162.Metal1 0.00280322f
Cred_6815 vdd.P0.nSD vout.$163.Metal1 0.0035144f
Cred_6816 vdd.P0.nSD vout.$164.Metal1 0.00342416f
Cred_6817 vdd.P0.nSD vout.$165.Metal1 0.00347776f
Cred_6818 vdd.P0.nSD vout.$396.Metal1 4.35463e-06f
Cred_6819 vdd.P0.nSD vout.$398.Metal1 7.60774e-06f
Cred_6820 vdd.P0.nSD vout.$400.Metal1 8.01736e-06f
Cred_6821 vdd.P0.nSD vout.$401.Metal1 8.01736e-06f
Cred_6822 vdd.P0.nSD vout.$403.Metal1 4.86688e-06f
Cred_6823 vdd.P0.nSD vout.$405.Metal1 4.35463e-06f
Cred_6824 vdd.P0.nSD vout.$584.Metal2 2.2372e-05f
Cred_6825 vdd.P0.nSD vout.$586.Metal2 2.1642e-05f
Cred_6826 vdd.P0.nSD vout.$588.Metal2 1.95953e-05f
Cred_6827 vdd.P0.nSD vout.$590.Metal2 1.94301e-05f
Cred_6828 vdd.P0.nSD vout.$592.Metal2 2.18322e-05f
Cred_6829 vdd.P0.nSD vout.$594.Metal2 2.0496e-05f
Cred_6830 vdd.P0.nSD vout.$596.Metal2 1.72612e-05f
Cred_6831 vdd.P0.nSD vout.$598.Metal2 2.16404e-05f
Cred_6832 vdd.P0.nSD vout.$600.Metal2 2.10847e-05f
Cred_6833 vdd.P0.nSD vout.$602.Metal2 2.14148e-05f
Cred_6834 vdd.P0.nSD vout.$604.Metal2 7.22444e-09f
Cred_6835 vdd.P0.nSD vout.$606.Metal2 6.98869e-09f
Cred_6836 vdd.P0.nSD vout.$608.Metal2 6.32776e-09f
Cred_6837 vdd.P0.nSD vout.$610.Metal2 6.27444e-09f
Cred_6838 vdd.P0.nSD vout.$612.Metal2 7.05013e-09f
Cred_6839 vdd.P0.nSD vout.$764.Metal2 8.63342e-12f
Cred_6840 vdd.P0.nSD vout.$768.Metal2 1.5083e-11f
Cred_6841 vdd.P0.nSD vout.$772.Metal2 1.58951e-11f
Cred_6842 vdd.P0.nSD vout.$774.Metal2 1.58951e-11f
Cred_6843 vdd.P0.nSD vout.$778.Metal2 9.64899e-12f
Cred_6844 vdd.P0.nSD vout.$784.Metal2 2.68482e-08f
Cred_6845 vdd.P0.nSD vout.$788.Metal2 4.6905e-08f
Cred_6846 vdd.P0.nSD vout.$792.Metal2 4.94304e-08f
Cred_6847 vdd.P0.nSD vout.$794.Metal2 4.94304e-08f
Cred_6848 vdd.P0.nSD vout.$798.Metal2 3.00064e-08f
Cred_6849 vdd.P0.nSD vout.$802.Metal2 2.68328e-08f
Cred_6850 vdd.P0.nSD vout.P0.GatPoly 0.00512349f
Cred_6851 vdd.P0.nSD vref 0.0433005f
Cred_6852 vdd.P0.nSD vref.P0.GatPoly 0.000784251f
Cred_6853 vdd.P0.nSD vref.P0.nSD 0.00212078f
Cred_6854 vdd.P0.nSD vref.P0.pSD 0.00888077f
Cred_6855 vdd.P0.nSD vss 0.129542f
Cred_6856 vdd.P0.nSD vss.$1211.Metal5 0.0484117f
Cred_6857 vdd.P0.nSD vss.$1229.Metal5 0.0484117f
Cred_6858 vdd.P0.nSD vss.$127.Metal1 0.00187448f
Cred_6859 vdd.P0.nSD vss.$1281.Metal5 0.18531f
Cred_6860 vdd.P0.nSD vss.$1299.Metal5 0.18531f
Cred_6861 vdd.P0.nSD vss.$406.Metal1 0.0113089f
Cred_6862 vdd.P0.nSD vss.$457.Metal2 2.73765e-05f
Cred_6863 vdd.P0.nSD vss.P0.GatPoly 6.70144e-05f
Cred_6864 vdd.P0.nSD vss.P0.pSD 0.0406698f
Cred_6865 vdd.P0.pSD vout.$1032.Metal3 0.00259375f
Cred_6866 vdd.P0.pSD vout.$1072.Metal3 0.00118653f
Cred_6867 vdd.P0.pSD vout.$1112.Metal3 0.00131247f
Cred_6868 vdd.P0.pSD vout.$1152.Metal3 0.00204203f
Cred_6869 vdd.P0.pSD vout.$1328.Metal4 0.000147583f
Cred_6870 vdd.P0.pSD vout.$1368.Metal4 0.00090737f
Cred_6871 vdd.P0.pSD vout.$1408.Metal4 0.00153003f
Cred_6872 vdd.P0.pSD vout.$156.Metal1 7.28534e-05f
Cred_6873 vdd.P0.pSD vout.$206.Metal1 3.70991e-05f
Cred_6874 vdd.P0.pSD vout.$226.Metal1 3.93475e-06f
Cred_6875 vdd.P0.pSD vout.$326.Metal1 2.99032e-06f
Cred_6876 vdd.P0.pSD vout.$346.Metal1 2.42963e-05f
Cred_6877 vdd.P0.pSD vout.$396.Metal1 2.98846e-05f
Cred_6878 vdd.P0.pSD vout.$584.Metal2 0.00806052f
Cred_6879 vdd.P0.pSD vout.$604.Metal2 0.00636707f
Cred_6880 vdd.P0.pSD vout.$644.Metal2 0.00610571f
Cred_6881 vdd.P0.pSD vout.$664.Metal2 0.00387625f
Cred_6882 vdd.P0.pSD vout.$684.Metal2 0.00338654f
Cred_6883 vdd.P0.pSD vout.$704.Metal2 0.00325286f
Cred_6884 vdd.P0.pSD vout.$724.Metal2 0.004406f
Cred_6885 vdd.P0.pSD vout.$764.Metal2 0.00387848f
Cred_6886 vdd.P0.pSD vout.$784.Metal2 0.00369496f
Cred_6887 vdd.P0.pSD vss 0.0151638f
Cred_6888 vdd.P0.pSD vss.$1211.Metal5 0.00342294f
Cred_6889 vdd.P0.pSD vss.$1229.Metal5 0.00342294f
Cred_6890 vdd.P0.pSD vss.$1281.Metal5 0.0131023f
Cred_6891 vdd.P0.pSD vss.$1299.Metal5 0.0131023f
Cred_6892 vdd.P1.GatPoly vout 7.44175e-06f
Cred_6893 vdd.P1.GatPoly vout.$1002.Metal3 1.14975e-10f
Cred_6894 vdd.P1.GatPoly vout.$1004.Metal3 7.50244e-11f
Cred_6895 vdd.P1.GatPoly vout.$1006.Metal3 7.29781e-11f
Cred_6896 vdd.P1.GatPoly vout.$1008.Metal3 5.52591e-11f
Cred_6897 vdd.P1.GatPoly vout.$1010.Metal3 4.37067e-11f
Cred_6898 vdd.P1.GatPoly vout.$1032.Metal3 4.68744e-10f
Cred_6899 vdd.P1.GatPoly vout.$1034.Metal3 3.49078e-10f
Cred_6900 vdd.P1.GatPoly vout.$1036.Metal3 2.43979e-10f
Cred_6901 vdd.P1.GatPoly vout.$1038.Metal3 1.87312e-10f
Cred_6902 vdd.P1.GatPoly vout.$1040.Metal3 1.63585e-10f
Cred_6903 vdd.P1.GatPoly vout.$1299.Metal4 1.73349e-08f
Cred_6904 vdd.P1.GatPoly vout.$1313.Metal4 5.77855e-06f
Cred_6905 vdd.P1.GatPoly vout.$1328.Metal4 5.58275e-11f
Cred_6906 vdd.P1.GatPoly vout.$1329.Metal4 4.15752e-11f
Cred_6907 vdd.P1.GatPoly vout.$1330.Metal4 2.9058e-11f
Cred_6908 vdd.P1.GatPoly vout.$1331.Metal4 2.2309e-11f
Cred_6909 vdd.P1.GatPoly vout.$1332.Metal4 1.94829e-11f
Cred_6910 vdd.P1.GatPoly vout.$156.Metal1 4.71916e-06f
Cred_6911 vdd.P1.GatPoly vout.$157.Metal1 3.5144e-06f
Cred_6912 vdd.P1.GatPoly vout.$158.Metal1 2.4563e-06f
Cred_6913 vdd.P1.GatPoly vout.$159.Metal1 1.8858e-06f
Cred_6914 vdd.P1.GatPoly vout.$160.Metal1 1.64692e-06f
Cred_6915 vdd.P1.GatPoly vout.$161.Metal1 9.68868e-07f
Cred_6916 vdd.P1.GatPoly vout.$162.Metal1 6.32214e-07f
Cred_6917 vdd.P1.GatPoly vout.$163.Metal1 6.14971e-07f
Cred_6918 vdd.P1.GatPoly vout.$164.Metal1 4.65657e-07f
Cred_6919 vdd.P1.GatPoly vout.$165.Metal1 3.68307e-07f
Cred_6920 vdd.P1.GatPoly vout.$584.Metal2 2.90958e-08f
Cred_6921 vdd.P1.GatPoly vout.$586.Metal2 2.16679e-08f
Cred_6922 vdd.P1.GatPoly vout.$588.Metal2 1.51443e-08f
Cred_6923 vdd.P1.GatPoly vout.$590.Metal2 1.16268e-08f
Cred_6924 vdd.P1.GatPoly vout.$592.Metal2 1.0154e-08f
Cred_6925 vdd.P1.GatPoly vout.$594.Metal2 5.96594e-09f
Cred_6926 vdd.P1.GatPoly vout.$596.Metal2 3.89295e-09f
Cred_6927 vdd.P1.GatPoly vout.$598.Metal2 3.78677e-09f
Cred_6928 vdd.P1.GatPoly vout.$600.Metal2 2.86735e-09f
Cred_6929 vdd.P1.GatPoly vout.$602.Metal2 2.2679e-09f
Cred_6930 vdd.P1.GatPoly vout.$604.Metal2 9.39572e-12f
Cred_6931 vdd.P1.GatPoly vout.$606.Metal2 6.99707e-12f
Cred_6932 vdd.P1.GatPoly vout.$608.Metal2 4.89043e-12f
Cred_6933 vdd.P1.GatPoly vout.$610.Metal2 3.75457e-12f
Cred_6934 vdd.P1.GatPoly vout.$612.Metal2 3.27896e-12f
Cred_6935 vdd.P1.GatPoly vout.P0.GatPoly 1.12003e-06f
Cred_6936 vdd.P1.GatPoly vref 4.16e-05f
Cred_6937 vdd.P1.GatPoly vref.P0.GatPoly 1.57345e-06f
Cred_6938 vdd.P1.GatPoly vref.P0.nSD 8.50709e-06f
Cred_6939 vdd.P1.GatPoly vref.P0.pSD 2.58734e-05f
Cred_6940 vdd.P1.GatPoly vss 0.00805985f
Cred_6941 vdd.P1.GatPoly vss.$1211.Metal5 0.00165699f
Cred_6942 vdd.P1.GatPoly vss.$1229.Metal5 0.00165699f
Cred_6943 vdd.P1.GatPoly vss.$127.Metal1 2.91068e-06f
Cred_6944 vdd.P1.GatPoly vss.$1281.Metal5 0.00634262f
Cred_6945 vdd.P1.GatPoly vss.$1299.Metal5 0.00634262f
Cred_6946 vdd.P1.GatPoly vss.$406.Metal1 2.17569e-06f
Cred_6947 vdd.P1.GatPoly vss.$457.Metal2 4.25101e-08f
Cred_6948 vdd.P1.GatPoly vss.P0.GatPoly 1.0406e-07f
Cred_6949 vdd.P1.GatPoly vss.P0.pSD 3.40126e-05f
Cred_6950 vdd.P1.pSD vout.$1032.Metal3 0.00871669f
Cred_6951 vdd.P1.pSD vout.$1072.Metal3 0.00322592f
Cred_6952 vdd.P1.pSD vout.$1112.Metal3 0.00323878f
Cred_6953 vdd.P1.pSD vout.$1152.Metal3 0.00489173f
Cred_6954 vdd.P1.pSD vout.$1328.Metal4 0.00414984f
Cred_6955 vdd.P1.pSD vout.$1368.Metal4 0.00214972f
Cred_6956 vdd.P1.pSD vout.$1408.Metal4 0.00187141f
Cred_6957 vdd.P1.pSD vout.$156.Metal1 0.0434148f
Cred_6958 vdd.P1.pSD vout.$206.Metal1 0.0396845f
Cred_6959 vdd.P1.pSD vout.$226.Metal1 0.0295335f
Cred_6960 vdd.P1.pSD vout.$266.Metal1 0.0284774f
Cred_6961 vdd.P1.pSD vout.$286.Metal1 0.0287312f
Cred_6962 vdd.P1.pSD vout.$326.Metal1 0.0283906f
Cred_6963 vdd.P1.pSD vout.$346.Metal1 0.0367966f
Cred_6964 vdd.P1.pSD vout.$396.Metal1 0.0393471f
Cred_6965 vdd.P1.pSD vout.$584.Metal2 0.0354552f
Cred_6966 vdd.P1.pSD vout.$604.Metal2 0.0279042f
Cred_6967 vdd.P1.pSD vout.$644.Metal2 0.0264754f
Cred_6968 vdd.P1.pSD vout.$664.Metal2 0.016514f
Cred_6969 vdd.P1.pSD vout.$684.Metal2 0.0164767f
Cred_6970 vdd.P1.pSD vout.$704.Metal2 0.0162945f
Cred_6971 vdd.P1.pSD vout.$724.Metal2 0.0222884f
Cred_6972 vdd.P1.pSD vout.$764.Metal2 0.0195834f
Cred_6973 vdd.P1.pSD vout.$784.Metal2 0.0183488f
Cred_6974 vdd.P1.pSD vout.P0.pSD 0.00104336f
Cred_6975 vdd.P1.pSD vss 0.00707916f
Cred_6976 vdd.P1.pSD vss.$1211.Metal5 0.001035f
Cred_6977 vdd.P1.pSD vss.$1229.Metal5 0.001035f
Cred_6978 vdd.P1.pSD vss.$1281.Metal5 0.00396178f
Cred_6979 vdd.P1.pSD vss.$1299.Metal5 0.00396178f
Cred_6980 vdd.P10.pSD vout.$1038.Metal3 0.00576479f
Cred_6981 vdd.P10.pSD vout.$1040.Metal3 0.0058183f
Cred_6982 vdd.P10.pSD vout.$1078.Metal3 0.00231225f
Cred_6983 vdd.P10.pSD vout.$1080.Metal3 0.00206268f
Cred_6984 vdd.P10.pSD vout.$1100.Metal3 0.00299245f
Cred_6985 vdd.P10.pSD vout.$1118.Metal3 0.00276883f
Cred_6986 vdd.P10.pSD vout.$1158.Metal3 0.00445505f
Cred_6987 vdd.P10.pSD vout.$1160.Metal3 0.00511646f
Cred_6988 vdd.P10.pSD vout.$1331.Metal4 0.00183064f
Cred_6989 vdd.P10.pSD vout.$1332.Metal4 0.00186189f
Cred_6990 vdd.P10.pSD vout.$1371.Metal4 0.0140971f
Cred_6991 vdd.P10.pSD vout.$1372.Metal4 0.00890329f
Cred_6992 vdd.P10.pSD vout.$159.Metal1 0.0421919f
Cred_6993 vdd.P10.pSD vout.$160.Metal1 0.0415088f
Cred_6994 vdd.P10.pSD vout.$209.Metal1 0.0384488f
Cred_6995 vdd.P10.pSD vout.$210.Metal1 0.0377691f
Cred_6996 vdd.P10.pSD vout.$229.Metal1 0.0280799f
Cred_6997 vdd.P10.pSD vout.$230.Metal1 0.0289563f
Cred_6998 vdd.P10.pSD vout.$269.Metal1 0.0279212f
Cred_6999 vdd.P10.pSD vout.$270.Metal1 0.0276542f
Cred_7000 vdd.P10.pSD vout.$289.Metal1 0.0279855f
Cred_7001 vdd.P10.pSD vout.$290.Metal1 0.0282502f
Cred_7002 vdd.P10.pSD vout.$329.Metal1 0.0280297f
Cred_7003 vdd.P10.pSD vout.$330.Metal1 0.027503f
Cred_7004 vdd.P10.pSD vout.$349.Metal1 0.03632f
Cred_7005 vdd.P10.pSD vout.$350.Metal1 0.0356471f
Cred_7006 vdd.P10.pSD vout.$399.Metal1 0.0388803f
Cred_7007 vdd.P10.pSD vout.$400.Metal1 0.038267f
Cred_7008 vdd.P10.pSD vout.$590.Metal2 0.0351809f
Cred_7009 vdd.P10.pSD vout.$592.Metal2 0.0347057f
Cred_7010 vdd.P10.pSD vout.$610.Metal2 0.0275047f
Cred_7011 vdd.P10.pSD vout.$612.Metal2 0.0274987f
Cred_7012 vdd.P10.pSD vout.$650.Metal2 0.0261237f
Cred_7013 vdd.P10.pSD vout.$652.Metal2 0.02613f
Cred_7014 vdd.P10.pSD vout.$670.Metal2 0.0167101f
Cred_7015 vdd.P10.pSD vout.$672.Metal2 0.0248776f
Cred_7016 vdd.P10.pSD vout.$690.Metal2 0.0164027f
Cred_7017 vdd.P10.pSD vout.$710.Metal2 0.0163408f
Cred_7018 vdd.P10.pSD vout.$712.Metal2 0.0239802f
Cred_7019 vdd.P10.pSD vout.$730.Metal2 0.0219875f
Cred_7020 vdd.P10.pSD vout.$732.Metal2 0.0215476f
Cred_7021 vdd.P10.pSD vout.$770.Metal2 0.0196256f
Cred_7022 vdd.P10.pSD vout.$772.Metal2 0.0192239f
Cred_7023 vdd.P10.pSD vout.$790.Metal2 0.0186035f
Cred_7024 vdd.P10.pSD vout.$792.Metal2 0.018077f
Cred_7025 vdd.P10.pSD vout.P6.pSD 0.0010191f
Cred_7026 vdd.P10.pSD vout.P8.pSD 0.000994376f
Cred_7027 vdd.P10.pSD vss 0.00222985f
Cred_7028 vdd.P10.pSD vss.$1211.Metal5 0.000813662f
Cred_7029 vdd.P10.pSD vss.$1229.Metal5 0.000813662f
Cred_7030 vdd.P10.pSD vss.$1281.Metal5 0.00311453f
Cred_7031 vdd.P10.pSD vss.$1299.Metal5 0.00311453f
Cred_7032 vdd.P11.pSD vout.$1040.Metal3 0.00552158f
Cred_7033 vdd.P11.pSD vout.$1080.Metal3 0.00171939f
Cred_7034 vdd.P11.pSD vout.$1100.Metal3 0.00276484f
Cred_7035 vdd.P11.pSD vout.$1122.Metal3 0.000531595f
Cred_7036 vdd.P11.pSD vout.$1160.Metal3 0.0051123f
Cred_7037 vdd.P11.pSD vout.$1162.Metal3 0.000964967f
Cred_7038 vdd.P11.pSD vout.$1332.Metal4 0.00182931f
Cred_7039 vdd.P11.pSD vout.$1372.Metal4 0.0296475f
Cred_7040 vdd.P11.pSD vout.$1383.Metal4 3.96815e-05f
Cred_7041 vdd.P11.pSD vout.$160.Metal1 0.0416146f
Cred_7042 vdd.P11.pSD vout.$210.Metal1 0.0377853f
Cred_7043 vdd.P11.pSD vout.$230.Metal1 0.027863f
Cred_7044 vdd.P11.pSD vout.$270.Metal1 0.0285781f
Cred_7045 vdd.P11.pSD vout.$290.Metal1 0.0275317f
Cred_7046 vdd.P11.pSD vout.$330.Metal1 0.0271679f
Cred_7047 vdd.P11.pSD vout.$331.Metal1 1.89603e-06f
Cred_7048 vdd.P11.pSD vout.$350.Metal1 0.0352037f
Cred_7049 vdd.P11.pSD vout.$351.Metal1 1.54052e-05f
Cred_7050 vdd.P11.pSD vout.$400.Metal1 0.0379672f
Cred_7051 vdd.P11.pSD vout.$401.Metal1 1.87599e-05f
Cred_7052 vdd.P11.pSD vout.$592.Metal2 0.0344224f
Cred_7053 vdd.P11.pSD vout.$612.Metal2 0.0271592f
Cred_7054 vdd.P11.pSD vout.$652.Metal2 0.0257915f
Cred_7055 vdd.P11.pSD vout.$672.Metal2 0.0249353f
Cred_7056 vdd.P11.pSD vout.$694.Metal2 0.00215444f
Cred_7057 vdd.P11.pSD vout.$712.Metal2 0.0242339f
Cred_7058 vdd.P11.pSD vout.$714.Metal2 0.00206113f
Cred_7059 vdd.P11.pSD vout.$732.Metal2 0.0216139f
Cred_7060 vdd.P11.pSD vout.$734.Metal2 0.00279225f
Cred_7061 vdd.P11.pSD vout.$772.Metal2 0.0192752f
Cred_7062 vdd.P11.pSD vout.$774.Metal2 0.00245522f
Cred_7063 vdd.P11.pSD vout.$792.Metal2 0.0185036f
Cred_7064 vdd.P11.pSD vout.$794.Metal2 0.00232635f
Cred_7065 vdd.P11.pSD vout.P8.pSD 0.00100351f
Cred_7066 vdd.P11.pSD vref 0.0605898f
Cred_7067 vdd.P11.pSD vref.P0.GatPoly 0.00236266f
Cred_7068 vdd.P11.pSD vref.P0.nSD 0.0135444f
Cred_7069 vdd.P11.pSD vref.P0.pSD 0.316594f
Cred_7070 vdd.P11.pSD vss 0.00209683f
Cred_7071 vdd.P11.pSD vss.$1211.Metal5 0.000765124f
Cred_7072 vdd.P11.pSD vss.$1229.Metal5 0.000765124f
Cred_7073 vdd.P11.pSD vss.$1281.Metal5 0.00292874f
Cred_7074 vdd.P11.pSD vss.$1299.Metal5 0.00292874f
Cred_7075 vdd.P13.pSD vout.$1002.Metal3 0.00359196f
Cred_7076 vdd.P13.pSD vout.$1042.Metal3 0.00309182f
Cred_7077 vdd.P13.pSD vout.$1082.Metal3 0.00229124f
Cred_7078 vdd.P13.pSD vout.$1100.Metal3 0.000364152f
Cred_7079 vdd.P13.pSD vout.$1122.Metal3 0.00262108f
Cred_7080 vdd.P13.pSD vout.$1160.Metal3 0.00113309f
Cred_7081 vdd.P13.pSD vout.$1162.Metal3 0.00450538f
Cred_7082 vdd.P13.pSD vout.$1313.Metal4 2.98844e-05f
Cred_7083 vdd.P13.pSD vout.$1323.Metal4 0.000461149f
Cred_7084 vdd.P13.pSD vout.$1333.Metal4 0.000471093f
Cred_7085 vdd.P13.pSD vout.$1343.Metal4 0.000443717f
Cred_7086 vdd.P13.pSD vout.$1353.Metal4 0.000440964f
Cred_7087 vdd.P13.pSD vout.$1363.Metal4 0.000411189f
Cred_7088 vdd.P13.pSD vout.$1372.Metal4 0.00460651f
Cred_7089 vdd.P13.pSD vout.$1373.Metal4 0.009793f
Cred_7090 vdd.P13.pSD vout.$1383.Metal4 0.00894778f
Cred_7091 vdd.P13.pSD vout.$161.Metal1 0.0433504f
Cred_7092 vdd.P13.pSD vout.$211.Metal1 0.0481574f
Cred_7093 vdd.P13.pSD vout.$251.Metal1 0.0380697f
Cred_7094 vdd.P13.pSD vout.$270.Metal1 1.06729e-05f
Cred_7095 vdd.P13.pSD vout.$290.Metal1 1.03844e-05f
Cred_7096 vdd.P13.pSD vout.$291.Metal1 0.0388104f
Cred_7097 vdd.P13.pSD vout.$330.Metal1 1.89603e-06f
Cred_7098 vdd.P13.pSD vout.$331.Metal1 0.028933f
Cred_7099 vdd.P13.pSD vout.$350.Metal1 1.54052e-05f
Cred_7100 vdd.P13.pSD vout.$351.Metal1 0.0374866f
Cred_7101 vdd.P13.pSD vout.$400.Metal1 1.87599e-05f
Cred_7102 vdd.P13.pSD vout.$401.Metal1 0.040111f
Cred_7103 vdd.P13.pSD vout.$594.Metal2 0.0352184f
Cred_7104 vdd.P13.pSD vout.$614.Metal2 0.0189348f
Cred_7105 vdd.P13.pSD vout.$634.Metal2 0.0181105f
Cred_7106 vdd.P13.pSD vout.$654.Metal2 0.0176928f
Cred_7107 vdd.P13.pSD vout.$672.Metal2 0.00105611f
Cred_7108 vdd.P13.pSD vout.$674.Metal2 0.0169249f
Cred_7109 vdd.P13.pSD vout.$694.Metal2 0.0169132f
Cred_7110 vdd.P13.pSD vout.$712.Metal2 0.00312412f
Cred_7111 vdd.P13.pSD vout.$714.Metal2 0.0162865f
Cred_7112 vdd.P13.pSD vout.$732.Metal2 0.00279562f
Cred_7113 vdd.P13.pSD vout.$734.Metal2 0.0219112f
Cred_7114 vdd.P13.pSD vout.$772.Metal2 0.00245522f
Cred_7115 vdd.P13.pSD vout.$774.Metal2 0.0195684f
Cred_7116 vdd.P13.pSD vout.$792.Metal2 0.00232635f
Cred_7117 vdd.P13.pSD vout.$794.Metal2 0.0184966f
Cred_7118 vdd.P13.pSD vout.P10.pSD 0.00115835f
Cred_7119 vdd.P13.pSD vref 0.0565979f
Cred_7120 vdd.P13.pSD vref.P0.GatPoly 0.002207f
Cred_7121 vdd.P13.pSD vref.P0.nSD 0.012652f
Cred_7122 vdd.P13.pSD vref.P0.pSD 0.295832f
Cred_7123 vdd.P13.pSD vss 0.00219265f
Cred_7124 vdd.P13.pSD vss.$1211.Metal5 0.000800086f
Cred_7125 vdd.P13.pSD vss.$1229.Metal5 0.000800086f
Cred_7126 vdd.P13.pSD vss.$1281.Metal5 0.00306257f
Cred_7127 vdd.P13.pSD vss.$1299.Metal5 0.00306257f
Cred_7128 vdd.P15.pSD vout 0.000869386f
Cred_7129 vdd.P15.pSD vout.$1002.Metal3 0.00368773f
Cred_7130 vdd.P15.pSD vout.$1004.Metal3 0.00372012f
Cred_7131 vdd.P15.pSD vout.$1042.Metal3 0.00261645f
Cred_7132 vdd.P15.pSD vout.$1044.Metal3 0.00326798f
Cred_7133 vdd.P15.pSD vout.$1082.Metal3 0.00311563f
Cred_7134 vdd.P15.pSD vout.$1084.Metal3 0.00229174f
Cred_7135 vdd.P15.pSD vout.$1122.Metal3 0.00294364f
Cred_7136 vdd.P15.pSD vout.$1124.Metal3 0.00262177f
Cred_7137 vdd.P15.pSD vout.$1162.Metal3 0.00445505f
Cred_7138 vdd.P15.pSD vout.$1164.Metal3 0.00439443f
Cred_7139 vdd.P15.pSD vout.$1299.Metal4 1.04689e-08f
Cred_7140 vdd.P15.pSD vout.$1313.Metal4 0.0018467f
Cred_7141 vdd.P15.pSD vout.$1323.Metal4 0.00173796f
Cred_7142 vdd.P15.pSD vout.$1333.Metal4 0.00174097f
Cred_7143 vdd.P15.pSD vout.$1343.Metal4 0.00167228f
Cred_7144 vdd.P15.pSD vout.$1353.Metal4 0.00361836f
Cred_7145 vdd.P15.pSD vout.$1363.Metal4 0.00343838f
Cred_7146 vdd.P15.pSD vout.$1373.Metal4 0.00155834f
Cred_7147 vdd.P15.pSD vout.$1383.Metal4 0.00514706f
Cred_7148 vdd.P15.pSD vout.$1384.Metal4 0.000760227f
Cred_7149 vdd.P15.pSD vout.$1394.Metal4 0.00414108f
Cred_7150 vdd.P15.pSD vout.$161.Metal1 0.0427021f
Cred_7151 vdd.P15.pSD vout.$162.Metal1 0.0421679f
Cred_7152 vdd.P15.pSD vout.$211.Metal1 0.0498132f
Cred_7153 vdd.P15.pSD vout.$212.Metal1 0.0383937f
Cred_7154 vdd.P15.pSD vout.$232.Metal1 0.0285928f
Cred_7155 vdd.P15.pSD vout.$251.Metal1 0.0391485f
Cred_7156 vdd.P15.pSD vout.$272.Metal1 0.0296103f
Cred_7157 vdd.P15.pSD vout.$291.Metal1 0.036797f
Cred_7158 vdd.P15.pSD vout.$292.Metal1 0.0282306f
Cred_7159 vdd.P15.pSD vout.$331.Metal1 0.0280297f
Cred_7160 vdd.P15.pSD vout.$332.Metal1 0.027503f
Cred_7161 vdd.P15.pSD vout.$351.Metal1 0.03632f
Cred_7162 vdd.P15.pSD vout.$352.Metal1 0.0356471f
Cred_7163 vdd.P15.pSD vout.$401.Metal1 0.0388803f
Cred_7164 vdd.P15.pSD vout.$402.Metal1 0.0382668f
Cred_7165 vdd.P15.pSD vout.$594.Metal2 0.0342341f
Cred_7166 vdd.P15.pSD vout.$596.Metal2 0.0343667f
Cred_7167 vdd.P15.pSD vout.$614.Metal2 0.0187002f
Cred_7168 vdd.P15.pSD vout.$616.Metal2 0.0274545f
Cred_7169 vdd.P15.pSD vout.$634.Metal2 0.0178903f
Cred_7170 vdd.P15.pSD vout.$654.Metal2 0.0170581f
Cred_7171 vdd.P15.pSD vout.$656.Metal2 0.0265609f
Cred_7172 vdd.P15.pSD vout.$674.Metal2 0.0166545f
Cred_7173 vdd.P15.pSD vout.$676.Metal2 0.0167108f
Cred_7174 vdd.P15.pSD vout.$694.Metal2 0.0168088f
Cred_7175 vdd.P15.pSD vout.$696.Metal2 0.0162355f
Cred_7176 vdd.P15.pSD vout.$714.Metal2 0.0163408f
Cred_7177 vdd.P15.pSD vout.$716.Metal2 0.0160027f
Cred_7178 vdd.P15.pSD vout.$734.Metal2 0.0219875f
Cred_7179 vdd.P15.pSD vout.$736.Metal2 0.021535f
Cred_7180 vdd.P15.pSD vout.$774.Metal2 0.0196256f
Cred_7181 vdd.P15.pSD vout.$776.Metal2 0.0192221f
Cred_7182 vdd.P15.pSD vout.$794.Metal2 0.0186035f
Cred_7183 vdd.P15.pSD vout.$796.Metal2 0.018067f
Cred_7184 vdd.P15.pSD vout.P0.GatPoly 1.36377e-07f
Cred_7185 vdd.P15.pSD vout.P10.pSD 0.00113724f
Cred_7186 vdd.P15.pSD vout.P12.pSD 0.00101015f
Cred_7187 vdd.P15.pSD vss 6.63468e-05f
Cred_7188 vdd.P15.pSD vss.$1211.Metal5 2.42096e-05f
Cred_7189 vdd.P15.pSD vss.$1229.Metal5 2.42096e-05f
Cred_7190 vdd.P15.pSD vss.$1281.Metal5 9.26694e-05f
Cred_7191 vdd.P15.pSD vss.$1299.Metal5 9.26694e-05f
Cred_7192 vdd.P17.pSD vout 0.000869371f
Cred_7193 vdd.P17.pSD vout.$1004.Metal3 0.00368767f
Cred_7194 vdd.P17.pSD vout.$1006.Metal3 0.00372005f
Cred_7195 vdd.P17.pSD vout.$1044.Metal3 0.00279198f
Cred_7196 vdd.P17.pSD vout.$1046.Metal3 0.00269258f
Cred_7197 vdd.P17.pSD vout.$1066.Metal3 0.00193506f
Cred_7198 vdd.P17.pSD vout.$1084.Metal3 0.00311556f
Cred_7199 vdd.P17.pSD vout.$1106.Metal3 0.00212653f
Cred_7200 vdd.P17.pSD vout.$1124.Metal3 0.00294356f
Cred_7201 vdd.P17.pSD vout.$1126.Metal3 0.00202921f
Cred_7202 vdd.P17.pSD vout.$1164.Metal3 0.00445488f
Cred_7203 vdd.P17.pSD vout.$1166.Metal3 0.00439431f
Cred_7204 vdd.P17.pSD vout.$1299.Metal4 1.04687e-08f
Cred_7205 vdd.P17.pSD vout.$1313.Metal4 0.00184667f
Cred_7206 vdd.P17.pSD vout.$1323.Metal4 0.00385593f
Cred_7207 vdd.P17.pSD vout.$1333.Metal4 0.00174094f
Cred_7208 vdd.P17.pSD vout.$1343.Metal4 0.00371021f
Cred_7209 vdd.P17.pSD vout.$1353.Metal4 0.00163437f
Cred_7210 vdd.P17.pSD vout.$1363.Metal4 0.00156495f
Cred_7211 vdd.P17.pSD vout.$1373.Metal4 0.00154971f
Cred_7212 vdd.P17.pSD vout.$1384.Metal4 0.00260363f
Cred_7213 vdd.P17.pSD vout.$1394.Metal4 0.00414161f
Cred_7214 vdd.P17.pSD vout.$1395.Metal4 0.00072411f
Cred_7215 vdd.P17.pSD vout.$1405.Metal4 0.000650842f
Cred_7216 vdd.P17.pSD vout.$1415.Metal4 0.00163929f
Cred_7217 vdd.P17.pSD vout.$162.Metal1 0.0427017f
Cred_7218 vdd.P17.pSD vout.$163.Metal1 0.0410481f
Cred_7219 vdd.P17.pSD vout.$212.Metal1 0.0393083f
Cred_7220 vdd.P17.pSD vout.$213.Metal1 0.0370123f
Cred_7221 vdd.P17.pSD vout.$232.Metal1 0.0292763f
Cred_7222 vdd.P17.pSD vout.$233.Metal1 0.0278003f
Cred_7223 vdd.P17.pSD vout.$272.Metal1 0.0275707f
Cred_7224 vdd.P17.pSD vout.$273.Metal1 0.0285239f
Cred_7225 vdd.P17.pSD vout.$292.Metal1 0.0279853f
Cred_7226 vdd.P17.pSD vout.$293.Metal1 0.028307f
Cred_7227 vdd.P17.pSD vout.$332.Metal1 0.0280294f
Cred_7228 vdd.P17.pSD vout.$333.Metal1 0.0275027f
Cred_7229 vdd.P17.pSD vout.$352.Metal1 0.0363196f
Cred_7230 vdd.P17.pSD vout.$353.Metal1 0.0356467f
Cred_7231 vdd.P17.pSD vout.$402.Metal1 0.0388799f
Cred_7232 vdd.P17.pSD vout.$403.Metal1 0.0382665f
Cred_7233 vdd.P17.pSD vout.$596.Metal2 0.0342336f
Cred_7234 vdd.P17.pSD vout.$598.Metal2 0.0343589f
Cred_7235 vdd.P17.pSD vout.$616.Metal2 0.0274592f
Cred_7236 vdd.P17.pSD vout.$618.Metal2 0.0274362f
Cred_7237 vdd.P17.pSD vout.$656.Metal2 0.025697f
Cred_7238 vdd.P17.pSD vout.$658.Metal2 0.0265449f
Cred_7239 vdd.P17.pSD vout.$676.Metal2 0.0167145f
Cred_7240 vdd.P17.pSD vout.$678.Metal2 0.0245258f
Cred_7241 vdd.P17.pSD vout.$696.Metal2 0.0167135f
Cred_7242 vdd.P17.pSD vout.$716.Metal2 0.0163404f
Cred_7243 vdd.P17.pSD vout.$718.Metal2 0.0238087f
Cred_7244 vdd.P17.pSD vout.$736.Metal2 0.0219868f
Cred_7245 vdd.P17.pSD vout.$738.Metal2 0.0215343f
Cred_7246 vdd.P17.pSD vout.$776.Metal2 0.0196249f
Cred_7247 vdd.P17.pSD vout.$778.Metal2 0.0192214f
Cred_7248 vdd.P17.pSD vout.$796.Metal2 0.0186026f
Cred_7249 vdd.P17.pSD vout.$798.Metal2 0.0180696f
Cred_7250 vdd.P17.pSD vout.P0.GatPoly 1.36375e-07f
Cred_7251 vdd.P17.pSD vout.P12.pSD 0.00103165f
Cred_7252 vdd.P17.pSD vout.P14.pSD 0.000995354f
Cred_7253 vdd.P17.pSD vss 7.0099e-05f
Cred_7254 vdd.P17.pSD vss.$1211.Metal5 2.44539e-05f
Cred_7255 vdd.P17.pSD vss.$1229.Metal5 2.44539e-05f
Cred_7256 vdd.P17.pSD vss.$1281.Metal5 9.36044e-05f
Cred_7257 vdd.P17.pSD vss.$1299.Metal5 9.36044e-05f
Cred_7258 vdd.P19.pSD vout 0.000869523f
Cred_7259 vdd.P19.pSD vout.$1006.Metal3 0.00368832f
Cred_7260 vdd.P19.pSD vout.$1008.Metal3 0.00372071f
Cred_7261 vdd.P19.pSD vout.$1046.Metal3 0.00199727f
Cred_7262 vdd.P19.pSD vout.$1048.Metal3 0.00326854f
Cred_7263 vdd.P19.pSD vout.$1066.Metal3 0.00217341f
Cred_7264 vdd.P19.pSD vout.$1088.Metal3 0.00272158f
Cred_7265 vdd.P19.pSD vout.$1106.Metal3 0.0022838f
Cred_7266 vdd.P19.pSD vout.$1126.Metal3 0.00217685f
Cred_7267 vdd.P19.pSD vout.$1128.Metal3 0.00262238f
Cred_7268 vdd.P19.pSD vout.$1166.Metal3 0.00445663f
Cred_7269 vdd.P19.pSD vout.$1168.Metal3 0.00256884f
Cred_7270 vdd.P19.pSD vout.$1208.Metal3 0.00220935f
Cred_7271 vdd.P19.pSD vout.$1299.Metal4 1.04705e-08f
Cred_7272 vdd.P19.pSD vout.$1313.Metal4 0.00184699f
Cred_7273 vdd.P19.pSD vout.$1323.Metal4 0.00173823f
Cred_7274 vdd.P19.pSD vout.$1333.Metal4 0.00174126f
Cred_7275 vdd.P19.pSD vout.$1343.Metal4 0.00167256f
Cred_7276 vdd.P19.pSD vout.$1353.Metal4 0.00163029f
Cred_7277 vdd.P19.pSD vout.$1363.Metal4 0.00156107f
Cred_7278 vdd.P19.pSD vout.$1373.Metal4 0.00154329f
Cred_7279 vdd.P19.pSD vout.$1384.Metal4 0.00152081f
Cred_7280 vdd.P19.pSD vout.$1395.Metal4 0.00229515f
Cred_7281 vdd.P19.pSD vout.$1405.Metal4 0.00130211f
Cred_7282 vdd.P19.pSD vout.$1415.Metal4 0.00248805f
Cred_7283 vdd.P19.pSD vout.$1416.Metal4 0.000595265f
Cred_7284 vdd.P19.pSD vout.$163.Metal1 0.0438252f
Cred_7285 vdd.P19.pSD vout.$164.Metal1 0.0421713f
Cred_7286 vdd.P19.pSD vout.$213.Metal1 0.040693f
Cred_7287 vdd.P19.pSD vout.$214.Metal1 0.0383968f
Cred_7288 vdd.P19.pSD vout.$233.Metal1 0.0300486f
Cred_7289 vdd.P19.pSD vout.$234.Metal1 0.0285952f
Cred_7290 vdd.P19.pSD vout.$273.Metal1 0.030137f
Cred_7291 vdd.P19.pSD vout.$274.Metal1 0.0282614f
Cred_7292 vdd.P19.pSD vout.$293.Metal1 0.0284606f
Cred_7293 vdd.P19.pSD vout.$294.Metal1 0.0278391f
Cred_7294 vdd.P19.pSD vout.$333.Metal1 0.0280323f
Cred_7295 vdd.P19.pSD vout.$334.Metal1 0.0275055f
Cred_7296 vdd.P19.pSD vout.$353.Metal1 0.0363235f
Cred_7297 vdd.P19.pSD vout.$354.Metal1 0.0356506f
Cred_7298 vdd.P19.pSD vout.$403.Metal1 0.0388842f
Cred_7299 vdd.P19.pSD vout.$404.Metal1 0.0382693f
Cred_7300 vdd.P19.pSD vout.$598.Metal2 0.0342467f
Cred_7301 vdd.P19.pSD vout.$600.Metal2 0.0343721f
Cred_7302 vdd.P19.pSD vout.$618.Metal2 0.0274821f
Cred_7303 vdd.P19.pSD vout.$620.Metal2 0.027459f
Cred_7304 vdd.P19.pSD vout.$658.Metal2 0.02569f
Cred_7305 vdd.P19.pSD vout.$660.Metal2 0.0265656f
Cred_7306 vdd.P19.pSD vout.$678.Metal2 0.0250709f
Cred_7307 vdd.P19.pSD vout.$680.Metal2 0.016714f
Cred_7308 vdd.P19.pSD vout.$700.Metal2 0.0162347f
Cred_7309 vdd.P19.pSD vout.$718.Metal2 0.0246802f
Cred_7310 vdd.P19.pSD vout.$720.Metal2 0.0160064f
Cred_7311 vdd.P19.pSD vout.$738.Metal2 0.0219934f
Cred_7312 vdd.P19.pSD vout.$740.Metal2 0.0215407f
Cred_7313 vdd.P19.pSD vout.$778.Metal2 0.0196319f
Cred_7314 vdd.P19.pSD vout.$780.Metal2 0.0191916f
Cred_7315 vdd.P19.pSD vout.$798.Metal2 0.0186119f
Cred_7316 vdd.P19.pSD vout.$800.Metal2 0.0179315f
Cred_7317 vdd.P19.pSD vout.P0.GatPoly 1.36399e-07f
Cred_7318 vdd.P19.pSD vout.P14.pSD 0.00104817f
Cred_7319 vdd.P19.pSD vout.P16.pSD 0.00101024f
Cred_7320 vdd.P19.pSD vss 6.64577e-05f
Cred_7321 vdd.P19.pSD vss.$1211.Metal5 2.42501e-05f
Cred_7322 vdd.P19.pSD vss.$1229.Metal5 2.42501e-05f
Cred_7323 vdd.P19.pSD vss.$1281.Metal5 9.28243e-05f
Cred_7324 vdd.P19.pSD vss.$1299.Metal5 9.28243e-05f
Cred_7325 vdd.P2.GatPoly vout 3.18174e-05f
Cred_7326 vdd.P2.GatPoly vout.$1002.Metal3 1.8371e-10f
Cred_7327 vdd.P2.GatPoly vout.$1004.Metal3 1.99059e-10f
Cred_7328 vdd.P2.GatPoly vout.$1006.Metal3 3.22319e-10f
Cred_7329 vdd.P2.GatPoly vout.$1008.Metal3 4.06829e-10f
Cred_7330 vdd.P2.GatPoly vout.$1010.Metal3 5.3674e-10f
Cred_7331 vdd.P2.GatPoly vout.$1032.Metal3 3.81699e-11f
Cred_7332 vdd.P2.GatPoly vout.$1034.Metal3 4.74148e-11f
Cred_7333 vdd.P2.GatPoly vout.$1036.Metal3 5.52408e-11f
Cred_7334 vdd.P2.GatPoly vout.$1038.Metal3 7.05972e-11f
Cred_7335 vdd.P2.GatPoly vout.$1040.Metal3 1.02379e-10f
Cred_7336 vdd.P2.GatPoly vout.$1299.Metal4 4.91515e-08f
Cred_7337 vdd.P2.GatPoly vout.$1313.Metal4 0.000597058f
Cred_7338 vdd.P2.GatPoly vout.$1328.Metal4 4.54604e-12f
Cred_7339 vdd.P2.GatPoly vout.$1329.Metal4 5.64711e-12f
Cred_7340 vdd.P2.GatPoly vout.$1330.Metal4 6.57919e-12f
Cred_7341 vdd.P2.GatPoly vout.$1331.Metal4 8.40814e-12f
Cred_7342 vdd.P2.GatPoly vout.$1332.Metal4 1.21934e-11f
Cred_7343 vdd.P2.GatPoly vout.$156.Metal1 3.84282e-07f
Cred_7344 vdd.P2.GatPoly vout.$157.Metal1 4.77357e-07f
Cred_7345 vdd.P2.GatPoly vout.$158.Metal1 5.56146e-07f
Cred_7346 vdd.P2.GatPoly vout.$159.Metal1 7.1075e-07f
Cred_7347 vdd.P2.GatPoly vout.$160.Metal1 1.03072e-06f
Cred_7348 vdd.P2.GatPoly vout.$161.Metal1 1.54808e-06f
Cred_7349 vdd.P2.GatPoly vout.$162.Metal1 1.67743e-06f
Cred_7350 vdd.P2.GatPoly vout.$163.Metal1 2.71611e-06f
Cred_7351 vdd.P2.GatPoly vout.$164.Metal1 3.42826e-06f
Cred_7352 vdd.P2.GatPoly vout.$165.Metal1 4.52299e-06f
Cred_7353 vdd.P2.GatPoly vout.$584.Metal2 2.36928e-09f
Cred_7354 vdd.P2.GatPoly vout.$586.Metal2 2.94313e-09f
Cred_7355 vdd.P2.GatPoly vout.$588.Metal2 3.4289e-09f
Cred_7356 vdd.P2.GatPoly vout.$590.Metal2 4.3821e-09f
Cred_7357 vdd.P2.GatPoly vout.$592.Metal2 6.35488e-09f
Cred_7358 vdd.P2.GatPoly vout.$594.Metal2 9.53255e-09f
Cred_7359 vdd.P2.GatPoly vout.$596.Metal2 1.0329e-08f
Cred_7360 vdd.P2.GatPoly vout.$598.Metal2 1.67249e-08f
Cred_7361 vdd.P2.GatPoly vout.$600.Metal2 2.111e-08f
Cred_7362 vdd.P2.GatPoly vout.$602.Metal2 2.7851e-08f
Cred_7363 vdd.P2.GatPoly vout.$604.Metal2 7.65094e-13f
Cred_7364 vdd.P2.GatPoly vout.$606.Metal2 9.50404e-13f
Cred_7365 vdd.P2.GatPoly vout.$608.Metal2 1.10727e-12f
Cred_7366 vdd.P2.GatPoly vout.$610.Metal2 1.41508e-12f
Cred_7367 vdd.P2.GatPoly vout.$612.Metal2 2.05214e-12f
Cred_7368 vdd.P2.GatPoly vout.P0.GatPoly 3.16905e-06f
Cred_7369 vdd.P2.GatPoly vref 0.000317597f
Cred_7370 vdd.P2.GatPoly vref.P0.GatPoly 4.01319e-07f
Cred_7371 vdd.P2.GatPoly vref.P0.nSD 5.81285e-07f
Cred_7372 vdd.P2.GatPoly vref.P0.pSD 2.58665e-06f
Cred_7373 vdd.P2.GatPoly vss 0.00525349f
Cred_7374 vdd.P2.GatPoly vss.$1211.Metal5 0.00192246f
Cred_7375 vdd.P2.GatPoly vss.$1229.Metal5 0.00192246f
Cred_7376 vdd.P2.GatPoly vss.$127.Metal1 3.27754e-07f
Cred_7377 vdd.P2.GatPoly vss.$1281.Metal5 0.00735879f
Cred_7378 vdd.P2.GatPoly vss.$1299.Metal5 0.00735879f
Cred_7379 vdd.P2.GatPoly vss.$406.Metal1 1.75295e-05f
Cred_7380 vdd.P2.GatPoly vss.$457.Metal2 4.7868e-09f
Cred_7381 vdd.P2.GatPoly vss.P0.GatPoly 1.17175e-08f
Cred_7382 vdd.P2.GatPoly vss.P0.pSD 2.09803e-05f
Cred_7383 vdd.P21.pSD vout 0.000869125f
Cred_7384 vdd.P21.pSD vout.$1008.Metal3 0.00368661f
Cred_7385 vdd.P21.pSD vout.$1010.Metal3 0.00444709f
Cred_7386 vdd.P21.pSD vout.$1048.Metal3 0.00279112f
Cred_7387 vdd.P21.pSD vout.$1050.Metal3 0.0035432f
Cred_7388 vdd.P21.pSD vout.$1070.Metal3 0.00219193f
Cred_7389 vdd.P21.pSD vout.$1088.Metal3 0.00268532f
Cred_7390 vdd.P21.pSD vout.$1110.Metal3 0.00302658f
Cred_7391 vdd.P21.pSD vout.$1128.Metal3 0.00294233f
Cred_7392 vdd.P21.pSD vout.$1150.Metal3 0.00304984f
Cred_7393 vdd.P21.pSD vout.$1168.Metal3 0.00257558f
Cred_7394 vdd.P21.pSD vout.$1190.Metal3 0.00356829f
Cred_7395 vdd.P21.pSD vout.$1208.Metal3 0.00226852f
Cred_7396 vdd.P21.pSD vout.$1299.Metal4 1.04657e-08f
Cred_7397 vdd.P21.pSD vout.$1313.Metal4 0.00185504f
Cred_7398 vdd.P21.pSD vout.$1323.Metal4 0.00173743f
Cred_7399 vdd.P21.pSD vout.$1333.Metal4 0.00431135f
Cred_7400 vdd.P21.pSD vout.$1343.Metal4 0.00167173f
Cred_7401 vdd.P21.pSD vout.$1353.Metal4 0.00163384f
Cred_7402 vdd.P21.pSD vout.$1363.Metal4 0.00156957f
Cred_7403 vdd.P21.pSD vout.$1373.Metal4 0.00154869f
Cred_7404 vdd.P21.pSD vout.$1384.Metal4 0.00153262f
Cred_7405 vdd.P21.pSD vout.$1395.Metal4 0.00143059f
Cred_7406 vdd.P21.pSD vout.$1405.Metal4 0.00209002f
Cred_7407 vdd.P21.pSD vout.$1415.Metal4 0.000842591f
Cred_7408 vdd.P21.pSD vout.$1416.Metal4 0.00298722f
Cred_7409 vdd.P21.pSD vout.$164.Metal1 0.0426955f
Cred_7410 vdd.P21.pSD vout.$165.Metal1 0.0421615f
Cred_7411 vdd.P21.pSD vout.$214.Metal1 0.0393025f
Cred_7412 vdd.P21.pSD vout.$215.Metal1 0.0383877f
Cred_7413 vdd.P21.pSD vout.$234.Metal1 0.0292491f
Cred_7414 vdd.P21.pSD vout.$235.Metal1 0.0285882f
Cred_7415 vdd.P21.pSD vout.$274.Metal1 0.0288804f
Cred_7416 vdd.P21.pSD vout.$275.Metal1 0.0283347f
Cred_7417 vdd.P21.pSD vout.$294.Metal1 0.0283713f
Cred_7418 vdd.P21.pSD vout.$295.Metal1 0.0279101f
Cred_7419 vdd.P21.pSD vout.$334.Metal1 0.0280248f
Cred_7420 vdd.P21.pSD vout.$335.Metal1 0.0274836f
Cred_7421 vdd.P21.pSD vout.$354.Metal1 0.0363132f
Cred_7422 vdd.P21.pSD vout.$355.Metal1 0.035522f
Cred_7423 vdd.P21.pSD vout.$404.Metal1 0.0388713f
Cred_7424 vdd.P21.pSD vout.$405.Metal1 0.0382586f
Cred_7425 vdd.P21.pSD vout.$600.Metal2 0.0342239f
Cred_7426 vdd.P21.pSD vout.$602.Metal2 0.0343649f
Cred_7427 vdd.P21.pSD vout.$620.Metal2 0.0274511f
Cred_7428 vdd.P21.pSD vout.$622.Metal2 0.0274516f
Cred_7429 vdd.P21.pSD vout.$660.Metal2 0.0256887f
Cred_7430 vdd.P21.pSD vout.$662.Metal2 0.0265404f
Cred_7431 vdd.P21.pSD vout.$680.Metal2 0.0167085f
Cred_7432 vdd.P21.pSD vout.$682.Metal2 0.0246726f
Cred_7433 vdd.P21.pSD vout.$700.Metal2 0.0167113f
Cred_7434 vdd.P21.pSD vout.$720.Metal2 0.0163336f
Cred_7435 vdd.P21.pSD vout.$722.Metal2 0.023956f
Cred_7436 vdd.P21.pSD vout.$740.Metal2 0.0219762f
Cred_7437 vdd.P21.pSD vout.$742.Metal2 0.014857f
Cred_7438 vdd.P21.pSD vout.$762.Metal2 0.0135824f
Cred_7439 vdd.P21.pSD vout.$780.Metal2 0.019576f
Cred_7440 vdd.P21.pSD vout.$782.Metal2 0.0125094f
Cred_7441 vdd.P21.pSD vout.$800.Metal2 0.01844f
Cred_7442 vdd.P21.pSD vout.$802.Metal2 0.0179688f
Cred_7443 vdd.P21.pSD vout.P0.GatPoly 1.36337e-07f
Cred_7444 vdd.P21.pSD vout.P16.pSD 0.00103134f
Cred_7445 vdd.P21.pSD vout.P18.pSD 0.00101156f
Cred_7446 vdd.P21.pSD vss 7.00552e-05f
Cred_7447 vdd.P21.pSD vss.$1211.Metal5 2.45626e-05f
Cred_7448 vdd.P21.pSD vss.$1229.Metal5 2.45626e-05f
Cred_7449 vdd.P21.pSD vss.$1281.Metal5 9.40207e-05f
Cred_7450 vdd.P21.pSD vss.$1299.Metal5 9.40207e-05f
Cred_7451 vdd.P23.pSD vout.$1010.Metal3 0.00428314f
Cred_7452 vdd.P23.pSD vout.$1050.Metal3 0.00199534f
Cred_7453 vdd.P23.pSD vout.$1070.Metal3 0.00272282f
Cred_7454 vdd.P23.pSD vout.$1110.Metal3 0.00372271f
Cred_7455 vdd.P23.pSD vout.$1150.Metal3 0.00303657f
Cred_7456 vdd.P23.pSD vout.$1190.Metal3 0.00371077f
Cred_7457 vdd.P23.pSD vout.$1313.Metal4 2.69083e-05f
Cred_7458 vdd.P23.pSD vout.$1323.Metal4 0.000461369f
Cred_7459 vdd.P23.pSD vout.$1333.Metal4 0.000466663f
Cred_7460 vdd.P23.pSD vout.$1343.Metal4 0.000443944f
Cred_7461 vdd.P23.pSD vout.$1353.Metal4 0.000429666f
Cred_7462 vdd.P23.pSD vout.$1363.Metal4 0.000422475f
Cred_7463 vdd.P23.pSD vout.$1373.Metal4 0.000447215f
Cred_7464 vdd.P23.pSD vout.$1384.Metal4 0.000498079f
Cred_7465 vdd.P23.pSD vout.$1395.Metal4 0.000446664f
Cred_7466 vdd.P23.pSD vout.$1405.Metal4 0.000426475f
Cred_7467 vdd.P23.pSD vout.$1416.Metal4 0.000991925f
Cred_7468 vdd.P23.pSD vout.$165.Metal1 0.041012f
Cred_7469 vdd.P23.pSD vout.$215.Metal1 0.0372249f
Cred_7470 vdd.P23.pSD vout.$235.Metal1 0.0276979f
Cred_7471 vdd.P23.pSD vout.$275.Metal1 0.0274361f
Cred_7472 vdd.P23.pSD vout.$295.Metal1 0.0270252f
Cred_7473 vdd.P23.pSD vout.$335.Metal1 0.0266104f
Cred_7474 vdd.P23.pSD vout.$355.Metal1 0.0343942f
Cred_7475 vdd.P23.pSD vout.$405.Metal1 0.0372019f
Cred_7476 vdd.P23.pSD vout.$602.Metal2 0.0342366f
Cred_7477 vdd.P23.pSD vout.$622.Metal2 0.0271054f
Cred_7478 vdd.P23.pSD vout.$662.Metal2 0.0257926f
Cred_7479 vdd.P23.pSD vout.$682.Metal2 0.0244334f
Cred_7480 vdd.P23.pSD vout.$722.Metal2 0.0239988f
Cred_7481 vdd.P23.pSD vout.$742.Metal2 0.0149208f
Cred_7482 vdd.P23.pSD vout.$762.Metal2 0.0136502f
Cred_7483 vdd.P23.pSD vout.$782.Metal2 0.0125561f
Cred_7484 vdd.P23.pSD vout.$802.Metal2 0.0182813f
Cred_7485 vdd.P23.pSD vout.P18.pSD 0.00097849f
Cred_7486 vdd.P23.pSD vss 0.00390677f
Cred_7487 vdd.P23.pSD vss.$1211.Metal5 0.00142556f
Cred_7488 vdd.P23.pSD vss.$1229.Metal5 0.00142556f
Cred_7489 vdd.P23.pSD vss.$1281.Metal5 0.00545675f
Cred_7490 vdd.P23.pSD vss.$1299.Metal5 0.00545675f
Cred_7491 vdd.P25.pSD vout.$1010.Metal3 0.00156607f
Cred_7492 vdd.P25.pSD vout.$1050.Metal3 0.000981348f
Cred_7493 vdd.P25.pSD vout.$1070.Metal3 0.00089015f
Cred_7494 vdd.P25.pSD vout.$1110.Metal3 0.00128016f
Cred_7495 vdd.P25.pSD vout.$1150.Metal3 0.0012457f
Cred_7496 vdd.P25.pSD vout.$1190.Metal3 0.00152995f
Cred_7497 vdd.P25.pSD vout.$1313.Metal4 0.00258946f
Cred_7498 vdd.P25.pSD vout.$1333.Metal4 6.29754e-06f
Cred_7499 vdd.P25.pSD vout.$1363.Metal4 5.69881e-06f
Cred_7500 vdd.P25.pSD vout.$1373.Metal4 0.000391324f
Cred_7501 vdd.P25.pSD vout.$1384.Metal4 0.000425247f
Cred_7502 vdd.P25.pSD vout.$1395.Metal4 0.000390638f
Cred_7503 vdd.P25.pSD vout.$1405.Metal4 0.000363807f
Cred_7504 vdd.P25.pSD vout.$1416.Metal4 0.000824484f
Cred_7505 vdd.P25.pSD vout.$165.Metal1 6.52056e-05f
Cred_7506 vdd.P25.pSD vout.$215.Metal1 3.70991e-05f
Cred_7507 vdd.P25.pSD vout.$235.Metal1 3.93475e-06f
Cred_7508 vdd.P25.pSD vout.$275.Metal1 1.67458e-05f
Cred_7509 vdd.P25.pSD vout.$295.Metal1 1.62932e-05f
Cred_7510 vdd.P25.pSD vout.$405.Metal1 2.95053e-05f
Cred_7511 vdd.P25.pSD vout.$602.Metal2 0.00762276f
Cred_7512 vdd.P25.pSD vout.$622.Metal2 0.00634071f
Cred_7513 vdd.P25.pSD vout.$662.Metal2 0.00609976f
Cred_7514 vdd.P25.pSD vout.$682.Metal2 0.00553899f
Cred_7515 vdd.P25.pSD vout.$722.Metal2 0.00491655f
Cred_7516 vdd.P25.pSD vout.$742.Metal2 0.00303554f
Cred_7517 vdd.P25.pSD vout.$762.Metal2 0.00278857f
Cred_7518 vdd.P25.pSD vout.$782.Metal2 0.00249198f
Cred_7519 vdd.P25.pSD vout.$802.Metal2 0.00365526f
Cred_7520 vdd.P25.pSD vss 0.0108888f
Cred_7521 vdd.P25.pSD vss.$1211.Metal5 0.00397325f
Cred_7522 vdd.P25.pSD vss.$1229.Metal5 0.00397325f
Cred_7523 vdd.P25.pSD vss.$1281.Metal5 0.0152088f
Cred_7524 vdd.P25.pSD vss.$1299.Metal5 0.0152088f
Cred_7525 vdd.P3.pSD vout.$1032.Metal3 0.00579381f
Cred_7526 vdd.P3.pSD vout.$1034.Metal3 0.0065823f
Cred_7527 vdd.P3.pSD vout.$1072.Metal3 0.00327817f
Cred_7528 vdd.P3.pSD vout.$1074.Metal3 0.00247856f
Cred_7529 vdd.P3.pSD vout.$1112.Metal3 0.0032372f
Cred_7530 vdd.P3.pSD vout.$1114.Metal3 0.00278777f
Cred_7531 vdd.P3.pSD vout.$1152.Metal3 0.00504962f
Cred_7532 vdd.P3.pSD vout.$1154.Metal3 0.00439148f
Cred_7533 vdd.P3.pSD vout.$1328.Metal4 0.00203852f
Cred_7534 vdd.P3.pSD vout.$1329.Metal4 0.00189114f
Cred_7535 vdd.P3.pSD vout.$1368.Metal4 0.00637338f
Cred_7536 vdd.P3.pSD vout.$1369.Metal4 0.0148321f
Cred_7537 vdd.P3.pSD vout.$1408.Metal4 0.00378873f
Cred_7538 vdd.P3.pSD vout.$156.Metal1 0.042186f
Cred_7539 vdd.P3.pSD vout.$157.Metal1 0.0421637f
Cred_7540 vdd.P3.pSD vout.$206.Metal1 0.0384428f
Cred_7541 vdd.P3.pSD vout.$207.Metal1 0.0383877f
Cred_7542 vdd.P3.pSD vout.$226.Metal1 0.0280635f
Cred_7543 vdd.P3.pSD vout.$227.Metal1 0.0291314f
Cred_7544 vdd.P3.pSD vout.$266.Metal1 0.0285737f
Cred_7545 vdd.P3.pSD vout.$267.Metal1 0.0286628f
Cred_7546 vdd.P3.pSD vout.$286.Metal1 0.0279808f
Cred_7547 vdd.P3.pSD vout.$287.Metal1 0.0281641f
Cred_7548 vdd.P3.pSD vout.$326.Metal1 0.0280248f
Cred_7549 vdd.P3.pSD vout.$327.Metal1 0.0274981f
Cred_7550 vdd.P3.pSD vout.$346.Metal1 0.0363132f
Cred_7551 vdd.P3.pSD vout.$347.Metal1 0.0356405f
Cred_7552 vdd.P3.pSD vout.$396.Metal1 0.038873f
Cred_7553 vdd.P3.pSD vout.$397.Metal1 0.0382594f
Cred_7554 vdd.P3.pSD vout.$584.Metal2 0.03522f
Cred_7555 vdd.P3.pSD vout.$586.Metal2 0.0346107f
Cred_7556 vdd.P3.pSD vout.$604.Metal2 0.0275059f
Cred_7557 vdd.P3.pSD vout.$606.Metal2 0.0275119f
Cred_7558 vdd.P3.pSD vout.$644.Metal2 0.0256801f
Cred_7559 vdd.P3.pSD vout.$646.Metal2 0.0265547f
Cred_7560 vdd.P3.pSD vout.$664.Metal2 0.017117f
Cred_7561 vdd.P3.pSD vout.$666.Metal2 0.0162923f
Cred_7562 vdd.P3.pSD vout.$684.Metal2 0.016396f
Cred_7563 vdd.P3.pSD vout.$686.Metal2 0.0162292f
Cred_7564 vdd.P3.pSD vout.$704.Metal2 0.0163336f
Cred_7565 vdd.P3.pSD vout.$706.Metal2 0.0159957f
Cred_7566 vdd.P3.pSD vout.$724.Metal2 0.0219766f
Cred_7567 vdd.P3.pSD vout.$726.Metal2 0.021524f
Cred_7568 vdd.P3.pSD vout.$764.Metal2 0.0196178f
Cred_7569 vdd.P3.pSD vout.$766.Metal2 0.0192103f
Cred_7570 vdd.P3.pSD vout.$784.Metal2 0.0186071f
Cred_7571 vdd.P3.pSD vout.$786.Metal2 0.0180515f
Cred_7572 vdd.P3.pSD vout.P0.pSD 0.00102037f
Cred_7573 vdd.P3.pSD vout.P2.pSD 0.00101073f
Cred_7574 vdd.P3.pSD vss 0.00234695f
Cred_7575 vdd.P3.pSD vss.$1211.Metal5 0.00084725f
Cred_7576 vdd.P3.pSD vss.$1229.Metal5 0.00084725f
Cred_7577 vdd.P3.pSD vss.$1281.Metal5 0.0032431f
Cred_7578 vdd.P3.pSD vss.$1299.Metal5 0.0032431f
Cred_7579 vdd.P5.pSD vout.$1034.Metal3 0.0055223f
Cred_7580 vdd.P5.pSD vout.$1036.Metal3 0.00657891f
Cred_7581 vdd.P5.pSD vout.$1074.Metal3 0.00296199f
Cred_7582 vdd.P5.pSD vout.$1076.Metal3 0.00247998f
Cred_7583 vdd.P5.pSD vout.$1114.Metal3 0.00276947f
Cred_7584 vdd.P5.pSD vout.$1116.Metal3 0.00278966f
Cred_7585 vdd.P5.pSD vout.$1154.Metal3 0.00445663f
Cred_7586 vdd.P5.pSD vout.$1156.Metal3 0.00439597f
Cred_7587 vdd.P5.pSD vout.$1329.Metal4 0.00183306f
Cred_7588 vdd.P5.pSD vout.$1330.Metal4 0.00189127f
Cred_7589 vdd.P5.pSD vout.$1369.Metal4 0.0141012f
Cred_7590 vdd.P5.pSD vout.$1370.Metal4 0.00886852f
Cred_7591 vdd.P5.pSD vout.$157.Metal1 0.0421953f
Cred_7592 vdd.P5.pSD vout.$158.Metal1 0.04172f
Cred_7593 vdd.P5.pSD vout.$207.Metal1 0.0384519f
Cred_7594 vdd.P5.pSD vout.$208.Metal1 0.0375519f
Cred_7595 vdd.P5.pSD vout.$227.Metal1 0.0280703f
Cred_7596 vdd.P5.pSD vout.$228.Metal1 0.0285965f
Cred_7597 vdd.P5.pSD vout.$267.Metal1 0.0278912f
Cred_7598 vdd.P5.pSD vout.$268.Metal1 0.0286031f
Cred_7599 vdd.P5.pSD vout.$287.Metal1 0.027988f
Cred_7600 vdd.P5.pSD vout.$288.Metal1 0.0281714f
Cred_7601 vdd.P5.pSD vout.$327.Metal1 0.0280323f
Cred_7602 vdd.P5.pSD vout.$328.Metal1 0.0275055f
Cred_7603 vdd.P5.pSD vout.$347.Metal1 0.0363235f
Cred_7604 vdd.P5.pSD vout.$348.Metal1 0.0356506f
Cred_7605 vdd.P5.pSD vout.$397.Metal1 0.0388842f
Cred_7606 vdd.P5.pSD vout.$398.Metal1 0.0382707f
Cred_7607 vdd.P5.pSD vout.$586.Metal2 0.0351864f
Cred_7608 vdd.P5.pSD vout.$588.Metal2 0.0342121f
Cred_7609 vdd.P5.pSD vout.$606.Metal2 0.0275093f
Cred_7610 vdd.P5.pSD vout.$608.Metal2 0.0275213f
Cred_7611 vdd.P5.pSD vout.$646.Metal2 0.0256976f
Cred_7612 vdd.P5.pSD vout.$648.Metal2 0.0261308f
Cred_7613 vdd.P5.pSD vout.$666.Metal2 0.0171266f
Cred_7614 vdd.P5.pSD vout.$668.Metal2 0.0163005f
Cred_7615 vdd.P5.pSD vout.$686.Metal2 0.0164061f
Cred_7616 vdd.P5.pSD vout.$688.Metal2 0.0162392f
Cred_7617 vdd.P5.pSD vout.$706.Metal2 0.0163446f
Cred_7618 vdd.P5.pSD vout.$708.Metal2 0.0160064f
Cred_7619 vdd.P5.pSD vout.$726.Metal2 0.0219934f
Cred_7620 vdd.P5.pSD vout.$728.Metal2 0.0215407f
Cred_7621 vdd.P5.pSD vout.$766.Metal2 0.0196319f
Cred_7622 vdd.P5.pSD vout.$768.Metal2 0.0192282f
Cred_7623 vdd.P5.pSD vout.$786.Metal2 0.0186119f
Cred_7624 vdd.P5.pSD vout.$788.Metal2 0.0180752f
Cred_7625 vdd.P5.pSD vout.P2.pSD 0.00101906f
Cred_7626 vdd.P5.pSD vout.P4.pSD 0.00100462f
Cred_7627 vdd.P5.pSD vss 0.00234517f
Cred_7628 vdd.P5.pSD vss.$1211.Metal5 0.00084737f
Cred_7629 vdd.P5.pSD vss.$1229.Metal5 0.00084737f
Cred_7630 vdd.P5.pSD vss.$1281.Metal5 0.00324356f
Cred_7631 vdd.P5.pSD vss.$1299.Metal5 0.00324356f
Cred_7632 vdd.P7.pSD vout.$1036.Metal3 0.00552724f
Cred_7633 vdd.P7.pSD vout.$1038.Metal3 0.00634086f
Cred_7634 vdd.P7.pSD vout.$1076.Metal3 0.00296135f
Cred_7635 vdd.P7.pSD vout.$1078.Metal3 0.00312859f
Cred_7636 vdd.P7.pSD vout.$1116.Metal3 0.00276876f
Cred_7637 vdd.P7.pSD vout.$1118.Metal3 0.00278894f
Cred_7638 vdd.P7.pSD vout.$1156.Metal3 0.00445494f
Cred_7639 vdd.P7.pSD vout.$1158.Metal3 0.00439426f
Cred_7640 vdd.P7.pSD vout.$1330.Metal4 0.00183343f
Cred_7641 vdd.P7.pSD vout.$1331.Metal4 0.00189381f
Cred_7642 vdd.P7.pSD vout.$1370.Metal4 0.0141022f
Cred_7643 vdd.P7.pSD vout.$1371.Metal4 0.00886794f
Cred_7644 vdd.P7.pSD vout.$158.Metal1 0.0426445f
Cred_7645 vdd.P7.pSD vout.$159.Metal1 0.0421699f
Cred_7646 vdd.P7.pSD vout.$208.Metal1 0.0392933f
Cred_7647 vdd.P7.pSD vout.$209.Metal1 0.0383934f
Cred_7648 vdd.P7.pSD vout.$228.Metal1 0.0286216f
Cred_7649 vdd.P7.pSD vout.$229.Metal1 0.0291466f
Cred_7650 vdd.P7.pSD vout.$268.Metal1 0.0279877f
Cred_7651 vdd.P7.pSD vout.$269.Metal1 0.0286718f
Cred_7652 vdd.P7.pSD vout.$288.Metal1 0.0279853f
Cred_7653 vdd.P7.pSD vout.$289.Metal1 0.0281718f
Cred_7654 vdd.P7.pSD vout.$328.Metal1 0.0280294f
Cred_7655 vdd.P7.pSD vout.$329.Metal1 0.0275027f
Cred_7656 vdd.P7.pSD vout.$348.Metal1 0.0363196f
Cred_7657 vdd.P7.pSD vout.$349.Metal1 0.0356467f
Cred_7658 vdd.P7.pSD vout.$398.Metal1 0.0388799f
Cred_7659 vdd.P7.pSD vout.$399.Metal1 0.0382664f
Cred_7660 vdd.P7.pSD vout.$588.Metal2 0.0355572f
Cred_7661 vdd.P7.pSD vout.$590.Metal2 0.0346205f
Cred_7662 vdd.P7.pSD vout.$608.Metal2 0.027508f
Cred_7663 vdd.P7.pSD vout.$610.Metal2 0.0275201f
Cred_7664 vdd.P7.pSD vout.$648.Metal2 0.0265651f
Cred_7665 vdd.P7.pSD vout.$650.Metal2 0.0261326f
Cred_7666 vdd.P7.pSD vout.$668.Metal2 0.0171241f
Cred_7667 vdd.P7.pSD vout.$670.Metal2 0.0167114f
Cred_7668 vdd.P7.pSD vout.$688.Metal2 0.0164023f
Cred_7669 vdd.P7.pSD vout.$690.Metal2 0.0162355f
Cred_7670 vdd.P7.pSD vout.$708.Metal2 0.0163404f
Cred_7671 vdd.P7.pSD vout.$710.Metal2 0.0160023f
Cred_7672 vdd.P7.pSD vout.$728.Metal2 0.0219868f
Cred_7673 vdd.P7.pSD vout.$730.Metal2 0.0215343f
Cred_7674 vdd.P7.pSD vout.$768.Metal2 0.0196249f
Cred_7675 vdd.P7.pSD vout.$770.Metal2 0.0192214f
Cred_7676 vdd.P7.pSD vout.$788.Metal2 0.018606f
Cred_7677 vdd.P7.pSD vout.$790.Metal2 0.0180661f
Cred_7678 vdd.P7.pSD vout.P4.pSD 0.00102723f
Cred_7679 vdd.P7.pSD vout.P6.pSD 0.0010109f
Cred_7680 vdd.P7.pSD vss 0.00230795f
Cred_7681 vdd.P7.pSD vss.$1211.Metal5 0.000786278f
Cred_7682 vdd.P7.pSD vss.$1229.Metal5 0.000786278f
Cred_7683 vdd.P7.pSD vss.$1281.Metal5 0.00300971f
Cred_7684 vdd.P7.pSD vss.$1299.Metal5 0.00300971f
Cred_7685 vout vref 1.02224f
Cred_7686 vout vref.P0.GatPoly 0.0350839f
Cred_7687 vout vref.P0.nSD 0.0640087f
Cred_7688 vout vref.P0.pSD 0.119891f
Cred_7689 vout vss 0.332642f
Cred_7690 vout vss.$1211.Metal5 0.15665f
Cred_7691 vout vss.$1229.Metal5 0.15665f
Cred_7692 vout vss.$127.Metal1 6.99597e-05f
Cred_7693 vout vss.$1281.Metal5 0.599624f
Cred_7694 vout vss.$1299.Metal5 0.599624f
Cred_7695 vout vss.$406.Metal1 0.00265114f
Cred_7696 vout vss.$457.Metal2 1.02175e-06f
Cred_7697 vout vss.P0.GatPoly 2.50113e-06f
Cred_7698 vout vss.P0.pSD 0.00700631f
Cred_7699 vout.$1002.Metal3 vref 0.0192235f
Cred_7700 vout.$1002.Metal3 vref.P0.GatPoly 0.000749609f
Cred_7701 vout.$1002.Metal3 vref.P0.nSD 0.00429726f
Cred_7702 vout.$1002.Metal3 vref.P0.pSD 0.0245299f
Cred_7703 vout.$1002.Metal3 vss 0.00111694f
Cred_7704 vout.$1002.Metal3 vss.$1211.Metal5 0.000407566f
Cred_7705 vout.$1002.Metal3 vss.$1229.Metal5 0.000407566f
Cred_7706 vout.$1002.Metal3 vss.$1281.Metal5 0.00156008f
Cred_7707 vout.$1002.Metal3 vss.$1299.Metal5 0.00156008f
Cred_7708 vout.$1010.Metal3 vss 0.005268f
Cred_7709 vout.$1010.Metal3 vss.$1211.Metal5 0.00192227f
Cred_7710 vout.$1010.Metal3 vss.$1229.Metal5 0.00192227f
Cred_7711 vout.$1010.Metal3 vss.$1281.Metal5 0.00735805f
Cred_7712 vout.$1010.Metal3 vss.$1299.Metal5 0.00735805f
Cred_7713 vout.$1032.Metal3 vref 0.000127264f
Cred_7714 vout.$1032.Metal3 vref.P0.GatPoly 4.96258e-06f
Cred_7715 vout.$1032.Metal3 vref.P0.nSD 2.84488e-05f
Cred_7716 vout.$1032.Metal3 vref.P0.pSD 8.64219e-05f
Cred_7717 vout.$1032.Metal3 vss 0.0124057f
Cred_7718 vout.$1032.Metal3 vss.$1211.Metal5 0.00455222f
Cred_7719 vout.$1032.Metal3 vss.$1229.Metal5 0.00455222f
Cred_7720 vout.$1032.Metal3 vss.$1281.Metal5 0.017425f
Cred_7721 vout.$1032.Metal3 vss.$1299.Metal5 0.017425f
Cred_7722 vout.$1034.Metal3 vref 0.000160095f
Cred_7723 vout.$1034.Metal3 vref.P0.GatPoly 6.24282e-06f
Cred_7724 vout.$1034.Metal3 vref.P0.nSD 3.5788e-05f
Cred_7725 vout.$1034.Metal3 vref.P0.pSD 0.000108688f
Cred_7726 vout.$1034.Metal3 vss 0.00577238f
Cred_7727 vout.$1034.Metal3 vss.$1211.Metal5 0.00213176f
Cred_7728 vout.$1034.Metal3 vss.$1229.Metal5 0.00213176f
Cred_7729 vout.$1034.Metal3 vss.$1281.Metal5 0.00815995f
Cred_7730 vout.$1034.Metal3 vss.$1299.Metal5 0.00815995f
Cred_7731 vout.$1036.Metal3 vref 0.000216249f
Cred_7732 vout.$1036.Metal3 vref.P0.GatPoly 8.43249e-06f
Cred_7733 vout.$1036.Metal3 vref.P0.nSD 4.83407e-05f
Cred_7734 vout.$1036.Metal3 vref.P0.pSD 0.000146762f
Cred_7735 vout.$1036.Metal3 vss 0.00581856f
Cred_7736 vout.$1036.Metal3 vss.$1211.Metal5 0.00212316f
Cred_7737 vout.$1036.Metal3 vss.$1229.Metal5 0.00212316f
Cred_7738 vout.$1036.Metal3 vss.$1281.Metal5 0.00812704f
Cred_7739 vout.$1036.Metal3 vss.$1299.Metal5 0.00812704f
Cred_7740 vout.$1038.Metal3 vref 0.000333235f
Cred_7741 vout.$1038.Metal3 vref.P0.GatPoly 1.29943e-05f
Cred_7742 vout.$1038.Metal3 vref.P0.nSD 7.44919e-05f
Cred_7743 vout.$1038.Metal3 vref.P0.pSD 0.000226007f
Cred_7744 vout.$1038.Metal3 vss 0.00582211f
Cred_7745 vout.$1038.Metal3 vss.$1211.Metal5 0.00212446f
Cred_7746 vout.$1038.Metal3 vss.$1229.Metal5 0.00212446f
Cred_7747 vout.$1038.Metal3 vss.$1281.Metal5 0.00813199f
Cred_7748 vout.$1038.Metal3 vss.$1299.Metal5 0.00813199f
Cred_7749 vout.$1040.Metal3 vref 0.0357159f
Cred_7750 vout.$1040.Metal3 vref.P0.GatPoly 0.00139272f
Cred_7751 vout.$1040.Metal3 vref.P0.nSD 0.00798399f
Cred_7752 vout.$1040.Metal3 vref.P0.pSD 0.0456907f
Cred_7753 vout.$1040.Metal3 vss 0.0053912f
Cred_7754 vout.$1040.Metal3 vss.$1211.Metal5 0.00196722f
Cred_7755 vout.$1040.Metal3 vss.$1229.Metal5 0.00196722f
Cred_7756 vout.$1040.Metal3 vss.$1281.Metal5 0.00753012f
Cred_7757 vout.$1040.Metal3 vss.$1299.Metal5 0.00753012f
Cred_7758 vout.$1042.Metal3 vref 0.0149362f
Cred_7759 vout.$1042.Metal3 vref.P0.GatPoly 0.000582426f
Cred_7760 vout.$1042.Metal3 vref.P0.nSD 0.00333886f
Cred_7761 vout.$1042.Metal3 vref.P0.pSD 0.0198789f
Cred_7762 vout.$1042.Metal3 vss 0.00114057f
Cred_7763 vout.$1042.Metal3 vss.$1211.Metal5 0.000416187f
Cred_7764 vout.$1042.Metal3 vss.$1229.Metal5 0.000416187f
Cred_7765 vout.$1042.Metal3 vss.$1281.Metal5 0.00159308f
Cred_7766 vout.$1042.Metal3 vss.$1299.Metal5 0.00159308f
Cred_7767 vout.$1050.Metal3 vss 0.00339655f
Cred_7768 vout.$1050.Metal3 vss.$1211.Metal5 0.00123939f
Cred_7769 vout.$1050.Metal3 vss.$1229.Metal5 0.00123939f
Cred_7770 vout.$1050.Metal3 vss.$1281.Metal5 0.00474411f
Cred_7771 vout.$1050.Metal3 vss.$1299.Metal5 0.00474411f
Cred_7772 vout.$1070.Metal3 vss 0.00335332f
Cred_7773 vout.$1070.Metal3 vss.$1211.Metal5 0.00122361f
Cred_7774 vout.$1070.Metal3 vss.$1229.Metal5 0.00122361f
Cred_7775 vout.$1070.Metal3 vss.$1281.Metal5 0.00468373f
Cred_7776 vout.$1070.Metal3 vss.$1299.Metal5 0.00468373f
Cred_7777 vout.$1072.Metal3 vref 4.66548e-05f
Cred_7778 vout.$1072.Metal3 vref.P0.GatPoly 1.81927e-06f
Cred_7779 vout.$1072.Metal3 vref.P0.nSD 1.04293e-05f
Cred_7780 vout.$1072.Metal3 vref.P0.pSD 3.34835e-05f
Cred_7781 vout.$1072.Metal3 vss 0.00587816f
Cred_7782 vout.$1072.Metal3 vss.$1211.Metal5 0.00214491f
Cred_7783 vout.$1072.Metal3 vss.$1229.Metal5 0.00214491f
Cred_7784 vout.$1072.Metal3 vss.$1281.Metal5 0.00821027f
Cred_7785 vout.$1072.Metal3 vss.$1299.Metal5 0.00821027f
Cred_7786 vout.$1074.Metal3 vref 5.79617e-05f
Cred_7787 vout.$1074.Metal3 vref.P0.GatPoly 2.26018e-06f
Cred_7788 vout.$1074.Metal3 vref.P0.nSD 1.29569e-05f
Cred_7789 vout.$1074.Metal3 vref.P0.pSD 4.15977e-05f
Cred_7790 vout.$1074.Metal3 vss 0.00245046f
Cred_7791 vout.$1074.Metal3 vss.$1211.Metal5 0.000894159f
Cred_7792 vout.$1074.Metal3 vss.$1229.Metal5 0.000894159f
Cred_7793 vout.$1074.Metal3 vss.$1281.Metal5 0.00342266f
Cred_7794 vout.$1074.Metal3 vss.$1299.Metal5 0.00342266f
Cred_7795 vout.$1076.Metal3 vref 7.74094e-05f
Cred_7796 vout.$1076.Metal3 vref.P0.GatPoly 3.01853e-06f
Cred_7797 vout.$1076.Metal3 vref.P0.nSD 1.73042e-05f
Cred_7798 vout.$1076.Metal3 vref.P0.pSD 5.55547e-05f
Cred_7799 vout.$1076.Metal3 vss 0.00245046f
Cred_7800 vout.$1076.Metal3 vss.$1211.Metal5 0.000894159f
Cred_7801 vout.$1076.Metal3 vss.$1229.Metal5 0.000894159f
Cred_7802 vout.$1076.Metal3 vss.$1281.Metal5 0.00342266f
Cred_7803 vout.$1076.Metal3 vss.$1299.Metal5 0.00342266f
Cred_7804 vout.$1078.Metal3 vref 0.000116497f
Cred_7805 vout.$1078.Metal3 vref.P0.GatPoly 4.54274e-06f
Cred_7806 vout.$1078.Metal3 vref.P0.nSD 2.6042e-05f
Cred_7807 vout.$1078.Metal3 vref.P0.pSD 8.36071e-05f
Cred_7808 vout.$1078.Metal3 vss 0.00245046f
Cred_7809 vout.$1078.Metal3 vss.$1211.Metal5 0.000894159f
Cred_7810 vout.$1078.Metal3 vss.$1229.Metal5 0.000894159f
Cred_7811 vout.$1078.Metal3 vss.$1281.Metal5 0.00342266f
Cred_7812 vout.$1078.Metal3 vss.$1299.Metal5 0.00342266f
Cred_7813 vout.$1080.Metal3 vref 0.0113833f
Cred_7814 vout.$1080.Metal3 vref.P0.GatPoly 0.000443885f
Cred_7815 vout.$1080.Metal3 vref.P0.nSD 0.00254464f
Cred_7816 vout.$1080.Metal3 vref.P0.pSD 0.0150555f
Cred_7817 vout.$1080.Metal3 vss 0.00202893f
Cred_7818 vout.$1080.Metal3 vss.$1211.Metal5 0.000740347f
Cred_7819 vout.$1080.Metal3 vss.$1229.Metal5 0.000740347f
Cred_7820 vout.$1080.Metal3 vss.$1281.Metal5 0.0028339f
Cred_7821 vout.$1080.Metal3 vss.$1299.Metal5 0.0028339f
Cred_7822 vout.$1082.Metal3 vref 0.0102365f
Cred_7823 vout.$1082.Metal3 vref.P0.GatPoly 0.000399167f
Cred_7824 vout.$1082.Metal3 vref.P0.nSD 0.00228829f
Cred_7825 vout.$1082.Metal3 vref.P0.pSD 0.0138307f
Cred_7826 vout.$1082.Metal3 vss 0.00103965f
Cred_7827 vout.$1082.Metal3 vss.$1211.Metal5 0.000379364f
Cred_7828 vout.$1082.Metal3 vss.$1229.Metal5 0.000379364f
Cred_7829 vout.$1082.Metal3 vss.$1281.Metal5 0.00145213f
Cred_7830 vout.$1082.Metal3 vss.$1299.Metal5 0.00145213f
Cred_7831 vout.$11.Metal1 vss 2.63722e-08f
Cred_7832 vout.$11.Metal1 vss.$10.Metal1 0.00370613f
Cred_7833 vout.$11.Metal1 vss.$1009.Metal4 1.16829e-07f
Cred_7834 vout.$11.Metal1 vss.$1011.Metal4 7.57122e-07f
Cred_7835 vout.$11.Metal1 vss.$1013.Metal4 2.3668e-07f
Cred_7836 vout.$11.Metal1 vss.$1211.Metal5 2.71979e-08f
Cred_7837 vout.$11.Metal1 vss.$1229.Metal5 2.71979e-08f
Cred_7838 vout.$11.Metal1 vss.$1281.Metal5 3.63525e-05f
Cred_7839 vout.$11.Metal1 vss.$1299.Metal5 1.04108e-07f
Cred_7840 vout.$11.Metal1 vss.$13.Metal1 0.00104796f
Cred_7841 vout.$11.Metal1 vss.$461.Metal2 0.000124515f
Cred_7842 vout.$11.Metal1 vss.$463.Metal2 0.0336432f
Cred_7843 vout.$11.Metal1 vss.$467.Metal2 0.0140387f
Cred_7844 vout.$11.Metal1 vss.$469.Metal2 0.0315814f
Cred_7845 vout.$11.Metal1 vss.$799.Metal3 7.57769e-05f
Cred_7846 vout.$11.Metal1 vss.$801.Metal3 2.70848e-06f
Cred_7847 vout.$11.Metal1 vss.$805.Metal3 1.07395e-08f
Cred_7848 vout.$11.Metal1 vss.P0.nSD 1.77202e-05f
Cred_7849 vout.$11.Metal1 vss.P0.pSD 9.53561e-06f
Cred_7850 vout.$11.Metal1 vss.P1.nSD 0.0330858f
Cred_7851 vout.$11.Metal1 vss.P3.nSD 0.032329f
Cred_7852 vout.$1100.Metal3 vss 0.000735222f
Cred_7853 vout.$1100.Metal3 vss.$1211.Metal5 0.000268279f
Cred_7854 vout.$1100.Metal3 vss.$1229.Metal5 0.000268279f
Cred_7855 vout.$1100.Metal3 vss.$1281.Metal5 0.00102692f
Cred_7856 vout.$1100.Metal3 vss.$1299.Metal5 0.00102692f
Cred_7857 vout.$1110.Metal3 vss 0.00443141f
Cred_7858 vout.$1110.Metal3 vss.$1211.Metal5 0.001617f
Cred_7859 vout.$1110.Metal3 vss.$1229.Metal5 0.001617f
Cred_7860 vout.$1110.Metal3 vss.$1281.Metal5 0.00618954f
Cred_7861 vout.$1110.Metal3 vss.$1299.Metal5 0.00618954f
Cred_7862 vout.$1112.Metal3 vss 0.00521242f
Cred_7863 vout.$1112.Metal3 vss.$1211.Metal5 0.00176205f
Cred_7864 vout.$1112.Metal3 vss.$1229.Metal5 0.00176205f
Cred_7865 vout.$1112.Metal3 vss.$1281.Metal5 0.00674477f
Cred_7866 vout.$1112.Metal3 vss.$1299.Metal5 0.00674477f
Cred_7867 vout.$1114.Metal3 vss 0.000302305f
Cred_7868 vout.$1114.Metal3 vss.$1211.Metal5 0.00011031f
Cred_7869 vout.$1114.Metal3 vss.$1229.Metal5 0.00011031f
Cred_7870 vout.$1114.Metal3 vss.$1281.Metal5 0.000422243f
Cred_7871 vout.$1114.Metal3 vss.$1299.Metal5 0.000422243f
Cred_7872 vout.$1116.Metal3 vss 0.000302305f
Cred_7873 vout.$1116.Metal3 vss.$1211.Metal5 0.00011031f
Cred_7874 vout.$1116.Metal3 vss.$1229.Metal5 0.00011031f
Cred_7875 vout.$1116.Metal3 vss.$1281.Metal5 0.000422243f
Cred_7876 vout.$1116.Metal3 vss.$1299.Metal5 0.000422243f
Cred_7877 vout.$1118.Metal3 vss 0.000302305f
Cred_7878 vout.$1118.Metal3 vss.$1211.Metal5 0.00011031f
Cred_7879 vout.$1118.Metal3 vss.$1229.Metal5 0.00011031f
Cred_7880 vout.$1118.Metal3 vss.$1281.Metal5 0.000422243f
Cred_7881 vout.$1118.Metal3 vss.$1299.Metal5 0.000422243f
Cred_7882 vout.$1122.Metal3 vss 0.000209234f
Cred_7883 vout.$1122.Metal3 vss.$1211.Metal5 7.63485e-05f
Cred_7884 vout.$1122.Metal3 vss.$1229.Metal5 7.63485e-05f
Cred_7885 vout.$1122.Metal3 vss.$1281.Metal5 0.000292247f
Cred_7886 vout.$1122.Metal3 vss.$1299.Metal5 0.000292247f
Cred_7887 vout.$1150.Metal3 vss 0.00443141f
Cred_7888 vout.$1150.Metal3 vss.$1211.Metal5 0.001617f
Cred_7889 vout.$1150.Metal3 vss.$1229.Metal5 0.001617f
Cred_7890 vout.$1150.Metal3 vss.$1281.Metal5 0.00618954f
Cred_7891 vout.$1150.Metal3 vss.$1299.Metal5 0.00618954f
Cred_7892 vout.$1152.Metal3 vss 0.0201332f
Cred_7893 vout.$1152.Metal3 vss.$1211.Metal5 0.00204347f
Cred_7894 vout.$1152.Metal3 vss.$1229.Metal5 0.00204347f
Cred_7895 vout.$1152.Metal3 vss.$1281.Metal5 0.00782197f
Cred_7896 vout.$1152.Metal3 vss.$1299.Metal5 0.00782197f
Cred_7897 vout.$1190.Metal3 vss 0.00728293f
Cred_7898 vout.$1190.Metal3 vss.$1211.Metal5 0.00265751f
Cred_7899 vout.$1190.Metal3 vss.$1229.Metal5 0.00265751f
Cred_7900 vout.$1190.Metal3 vss.$1281.Metal5 0.0101724f
Cred_7901 vout.$1190.Metal3 vss.$1299.Metal5 0.0101724f
Cred_7902 vout.$12.Metal1 vss.$1281.Metal5 1.0906e-06f
Cred_7903 vout.$12.Metal1 vss.$13.Metal1 0.00398408f
Cred_7904 vout.$12.Metal1 vss.$467.Metal2 0.00761223f
Cred_7905 vout.$12.Metal1 vss.$469.Metal2 0.0314506f
Cred_7906 vout.$12.Metal1 vss.$473.Metal2 0.0276483f
Cred_7907 vout.$12.Metal1 vss.$475.Metal2 0.0114199f
Cred_7908 vout.$12.Metal1 vss.$805.Metal3 6.89002e-06f
Cred_7909 vout.$12.Metal1 vss.P3.nSD 0.0321687f
Cred_7910 vout.$12.Metal1 vss.P5.nSD 0.0321867f
Cred_7911 vout.$1208.Metal3 vss 0.000256267f
Cred_7912 vout.$1208.Metal3 vss.$1211.Metal5 9.35104e-05f
Cred_7913 vout.$1208.Metal3 vss.$1229.Metal5 9.35104e-05f
Cred_7914 vout.$1208.Metal3 vss.$1281.Metal5 0.000357939f
Cred_7915 vout.$1208.Metal3 vss.$1299.Metal5 0.000357939f
Cred_7916 vout.$121.Metal1 vref 1.17875e-07f
Cred_7917 vout.$121.Metal1 vref.P0.GatPoly 4.59645e-09f
Cred_7918 vout.$121.Metal1 vref.P0.nSD 3.82288e-08f
Cred_7919 vout.$121.Metal1 vref.P0.pSD 4.61845e-08f
Cred_7920 vout.$121.Metal1 vss 6.13574e-06f
Cred_7921 vout.$121.Metal1 vss.$10.Metal1 7.2335e-05f
Cred_7922 vout.$121.Metal1 vss.$1211.Metal5 6.32783e-06f
Cred_7923 vout.$121.Metal1 vss.$1229.Metal5 6.32783e-06f
Cred_7924 vout.$121.Metal1 vss.$127.Metal1 0.000232352f
Cred_7925 vout.$121.Metal1 vss.$1281.Metal5 2.42217e-05f
Cred_7926 vout.$121.Metal1 vss.$1299.Metal5 2.42217e-05f
Cred_7927 vout.$121.Metal1 vss.$406.Metal1 0.000112912f
Cred_7928 vout.$121.Metal1 vss.$457.Metal2 3.39347e-06f
Cred_7929 vout.$121.Metal1 vss.$461.Metal2 0.000107326f
Cred_7930 vout.$121.Metal1 vss.$463.Metal2 0.0328819f
Cred_7931 vout.$121.Metal1 vss.$467.Metal2 0.0136789f
Cred_7932 vout.$121.Metal1 vss.$469.Metal2 0.0311191f
Cred_7933 vout.$121.Metal1 vss.$799.Metal3 7.2335e-05f
Cred_7934 vout.$121.Metal1 vss.P0.GatPoly 8.3068e-06f
Cred_7935 vout.$121.Metal1 vss.P0.nSD 3.07815e-05f
Cred_7936 vout.$121.Metal1 vss.P0.pSD 0.00331932f
Cred_7937 vout.$121.Metal1 vss.P1.nSD 0.0334484f
Cred_7938 vout.$121.Metal1 vss.P3.nSD 0.0329585f
Cred_7939 vout.$122.Metal1 vref 2.50107e-07f
Cred_7940 vout.$122.Metal1 vref.P0.GatPoly 9.75275e-09f
Cred_7941 vout.$122.Metal1 vref.P0.nSD 8.11746e-08f
Cred_7942 vout.$122.Metal1 vref.P0.pSD 9.79943e-08f
Cred_7943 vout.$122.Metal1 vss 6.13439e-06f
Cred_7944 vout.$122.Metal1 vss.$1211.Metal5 6.32644e-06f
Cred_7945 vout.$122.Metal1 vss.$1229.Metal5 6.32644e-06f
Cred_7946 vout.$122.Metal1 vss.$127.Metal1 0.000179931f
Cred_7947 vout.$122.Metal1 vss.$1281.Metal5 2.42163e-05f
Cred_7948 vout.$122.Metal1 vss.$1299.Metal5 2.42163e-05f
Cred_7949 vout.$122.Metal1 vss.$406.Metal1 0.00014606f
Cred_7950 vout.$122.Metal1 vss.$457.Metal2 2.62786e-06f
Cred_7951 vout.$122.Metal1 vss.$467.Metal2 0.00744301f
Cred_7952 vout.$122.Metal1 vss.$469.Metal2 0.0307024f
Cred_7953 vout.$122.Metal1 vss.$473.Metal2 0.0273468f
Cred_7954 vout.$122.Metal1 vss.$475.Metal2 0.0113159f
Cred_7955 vout.$122.Metal1 vss.P0.GatPoly 6.4327e-06f
Cred_7956 vout.$122.Metal1 vss.P0.pSD 0.00334123f
Cred_7957 vout.$122.Metal1 vss.P3.nSD 0.0325187f
Cred_7958 vout.$122.Metal1 vss.P5.nSD 0.0329775f
Cred_7959 vout.$123.Metal1 vref 3.37957e-07f
Cred_7960 vout.$123.Metal1 vref.P0.GatPoly 1.31784e-08f
Cred_7961 vout.$123.Metal1 vref.P0.nSD 1.09675e-07f
Cred_7962 vout.$123.Metal1 vref.P0.pSD 1.32415e-07f
Cred_7963 vout.$123.Metal1 vss 3.92538e-06f
Cred_7964 vout.$123.Metal1 vss.$1211.Metal5 4.04828e-06f
Cred_7965 vout.$123.Metal1 vss.$1229.Metal5 4.04828e-06f
Cred_7966 vout.$123.Metal1 vss.$127.Metal1 0.000139443f
Cred_7967 vout.$123.Metal1 vss.$1281.Metal5 1.61959e-05f
Cred_7968 vout.$123.Metal1 vss.$1299.Metal5 1.5496e-05f
Cred_7969 vout.$123.Metal1 vss.$136.Metal1 4.94556e-05f
Cred_7970 vout.$123.Metal1 vss.$406.Metal1 0.000188895f
Cred_7971 vout.$123.Metal1 vss.$457.Metal2 2.03655e-06f
Cred_7972 vout.$123.Metal1 vss.$473.Metal2 0.0269693f
Cred_7973 vout.$123.Metal1 vss.$475.Metal2 0.0153541f
Cred_7974 vout.$123.Metal1 vss.$479.Metal2 0.0343729f
Cred_7975 vout.$123.Metal1 vss.$811.Metal3 4.94556e-05f
Cred_7976 vout.$123.Metal1 vss.P0.GatPoly 4.98523e-06f
Cred_7977 vout.$123.Metal1 vss.P0.pSD 0.00334092f
Cred_7978 vout.$123.Metal1 vss.P5.nSD 0.0325332f
Cred_7979 vout.$123.Metal1 vss.P7.nSD 0.0329739f
Cred_7980 vout.$1235.Metal4 vref 0.00377204f
Cred_7981 vout.$1235.Metal4 vref.P0.GatPoly 0.000147088f
Cred_7982 vout.$1235.Metal4 vref.P0.nSD 0.00123181f
Cred_7983 vout.$1235.Metal4 vref.P0.pSD 0.00147792f
Cred_7984 vout.$1235.Metal4 vss 0.0185334f
Cred_7985 vout.$1235.Metal4 vss.$10.Metal1 0.000693447f
Cred_7986 vout.$1235.Metal4 vss.$1009.Metal4 0.00285541f
Cred_7987 vout.$1235.Metal4 vss.$1011.Metal4 0.0185048f
Cred_7988 vout.$1235.Metal4 vss.$1013.Metal4 0.0214761f
Cred_7989 vout.$1235.Metal4 vss.$1015.Metal4 0.022534f
Cred_7990 vout.$1235.Metal4 vss.$1017.Metal4 0.0178881f
Cred_7991 vout.$1235.Metal4 vss.$1211.Metal5 0.0191136f
Cred_7992 vout.$1235.Metal4 vss.$1229.Metal5 0.0191136f
Cred_7993 vout.$1235.Metal4 vss.$127.Metal1 2.38701e-09f
Cred_7994 vout.$1235.Metal4 vss.$1281.Metal5 0.293468f
Cred_7995 vout.$1235.Metal4 vss.$1299.Metal5 0.073163f
Cred_7996 vout.$1235.Metal4 vss.$13.Metal1 0.00163554f
Cred_7997 vout.$1235.Metal4 vss.$406.Metal1 1.93766e-09f
Cred_7998 vout.$1235.Metal4 vss.$457.Metal2 3.48619e-11f
Cred_7999 vout.$1235.Metal4 vss.$461.Metal2 0.00241216f
Cred_8000 vout.$1235.Metal4 vss.$463.Metal2 0.0045467f
Cred_8001 vout.$1235.Metal4 vss.$467.Metal2 0.00733293f
Cred_8002 vout.$1235.Metal4 vss.$469.Metal2 0.0219853f
Cred_8003 vout.$1235.Metal4 vss.$473.Metal2 0.0150816f
Cred_8004 vout.$1235.Metal4 vss.$475.Metal2 0.00492042f
Cred_8005 vout.$1235.Metal4 vss.$799.Metal3 0.000114597f
Cred_8006 vout.$1235.Metal4 vss.$801.Metal3 0.00600713f
Cred_8007 vout.$1235.Metal4 vss.$805.Metal3 0.00959075f
Cred_8008 vout.$1235.Metal4 vss.$809.Metal3 0.00218512f
Cred_8009 vout.$1235.Metal4 vss.P0.GatPoly 8.53378e-11f
Cred_8010 vout.$1235.Metal4 vss.P0.nSD 0.000371888f
Cred_8011 vout.$1235.Metal4 vss.P0.pSD 3.12831e-06f
Cred_8012 vout.$1235.Metal4 vss.P1.nSD 0.000753435f
Cred_8013 vout.$1235.Metal4 vss.P3.nSD 0.00503421f
Cred_8014 vout.$1235.Metal4 vss.P5.nSD 0.00431903f
Cred_8015 vout.$1236.Metal4 vref 0.00508477f
Cred_8016 vout.$1236.Metal4 vref.P0.GatPoly 0.000198277f
Cred_8017 vout.$1236.Metal4 vref.P0.nSD 0.00166027f
Cred_8018 vout.$1236.Metal4 vref.P0.pSD 0.00199226f
Cred_8019 vout.$1236.Metal4 vss 0.0110291f
Cred_8020 vout.$1236.Metal4 vss.$1017.Metal4 0.00467854f
Cred_8021 vout.$1236.Metal4 vss.$1019.Metal4 0.022534f
Cred_8022 vout.$1236.Metal4 vss.$1021.Metal4 0.022534f
Cred_8023 vout.$1236.Metal4 vss.$1023.Metal4 0.00632939f
Cred_8024 vout.$1236.Metal4 vss.$1211.Metal5 0.0113744f
Cred_8025 vout.$1236.Metal4 vss.$1229.Metal5 0.0113744f
Cred_8026 vout.$1236.Metal4 vss.$127.Metal1 1.84989e-09f
Cred_8027 vout.$1236.Metal4 vss.$1281.Metal5 0.209621f
Cred_8028 vout.$1236.Metal4 vss.$1299.Metal5 0.0435387f
Cred_8029 vout.$1236.Metal4 vss.$13.Metal1 0.00040795f
Cred_8030 vout.$1236.Metal4 vss.$136.Metal1 0.00226224f
Cred_8031 vout.$1236.Metal4 vss.$406.Metal1 2.50593e-09f
Cred_8032 vout.$1236.Metal4 vss.$457.Metal2 2.70174e-11f
Cred_8033 vout.$1236.Metal4 vss.$473.Metal2 0.0120727f
Cred_8034 vout.$1236.Metal4 vss.$475.Metal2 0.0108377f
Cred_8035 vout.$1236.Metal4 vss.$479.Metal2 0.0166139f
Cred_8036 vout.$1236.Metal4 vss.$805.Metal3 0.000581296f
Cred_8037 vout.$1236.Metal4 vss.$809.Metal3 0.00570602f
Cred_8038 vout.$1236.Metal4 vss.$811.Metal3 0.00592924f
Cred_8039 vout.$1236.Metal4 vss.$815.Metal3 0.000752265f
Cred_8040 vout.$1236.Metal4 vss.P0.GatPoly 6.61353e-11f
Cred_8041 vout.$1236.Metal4 vss.P0.pSD 3.91079e-06f
Cred_8042 vout.$1236.Metal4 vss.P5.nSD 0.00417596f
Cred_8043 vout.$1236.Metal4 vss.P7.nSD 0.00432032f
Cred_8044 vout.$1237.Metal4 vref 0.00780294f
Cred_8045 vout.$1237.Metal4 vref.P0.GatPoly 0.000304271f
Cred_8046 vout.$1237.Metal4 vref.P0.nSD 0.00254711f
Cred_8047 vout.$1237.Metal4 vref.P0.pSD 0.00305727f
Cred_8048 vout.$1237.Metal4 vss 0.00618585f
Cred_8049 vout.$1237.Metal4 vss.$1023.Metal4 0.0162365f
Cred_8050 vout.$1237.Metal4 vss.$1025.Metal4 0.022534f
Cred_8051 vout.$1237.Metal4 vss.$1027.Metal4 0.0173373f
Cred_8052 vout.$1237.Metal4 vss.$1211.Metal5 0.00637952f
Cred_8053 vout.$1237.Metal4 vss.$1229.Metal5 0.00637952f
Cred_8054 vout.$1237.Metal4 vss.$127.Metal1 1.43546e-09f
Cred_8055 vout.$1237.Metal4 vss.$1281.Metal5 0.245271f
Cred_8056 vout.$1237.Metal4 vss.$1299.Metal5 0.0244195f
Cred_8057 vout.$1237.Metal4 vss.$136.Metal1 2.14709e-05f
Cred_8058 vout.$1237.Metal4 vss.$138.Metal1 0.00119863f
Cred_8059 vout.$1237.Metal4 vss.$140.Metal1 2.62757e-05f
Cred_8060 vout.$1237.Metal4 vss.$406.Metal1 3.24039e-09f
Cred_8061 vout.$1237.Metal4 vss.$457.Metal2 2.09647e-11f
Cred_8062 vout.$1237.Metal4 vss.$475.Metal2 0.00182098f
Cred_8063 vout.$1237.Metal4 vss.$479.Metal2 0.0178183f
Cred_8064 vout.$1237.Metal4 vss.$483.Metal2 0.0176191f
Cred_8065 vout.$1237.Metal4 vss.$487.Metal2 0.00222848f
Cred_8066 vout.$1237.Metal4 vss.$811.Metal3 0.00197052f
Cred_8067 vout.$1237.Metal4 vss.$815.Metal3 0.00884826f
Cred_8068 vout.$1237.Metal4 vss.$819.Metal3 0.00211211f
Cred_8069 vout.$1237.Metal4 vss.P0.GatPoly 5.13191e-11f
Cred_8070 vout.$1237.Metal4 vss.P0.pSD 4.40224e-08f
Cred_8071 vout.$1237.Metal4 vss.P10.nSD 0.00432233f
Cred_8072 vout.$1237.Metal4 vss.P7.nSD 0.00417399f
Cred_8073 vout.$1238.Metal4 vref 0.0549402f
Cred_8074 vout.$1238.Metal4 vref.P0.GatPoly 0.00214236f
Cred_8075 vout.$1238.Metal4 vref.P0.nSD 0.0270438f
Cred_8076 vout.$1238.Metal4 vref.P0.pSD 0.0215261f
Cred_8077 vout.$1238.Metal4 vss 0.00355513f
Cred_8078 vout.$1238.Metal4 vss.$1027.Metal4 0.00522896f
Cred_8079 vout.$1238.Metal4 vss.$1029.Metal4 0.022534f
Cred_8080 vout.$1238.Metal4 vss.$1031.Metal4 0.022534f
Cred_8081 vout.$1238.Metal4 vss.$1033.Metal4 0.0282823f
Cred_8082 vout.$1238.Metal4 vss.$1037.Metal4 0.00571642f
Cred_8083 vout.$1238.Metal4 vss.$1211.Metal5 0.00366644f
Cred_8084 vout.$1238.Metal4 vss.$1229.Metal5 0.00366644f
Cred_8085 vout.$1238.Metal4 vss.$1246.Metal5 0.0390192f
Cred_8086 vout.$1238.Metal4 vss.$127.Metal1 1.11624e-09f
Cred_8087 vout.$1238.Metal4 vss.$1281.Metal5 0.332988f
Cred_8088 vout.$1238.Metal4 vss.$1299.Metal5 0.0230318f
Cred_8089 vout.$1238.Metal4 vss.$140.Metal1 0.00227009f
Cred_8090 vout.$1238.Metal4 vss.$143.Metal1 0.000437921f
Cred_8091 vout.$1238.Metal4 vss.$406.Metal1 4.18977e-09f
Cred_8092 vout.$1238.Metal4 vss.$457.Metal2 1.63025e-11f
Cred_8093 vout.$1238.Metal4 vss.$483.Metal2 0.0161012f
Cred_8094 vout.$1238.Metal4 vss.$487.Metal2 0.0146219f
Cred_8095 vout.$1238.Metal4 vss.$489.Metal2 0.0289486f
Cred_8096 vout.$1238.Metal4 vss.$493.Metal2 0.00884957f
Cred_8097 vout.$1238.Metal4 vss.$495.Metal2 0.00255174f
Cred_8098 vout.$1238.Metal4 vss.$815.Metal3 0.000649685f
Cred_8099 vout.$1238.Metal4 vss.$819.Metal3 0.00578456f
Cred_8100 vout.$1238.Metal4 vss.$821.Metal3 0.00875993f
Cred_8101 vout.$1238.Metal4 vss.$825.Metal3 0.00547838f
Cred_8102 vout.$1238.Metal4 vss.P0.GatPoly 3.99065e-11f
Cred_8103 vout.$1238.Metal4 vss.P0.pSD 3.92726e-06f
Cred_8104 vout.$1238.Metal4 vss.P10.nSD 0.00432488f
Cred_8105 vout.$1238.Metal4 vss.P11.nSD 0.00847034f
Cred_8106 vout.$1238.Metal4 vss.P13.nSD 0.00170109f
Cred_8107 vout.$1239.Metal4 vref 0.00243432f
Cred_8108 vout.$1239.Metal4 vref.P0.GatPoly 9.49248e-05f
Cred_8109 vout.$1239.Metal4 vref.P0.nSD 0.00384487f
Cred_8110 vout.$1239.Metal4 vref.P0.pSD 0.000953791f
Cred_8111 vout.$1239.Metal4 vss.$1033.Metal4 0.00565785f
Cred_8112 vout.$1239.Metal4 vss.$1037.Metal4 0.0282237f
Cred_8113 vout.$1239.Metal4 vss.$1039.Metal4 0.022534f
Cred_8114 vout.$1239.Metal4 vss.$1041.Metal4 0.022534f
Cred_8115 vout.$1239.Metal4 vss.$1043.Metal4 0.0052213f
Cred_8116 vout.$1239.Metal4 vss.$1246.Metal5 0.0236459f
Cred_8117 vout.$1239.Metal4 vss.$1299.Metal5 0.203048f
Cred_8118 vout.$1239.Metal4 vss.$143.Metal1 0.000437921f
Cred_8119 vout.$1239.Metal4 vss.$146.Metal1 0.000880316f
Cred_8120 vout.$1239.Metal4 vss.$487.Metal2 3.06529e-05f
Cred_8121 vout.$1239.Metal4 vss.$489.Metal2 0.0010342f
Cred_8122 vout.$1239.Metal4 vss.$493.Metal2 0.0164964f
Cred_8123 vout.$1239.Metal4 vss.$495.Metal2 0.00864553f
Cred_8124 vout.$1239.Metal4 vss.$499.Metal2 0.0105518f
Cred_8125 vout.$1239.Metal4 vss.$825.Metal3 0.00547769f
Cred_8126 vout.$1239.Metal4 vss.$829.Metal3 0.00875993f
Cred_8127 vout.$1239.Metal4 vss.$831.Metal3 0.00030602f
Cred_8128 vout.$1239.Metal4 vss.P0.pSD 3.88385e-06f
Cred_8129 vout.$1239.Metal4 vss.P11.nSD 2.1935e-05f
Cred_8130 vout.$1239.Metal4 vss.P13.nSD 0.00362184f
Cred_8131 vout.$1239.Metal4 vss.P15.nSD 0.00165736f
Cred_8132 vout.$124.Metal1 vref 5.21181e-07f
Cred_8133 vout.$124.Metal1 vref.P0.GatPoly 2.03231e-08f
Cred_8134 vout.$124.Metal1 vref.P0.nSD 1.69099e-07f
Cred_8135 vout.$124.Metal1 vref.P0.pSD 2.04204e-07f
Cred_8136 vout.$124.Metal1 vss 3.6948e-06f
Cred_8137 vout.$124.Metal1 vss.$1211.Metal5 3.81048e-06f
Cred_8138 vout.$124.Metal1 vss.$1229.Metal5 3.81048e-06f
Cred_8139 vout.$124.Metal1 vss.$127.Metal1 0.000108204f
Cred_8140 vout.$124.Metal1 vss.$1281.Metal5 2.36421e-05f
Cred_8141 vout.$124.Metal1 vss.$1299.Metal5 1.45857e-05f
Cred_8142 vout.$124.Metal1 vss.$136.Metal1 4.80038e-05f
Cred_8143 vout.$124.Metal1 vss.$140.Metal1 6.13713e-05f
Cred_8144 vout.$124.Metal1 vss.$406.Metal1 0.000244258f
Cred_8145 vout.$124.Metal1 vss.$457.Metal2 1.5803e-06f
Cred_8146 vout.$124.Metal1 vss.$475.Metal2 0.00407128f
Cred_8147 vout.$124.Metal1 vss.$479.Metal2 0.0333639f
Cred_8148 vout.$124.Metal1 vss.$483.Metal2 0.0339306f
Cred_8149 vout.$124.Metal1 vss.$487.Metal2 0.005205f
Cred_8150 vout.$124.Metal1 vss.$811.Metal3 4.80038e-05f
Cred_8151 vout.$124.Metal1 vss.$819.Metal3 6.13713e-05f
Cred_8152 vout.$124.Metal1 vss.P0.GatPoly 3.86839e-06f
Cred_8153 vout.$124.Metal1 vss.P0.pSD 0.00331837f
Cred_8154 vout.$124.Metal1 vss.P10.nSD 0.0335065f
Cred_8155 vout.$124.Metal1 vss.P7.nSD 0.032009f
Cred_8156 vout.$1240.Metal4 vss.$1043.Metal4 0.0173127f
Cred_8157 vout.$1240.Metal4 vss.$1045.Metal4 0.022534f
Cred_8158 vout.$1240.Metal4 vss.$1047.Metal4 0.0162135f
Cred_8159 vout.$1240.Metal4 vss.$1299.Metal5 0.15088f
Cred_8160 vout.$1240.Metal4 vss.$146.Metal1 1.90057e-05f
Cred_8161 vout.$1240.Metal4 vss.$148.Metal1 1.1724e-07f
Cred_8162 vout.$1240.Metal4 vss.$150.Metal1 1.53723e-05f
Cred_8163 vout.$1240.Metal4 vss.$495.Metal2 0.0016119f
Cred_8164 vout.$1240.Metal4 vss.$499.Metal2 0.0105128f
Cred_8165 vout.$1240.Metal4 vss.$503.Metal2 0.0106892f
Cred_8166 vout.$1240.Metal4 vss.$507.Metal2 0.00130374f
Cred_8167 vout.$1240.Metal4 vss.$831.Metal3 1.90057e-05f
Cred_8168 vout.$1240.Metal4 vss.$835.Metal3 0.00216856f
Cred_8169 vout.$1240.Metal4 vss.$839.Metal3 1.53723e-05f
Cred_8170 vout.$1240.Metal4 vss.P15.nSD 0.0016503f
Cred_8171 vout.$1240.Metal4 vss.P17.nSD 0.0016201f
Cred_8172 vout.$1241.Metal4 vss.$1047.Metal4 0.00632052f
Cred_8173 vout.$1241.Metal4 vss.$1049.Metal4 0.022534f
Cred_8174 vout.$1241.Metal4 vss.$1051.Metal4 0.022534f
Cred_8175 vout.$1241.Metal4 vss.$1053.Metal4 0.0223793f
Cred_8176 vout.$1241.Metal4 vss.$1055.Metal4 0.0223389f
Cred_8177 vout.$1241.Metal4 vss.$1057.Metal4 0.0155283f
Cred_8178 vout.$1241.Metal4 vss.$1299.Metal5 0.213981f
Cred_8179 vout.$1241.Metal4 vss.$150.Metal1 1.08553e-05f
Cred_8180 vout.$1241.Metal4 vss.$153.Metal1 2.40463e-08f
Cred_8181 vout.$1241.Metal4 vss.$503.Metal2 0.00753262f
Cred_8182 vout.$1241.Metal4 vss.$507.Metal2 0.00598638f
Cred_8183 vout.$1241.Metal4 vss.$509.Metal2 0.0122435f
Cred_8184 vout.$1241.Metal4 vss.$513.Metal2 0.00623297f
Cred_8185 vout.$1241.Metal4 vss.$515.Metal2 0.00151079f
Cred_8186 vout.$1241.Metal4 vss.$839.Metal3 8.61115e-05f
Cred_8187 vout.$1241.Metal4 vss.$841.Metal3 4.96601e-05f
Cred_8188 vout.$1241.Metal4 vss.$845.Metal3 0.00163338f
Cred_8189 vout.$1241.Metal4 vss.P0.pSD 1.48109e-11f
Cred_8190 vout.$1241.Metal4 vss.P17.nSD 0.000983237f
Cred_8191 vout.$1241.Metal4 vss.P19.nSD 0.00203257f
Cred_8192 vout.$1241.Metal4 vss.P21.nSD 0.000862467f
Cred_8193 vout.$125.Metal1 vref 1.84689e-05f
Cred_8194 vout.$125.Metal1 vref.P0.GatPoly 7.20183e-07f
Cred_8195 vout.$125.Metal1 vref.P0.nSD 1.53036e-05f
Cred_8196 vout.$125.Metal1 vref.P0.pSD 7.2363e-06f
Cred_8197 vout.$125.Metal1 vss 6.04093e-08f
Cred_8198 vout.$125.Metal1 vss.$1033.Metal4 1.78396e-10f
Cred_8199 vout.$125.Metal1 vss.$1037.Metal4 1.78396e-10f
Cred_8200 vout.$125.Metal1 vss.$1211.Metal5 6.23006e-08f
Cred_8201 vout.$125.Metal1 vss.$1229.Metal5 6.23006e-08f
Cred_8202 vout.$125.Metal1 vss.$1246.Metal5 4.68265e-08f
Cred_8203 vout.$125.Metal1 vss.$127.Metal1 8.4141e-05f
Cred_8204 vout.$125.Metal1 vss.$1281.Metal5 3.54888e-05f
Cred_8205 vout.$125.Metal1 vss.$1299.Metal5 2.38474e-07f
Cred_8206 vout.$125.Metal1 vss.$140.Metal1 5.99974e-05f
Cred_8207 vout.$125.Metal1 vss.$406.Metal1 0.000315821f
Cred_8208 vout.$125.Metal1 vss.$457.Metal2 1.22887e-06f
Cred_8209 vout.$125.Metal1 vss.$483.Metal2 0.033171f
Cred_8210 vout.$125.Metal1 vss.$487.Metal2 0.0142002f
Cred_8211 vout.$125.Metal1 vss.$489.Metal2 0.0282463f
Cred_8212 vout.$125.Metal1 vss.$819.Metal3 5.99974e-05f
Cred_8213 vout.$125.Metal1 vss.$825.Metal3 2.10344e-12f
Cred_8214 vout.$125.Metal1 vss.P0.GatPoly 3.00812e-06f
Cred_8215 vout.$125.Metal1 vss.P0.pSD 0.00327208f
Cred_8216 vout.$125.Metal1 vss.P10.nSD 0.0327605f
Cred_8217 vout.$125.Metal1 vss.P11.nSD 0.0318513f
Cred_8218 vout.$1252.Metal4 vss 0.00438501f
Cred_8219 vout.$1252.Metal4 vss.$1057.Metal4 0.00684432f
Cred_8220 vout.$1252.Metal4 vss.$1059.Metal4 0.0219062f
Cred_8221 vout.$1252.Metal4 vss.$1061.Metal4 0.00338027f
Cred_8222 vout.$1252.Metal4 vss.$1211.Metal5 0.00452229f
Cred_8223 vout.$1252.Metal4 vss.$1229.Metal5 0.00452229f
Cred_8224 vout.$1252.Metal4 vss.$1281.Metal5 0.0173104f
Cred_8225 vout.$1252.Metal4 vss.$1299.Metal5 0.133956f
Cred_8226 vout.$1252.Metal4 vss.$150.Metal1 4.89486e-07f
Cred_8227 vout.$1252.Metal4 vss.$153.Metal1 2.93487e-09f
Cred_8228 vout.$1252.Metal4 vss.$156.Metal1 1.02758e-05f
Cred_8229 vout.$1252.Metal4 vss.$503.Metal2 0.000340206f
Cred_8230 vout.$1252.Metal4 vss.$507.Metal2 0.000578686f
Cred_8231 vout.$1252.Metal4 vss.$509.Metal2 0.00129817f
Cred_8232 vout.$1252.Metal4 vss.$513.Metal2 0.00796808f
Cred_8233 vout.$1252.Metal4 vss.$515.Metal2 0.00280352f
Cred_8234 vout.$1252.Metal4 vss.$519.Metal2 0.00491738f
Cred_8235 vout.$1252.Metal4 vss.$521.Metal2 0.00321294f
Cred_8236 vout.$1252.Metal4 vss.$839.Metal3 4.89486e-07f
Cred_8237 vout.$1252.Metal4 vss.$849.Metal3 7.2755e-05f
Cred_8238 vout.$1252.Metal4 vss.$851.Metal3 5.39185e-05f
Cred_8239 vout.$1252.Metal4 vss.P0.pSD 2.67051e-11f
Cred_8240 vout.$1252.Metal4 vss.P17.nSD 6.3836e-05f
Cred_8241 vout.$1252.Metal4 vss.P19.nSD 0.000306343f
Cred_8242 vout.$1252.Metal4 vss.P21.nSD 0.00127206f
Cred_8243 vout.$1252.Metal4 vss.P23.nSD 0.000780794f
Cred_8244 vout.$1252.Metal4 vss.P25.nSD 0.000491123f
Cred_8245 vout.$126.Metal1 vref 2.82568e-06f
Cred_8246 vout.$126.Metal1 vref.P0.GatPoly 1.10186e-07f
Cred_8247 vout.$126.Metal1 vref.P0.nSD 2.45866e-06f
Cred_8248 vout.$126.Metal1 vref.P0.pSD 1.10713e-06f
Cred_8249 vout.$126.Metal1 vss.$127.Metal1 5.14245e-05f
Cred_8250 vout.$126.Metal1 vss.$1299.Metal5 6.8821e-07f
Cred_8251 vout.$126.Metal1 vss.$146.Metal1 6.03831e-05f
Cred_8252 vout.$126.Metal1 vss.$406.Metal1 0.000510792f
Cred_8253 vout.$126.Metal1 vss.$457.Metal2 7.51048e-07f
Cred_8254 vout.$126.Metal1 vss.$493.Metal2 0.0296286f
Cred_8255 vout.$126.Metal1 vss.$495.Metal2 0.0146788f
Cred_8256 vout.$126.Metal1 vss.$499.Metal2 0.0333843f
Cred_8257 vout.$126.Metal1 vss.$831.Metal3 6.03831e-05f
Cred_8258 vout.$126.Metal1 vss.P0.GatPoly 1.83848e-06f
Cred_8259 vout.$126.Metal1 vss.P0.pSD 0.00311147f
Cred_8260 vout.$126.Metal1 vss.P13.nSD 0.0334254f
Cred_8261 vout.$126.Metal1 vss.P15.nSD 0.0329774f
Cred_8262 vout.$1261.Metal4 vss 0.00610328f
Cred_8263 vout.$1261.Metal4 vss.$1211.Metal5 0.00629436f
Cred_8264 vout.$1261.Metal4 vss.$1229.Metal5 0.00629436f
Cred_8265 vout.$1261.Metal4 vss.$1281.Metal5 0.0240935f
Cred_8266 vout.$1261.Metal4 vss.$1299.Metal5 0.0500033f
Cred_8267 vout.$1261.Metal4 vss.$150.Metal1 1.93566e-06f
Cred_8268 vout.$1261.Metal4 vss.$156.Metal1 2.13619e-06f
Cred_8269 vout.$1261.Metal4 vss.$503.Metal2 0.00134533f
Cred_8270 vout.$1261.Metal4 vss.$507.Metal2 0.0012219f
Cred_8271 vout.$1261.Metal4 vss.$509.Metal2 0.00255618f
Cred_8272 vout.$1261.Metal4 vss.$513.Metal2 0.00293247f
Cred_8273 vout.$1261.Metal4 vss.$515.Metal2 0.000892076f
Cred_8274 vout.$1261.Metal4 vss.$519.Metal2 0.0010444f
Cred_8275 vout.$1261.Metal4 vss.$521.Metal2 0.000931991f
Cred_8276 vout.$1261.Metal4 vss.$839.Metal3 1.93566e-06f
Cred_8277 vout.$1261.Metal4 vss.$851.Metal3 2.13619e-06f
Cred_8278 vout.$1261.Metal4 vss.P17.nSD 0.000289532f
Cred_8279 vout.$1261.Metal4 vss.P19.nSD 0.000708283f
Cred_8280 vout.$1261.Metal4 vss.P21.nSD 0.000712347f
Cred_8281 vout.$1261.Metal4 vss.P23.nSD 0.000227257f
Cred_8282 vout.$1261.Metal4 vss.P25.nSD 0.000195764f
Cred_8283 vout.$1264.Metal4 vref 0.00298609f
Cred_8284 vout.$1264.Metal4 vref.P0.GatPoly 0.000116441f
Cred_8285 vout.$1264.Metal4 vref.P0.nSD 0.000975241f
Cred_8286 vout.$1264.Metal4 vref.P0.pSD 0.00116998f
Cred_8287 vout.$1264.Metal4 vss 0.0153053f
Cred_8288 vout.$1264.Metal4 vss.$10.Metal1 9.09919e-05f
Cred_8289 vout.$1264.Metal4 vss.$1009.Metal4 0.000350529f
Cred_8290 vout.$1264.Metal4 vss.$1011.Metal4 0.00227164f
Cred_8291 vout.$1264.Metal4 vss.$1013.Metal4 0.000710775f
Cred_8292 vout.$1264.Metal4 vss.$1211.Metal5 0.0157844f
Cred_8293 vout.$1264.Metal4 vss.$1229.Metal5 0.0157844f
Cred_8294 vout.$1264.Metal4 vss.$127.Metal1 1.65832e-09f
Cred_8295 vout.$1264.Metal4 vss.$1281.Metal5 0.0785434f
Cred_8296 vout.$1264.Metal4 vss.$1299.Metal5 0.0604196f
Cred_8297 vout.$1264.Metal4 vss.$13.Metal1 4.16066e-05f
Cred_8298 vout.$1264.Metal4 vss.$406.Metal1 8.05864e-10f
Cred_8299 vout.$1264.Metal4 vss.$457.Metal2 2.42196e-11f
Cred_8300 vout.$1264.Metal4 vss.$461.Metal2 0.00154684f
Cred_8301 vout.$1264.Metal4 vss.$463.Metal2 0.00332219f
Cred_8302 vout.$1264.Metal4 vss.$467.Metal2 0.00195244f
Cred_8303 vout.$1264.Metal4 vss.$469.Metal2 0.00464432f
Cred_8304 vout.$1264.Metal4 vss.$799.Metal3 1.99326e-05f
Cred_8305 vout.$1264.Metal4 vss.$801.Metal3 0.000506562f
Cred_8306 vout.$1264.Metal4 vss.$805.Metal3 8.73533e-05f
Cred_8307 vout.$1264.Metal4 vss.P0.GatPoly 5.92867e-11f
Cred_8308 vout.$1264.Metal4 vss.P0.nSD 0.000335335f
Cred_8309 vout.$1264.Metal4 vss.P0.pSD 4.02279e-07f
Cred_8310 vout.$1264.Metal4 vss.P1.nSD 0.000838342f
Cred_8311 vout.$1264.Metal4 vss.P3.nSD 0.00127503f
Cred_8312 vout.$1269.Metal4 vref 0.0141258f
Cred_8313 vout.$1269.Metal4 vref.P0.GatPoly 0.000550826f
Cred_8314 vout.$1269.Metal4 vref.P0.nSD 0.00467016f
Cred_8315 vout.$1269.Metal4 vref.P0.pSD 0.00553463f
Cred_8316 vout.$1269.Metal4 vss 0.00960386f
Cred_8317 vout.$1269.Metal4 vss.$1033.Metal4 4.96125e-05f
Cred_8318 vout.$1269.Metal4 vss.$1037.Metal4 4.96125e-05f
Cred_8319 vout.$1269.Metal4 vss.$1043.Metal4 3.82201e-05f
Cred_8320 vout.$1269.Metal4 vss.$1047.Metal4 3.77424e-05f
Cred_8321 vout.$1269.Metal4 vss.$1053.Metal4 3.85844e-05f
Cred_8322 vout.$1269.Metal4 vss.$1057.Metal4 3.77424e-05f
Cred_8323 vout.$1269.Metal4 vss.$1211.Metal5 0.00990454f
Cred_8324 vout.$1269.Metal4 vss.$1229.Metal5 0.00990454f
Cred_8325 vout.$1269.Metal4 vss.$1246.Metal5 0.0130226f
Cred_8326 vout.$1269.Metal4 vss.$1281.Metal5 0.0379125f
Cred_8327 vout.$1269.Metal4 vss.$1299.Metal5 0.118774f
Cred_8328 vout.$1269.Metal4 vss.$146.Metal1 0.00339219f
Cred_8329 vout.$1269.Metal4 vss.$148.Metal1 0.00265769f
Cred_8330 vout.$1269.Metal4 vss.$150.Metal1 0.0047971f
Cred_8331 vout.$1269.Metal4 vss.$153.Metal1 0.00458119f
Cred_8332 vout.$1269.Metal4 vss.$156.Metal1 0.00164555f
Cred_8333 vout.$1269.Metal4 vss.$493.Metal2 0.00329543f
Cred_8334 vout.$1269.Metal4 vss.$495.Metal2 0.00303435f
Cred_8335 vout.$1269.Metal4 vss.$499.Metal2 0.00809931f
Cred_8336 vout.$1269.Metal4 vss.$503.Metal2 0.00785856f
Cred_8337 vout.$1269.Metal4 vss.$507.Metal2 0.00599532f
Cred_8338 vout.$1269.Metal4 vss.$509.Metal2 0.00626433f
Cred_8339 vout.$1269.Metal4 vss.$513.Metal2 0.00599017f
Cred_8340 vout.$1269.Metal4 vss.$515.Metal2 0.00374327f
Cred_8341 vout.$1269.Metal4 vss.$519.Metal2 0.000883029f
Cred_8342 vout.$1269.Metal4 vss.$521.Metal2 0.000795832f
Cred_8343 vout.$1269.Metal4 vss.$825.Metal3 5.84973e-07f
Cred_8344 vout.$1269.Metal4 vss.$831.Metal3 0.00810235f
Cred_8345 vout.$1269.Metal4 vss.$835.Metal3 0.00957289f
Cred_8346 vout.$1269.Metal4 vss.$839.Metal3 0.00781421f
Cred_8347 vout.$1269.Metal4 vss.$841.Metal3 0.00827399f
Cred_8348 vout.$1269.Metal4 vss.$845.Metal3 0.00960379f
Cred_8349 vout.$1269.Metal4 vss.$849.Metal3 0.00762862f
Cred_8350 vout.$1269.Metal4 vss.$851.Metal3 1.80477e-06f
Cred_8351 vout.$1269.Metal4 vss.P0.pSD 2.58836e-05f
Cred_8352 vout.$1269.Metal4 vss.P13.nSD 0.00266833f
Cred_8353 vout.$1269.Metal4 vss.P15.nSD 0.00074163f
Cred_8354 vout.$1269.Metal4 vss.P17.nSD 0.000739976f
Cred_8355 vout.$1269.Metal4 vss.P19.nSD 0.000737757f
Cred_8356 vout.$1269.Metal4 vss.P21.nSD 0.000736439f
Cred_8357 vout.$1269.Metal4 vss.P23.nSD 0.000215215f
Cred_8358 vout.$1269.Metal4 vss.P25.nSD 0.000187539f
Cred_8359 vout.$127.Metal1 vss.$127.Metal1 3.9278e-05f
Cred_8360 vout.$127.Metal1 vss.$146.Metal1 5.95917e-05f
Cred_8361 vout.$127.Metal1 vss.$150.Metal1 4.94187e-05f
Cred_8362 vout.$127.Metal1 vss.$406.Metal1 0.000655015f
Cred_8363 vout.$127.Metal1 vss.$457.Metal2 5.7365e-07f
Cred_8364 vout.$127.Metal1 vss.$495.Metal2 0.00505406f
Cred_8365 vout.$127.Metal1 vss.$499.Metal2 0.0329467f
Cred_8366 vout.$127.Metal1 vss.$503.Metal2 0.0343473f
Cred_8367 vout.$127.Metal1 vss.$507.Metal2 0.00419127f
Cred_8368 vout.$127.Metal1 vss.$831.Metal3 5.95917e-05f
Cred_8369 vout.$127.Metal1 vss.$839.Metal3 4.94187e-05f
Cred_8370 vout.$127.Metal1 vss.P0.GatPoly 1.40423e-06f
Cred_8371 vout.$127.Metal1 vss.P0.pSD 0.00298001f
Cred_8372 vout.$127.Metal1 vss.P15.nSD 0.0325403f
Cred_8373 vout.$127.Metal1 vss.P17.nSD 0.0329663f
Cred_8374 vout.$1279.Metal4 vref 0.0111767f
Cred_8375 vout.$1279.Metal4 vref.P0.GatPoly 0.000435829f
Cred_8376 vout.$1279.Metal4 vref.P0.nSD 0.00377745f
Cred_8377 vout.$1279.Metal4 vref.P0.pSD 0.00437915f
Cred_8378 vout.$1279.Metal4 vss 0.00900398f
Cred_8379 vout.$1279.Metal4 vss.$1033.Metal4 5.11361e-06f
Cred_8380 vout.$1279.Metal4 vss.$1037.Metal4 5.11361e-06f
Cred_8381 vout.$1279.Metal4 vss.$1211.Metal5 0.00928587f
Cred_8382 vout.$1279.Metal4 vss.$1229.Metal5 0.00928587f
Cred_8383 vout.$1279.Metal4 vss.$1246.Metal5 0.00134225f
Cred_8384 vout.$1279.Metal4 vss.$1281.Metal5 0.0355444f
Cred_8385 vout.$1279.Metal4 vss.$1299.Metal5 0.0901225f
Cred_8386 vout.$1279.Metal4 vss.$146.Metal1 4.9948e-06f
Cred_8387 vout.$1279.Metal4 vss.$150.Metal1 4.08783e-06f
Cred_8388 vout.$1279.Metal4 vss.$156.Metal1 1.58135e-06f
Cred_8389 vout.$1279.Metal4 vss.$493.Metal2 0.00065406f
Cred_8390 vout.$1279.Metal4 vss.$495.Metal2 0.000634603f
Cred_8391 vout.$1279.Metal4 vss.$499.Metal2 0.0027615f
Cred_8392 vout.$1279.Metal4 vss.$503.Metal2 0.00284115f
Cred_8393 vout.$1279.Metal4 vss.$507.Metal2 0.00128203f
Cred_8394 vout.$1279.Metal4 vss.$509.Metal2 0.00226039f
Cred_8395 vout.$1279.Metal4 vss.$513.Metal2 0.00256629f
Cred_8396 vout.$1279.Metal4 vss.$515.Metal2 0.000756248f
Cred_8397 vout.$1279.Metal4 vss.$519.Metal2 0.000719511f
Cred_8398 vout.$1279.Metal4 vss.$521.Metal2 1.07468e-05f
Cred_8399 vout.$1279.Metal4 vss.$825.Metal3 6.02938e-08f
Cred_8400 vout.$1279.Metal4 vss.$831.Metal3 4.9948e-06f
Cred_8401 vout.$1279.Metal4 vss.$839.Metal3 4.08783e-06f
Cred_8402 vout.$1279.Metal4 vss.$851.Metal3 1.58135e-06f
Cred_8403 vout.$1279.Metal4 vss.P13.nSD 0.000210266f
Cred_8404 vout.$1279.Metal4 vss.P15.nSD 0.00077811f
Cred_8405 vout.$1279.Metal4 vss.P17.nSD 0.000777188f
Cred_8406 vout.$1279.Metal4 vss.P19.nSD 0.000777486f
Cred_8407 vout.$1279.Metal4 vss.P21.nSD 0.000774154f
Cred_8408 vout.$1279.Metal4 vss.P23.nSD 0.000208737f
Cred_8409 vout.$1279.Metal4 vss.P25.nSD 2.80522e-06f
Cred_8410 vout.$128.Metal1 vss.$127.Metal1 2.56365e-05f
Cred_8411 vout.$128.Metal1 vss.$150.Metal1 4.87709e-05f
Cred_8412 vout.$128.Metal1 vss.$406.Metal1 0.000726494f
Cred_8413 vout.$128.Metal1 vss.$457.Metal2 3.74418e-07f
Cred_8414 vout.$128.Metal1 vss.$503.Metal2 0.0338971f
Cred_8415 vout.$128.Metal1 vss.$507.Metal2 0.0154438f
Cred_8416 vout.$128.Metal1 vss.$509.Metal2 0.0273263f
Cred_8417 vout.$128.Metal1 vss.$839.Metal3 4.87709e-05f
Cred_8418 vout.$128.Metal1 vss.P0.GatPoly 9.1653e-07f
Cred_8419 vout.$128.Metal1 vss.P0.pSD 0.00241598f
Cred_8420 vout.$128.Metal1 vss.P17.nSD 0.0325293f
Cred_8421 vout.$128.Metal1 vss.P19.nSD 0.0329699f
Cred_8422 vout.$1289.Metal4 vref 0.0139673f
Cred_8423 vout.$1289.Metal4 vref.P0.GatPoly 0.000544646f
Cred_8424 vout.$1289.Metal4 vref.P0.nSD 0.00454315f
Cred_8425 vout.$1289.Metal4 vref.P0.pSD 0.00547253f
Cred_8426 vout.$1289.Metal4 vss 0.0101659f
Cred_8427 vout.$1289.Metal4 vss.$1211.Metal5 0.0104842f
Cred_8428 vout.$1289.Metal4 vss.$1229.Metal5 0.0104842f
Cred_8429 vout.$1289.Metal4 vss.$1281.Metal5 0.0401313f
Cred_8430 vout.$1289.Metal4 vss.$1299.Metal5 0.0839376f
Cred_8431 vout.$1289.Metal4 vss.$146.Metal1 4.84931e-06f
Cred_8432 vout.$1289.Metal4 vss.$150.Metal1 3.96876e-06f
Cred_8433 vout.$1289.Metal4 vss.$156.Metal1 1.52052e-06f
Cred_8434 vout.$1289.Metal4 vss.$493.Metal2 0.000622682f
Cred_8435 vout.$1289.Metal4 vss.$495.Metal2 0.000612143f
Cred_8436 vout.$1289.Metal4 vss.$499.Metal2 0.00268106f
Cred_8437 vout.$1289.Metal4 vss.$503.Metal2 0.0027584f
Cred_8438 vout.$1289.Metal4 vss.$507.Metal2 0.00124469f
Cred_8439 vout.$1289.Metal4 vss.$509.Metal2 0.00219455f
Cred_8440 vout.$1289.Metal4 vss.$513.Metal2 0.00249823f
Cred_8441 vout.$1289.Metal4 vss.$515.Metal2 0.000734589f
Cred_8442 vout.$1289.Metal4 vss.$519.Metal2 0.000691019f
Cred_8443 vout.$1289.Metal4 vss.$831.Metal3 4.84931e-06f
Cred_8444 vout.$1289.Metal4 vss.$839.Metal3 3.96876e-06f
Cred_8445 vout.$1289.Metal4 vss.$851.Metal3 1.52052e-06f
Cred_8446 vout.$1289.Metal4 vss.P13.nSD 0.000213293f
Cred_8447 vout.$1289.Metal4 vss.P15.nSD 0.000804863f
Cred_8448 vout.$1289.Metal4 vss.P17.nSD 0.000803968f
Cred_8449 vout.$1289.Metal4 vss.P19.nSD 0.000804257f
Cred_8450 vout.$1289.Metal4 vss.P21.nSD 0.000803039f
Cred_8451 vout.$1289.Metal4 vss.P23.nSD 0.000213822f
Cred_8452 vout.$129.Metal1 vss.$127.Metal1 1.91109e-05f
Cred_8453 vout.$129.Metal1 vss.$406.Metal1 0.000936468f
Cred_8454 vout.$129.Metal1 vss.$457.Metal2 2.79112e-07f
Cred_8455 vout.$129.Metal1 vss.$507.Metal2 0.0111592f
Cred_8456 vout.$129.Metal1 vss.$509.Metal2 0.0269682f
Cred_8457 vout.$129.Metal1 vss.$513.Metal2 0.0309487f
Cred_8458 vout.$129.Metal1 vss.$515.Metal2 0.00750271f
Cred_8459 vout.$129.Metal1 vss.P0.GatPoly 6.83232e-07f
Cred_8460 vout.$129.Metal1 vss.P0.pSD 0.00221286f
Cred_8461 vout.$129.Metal1 vss.P19.nSD 0.0325328f
Cred_8462 vout.$129.Metal1 vss.P21.nSD 0.0327846f
Cred_8463 vout.$1299.Metal4 vref 0.302349f
Cred_8464 vout.$1299.Metal4 vref.P0.GatPoly 0.0109634f
Cred_8465 vout.$1299.Metal4 vref.P0.nSD 0.0430668f
Cred_8466 vout.$1299.Metal4 vref.P0.pSD 0.0596078f
Cred_8467 vout.$1299.Metal4 vss 0.114687f
Cred_8468 vout.$1299.Metal4 vss.$1211.Metal5 0.115777f
Cred_8469 vout.$1299.Metal4 vss.$1229.Metal5 0.115777f
Cred_8470 vout.$1299.Metal4 vss.$127.Metal1 0.000362212f
Cred_8471 vout.$1299.Metal4 vss.$1281.Metal5 0.44317f
Cred_8472 vout.$1299.Metal4 vss.$1299.Metal5 0.531451f
Cred_8473 vout.$1299.Metal4 vss.$146.Metal1 6.31273e-06f
Cred_8474 vout.$1299.Metal4 vss.$150.Metal1 5.43746e-06f
Cred_8475 vout.$1299.Metal4 vss.$156.Metal1 8.69276e-08f
Cred_8476 vout.$1299.Metal4 vss.$159.Metal1 0.000637165f
Cred_8477 vout.$1299.Metal4 vss.$406.Metal1 0.0289473f
Cred_8478 vout.$1299.Metal4 vss.$457.Metal2 5.29005e-06f
Cred_8479 vout.$1299.Metal4 vss.$493.Metal2 3.59283e-05f
Cred_8480 vout.$1299.Metal4 vss.$495.Metal2 0.000546982f
Cred_8481 vout.$1299.Metal4 vss.$499.Metal2 0.00349015f
Cred_8482 vout.$1299.Metal4 vss.$503.Metal2 0.00377918f
Cred_8483 vout.$1299.Metal4 vss.$507.Metal2 0.0017053f
Cred_8484 vout.$1299.Metal4 vss.$509.Metal2 0.00300668f
Cred_8485 vout.$1299.Metal4 vss.$513.Metal2 0.00342273f
Cred_8486 vout.$1299.Metal4 vss.$515.Metal2 0.000837126f
Cred_8487 vout.$1299.Metal4 vss.$519.Metal2 0.000508846f
Cred_8488 vout.$1299.Metal4 vss.$521.Metal2 0.00594499f
Cred_8489 vout.$1299.Metal4 vss.$525.Metal2 9.30571e-06f
Cred_8490 vout.$1299.Metal4 vss.$831.Metal3 6.31273e-06f
Cred_8491 vout.$1299.Metal4 vss.$839.Metal3 5.43746e-06f
Cred_8492 vout.$1299.Metal4 vss.$851.Metal3 8.69276e-08f
Cred_8493 vout.$1299.Metal4 vss.P0.GatPoly 1.29494e-05f
Cred_8494 vout.$1299.Metal4 vss.P0.pSD 0.0346664f
Cred_8495 vout.$1299.Metal4 vss.P1.GatPoly 0.000442761f
Cred_8496 vout.$1299.Metal4 vss.P13.nSD 1.27031e-05f
Cred_8497 vout.$1299.Metal4 vss.P15.nSD 0.00108016f
Cred_8498 vout.$1299.Metal4 vss.P17.nSD 0.00113559f
Cred_8499 vout.$1299.Metal4 vss.P19.nSD 0.00113599f
Cred_8500 vout.$1299.Metal4 vss.P21.nSD 0.00113432f
Cred_8501 vout.$1299.Metal4 vss.P23.nSD 1.26173e-05f
Cred_8502 vout.$1299.Metal4 vss.P25.nSD 0.00170522f
Cred_8503 vout.$13.Metal1 vss.$1281.Metal5 1.0906e-06f
Cred_8504 vout.$13.Metal1 vss.$13.Metal1 0.000800788f
Cred_8505 vout.$13.Metal1 vss.$136.Metal1 0.0046943f
Cred_8506 vout.$13.Metal1 vss.$473.Metal2 0.0275952f
Cred_8507 vout.$13.Metal1 vss.$475.Metal2 0.0157424f
Cred_8508 vout.$13.Metal1 vss.$479.Metal2 0.0347177f
Cred_8509 vout.$13.Metal1 vss.$809.Metal3 2.50366e-06f
Cred_8510 vout.$13.Metal1 vss.$811.Metal3 5.4045e-05f
Cred_8511 vout.$13.Metal1 vss.P0.pSD 7.58971e-06f
Cred_8512 vout.$13.Metal1 vss.P5.nSD 0.032184f
Cred_8513 vout.$13.Metal1 vss.P7.nSD 0.0321831f
Cred_8514 vout.$130.Metal1 vss 3.52281e-07f
Cred_8515 vout.$130.Metal1 vss.$1211.Metal5 3.6331e-07f
Cred_8516 vout.$130.Metal1 vss.$1229.Metal5 3.6331e-07f
Cred_8517 vout.$130.Metal1 vss.$127.Metal1 1.60682e-05f
Cred_8518 vout.$130.Metal1 vss.$1281.Metal5 1.39068e-06f
Cred_8519 vout.$130.Metal1 vss.$1299.Metal5 1.39068e-06f
Cred_8520 vout.$130.Metal1 vss.$156.Metal1 6.94156e-05f
Cred_8521 vout.$130.Metal1 vss.$406.Metal1 0.00140183f
Cred_8522 vout.$130.Metal1 vss.$457.Metal2 2.34674e-07f
Cred_8523 vout.$130.Metal1 vss.$513.Metal2 0.030859f
Cred_8524 vout.$130.Metal1 vss.$515.Metal2 0.0133682f
Cred_8525 vout.$130.Metal1 vss.$519.Metal2 0.0315551f
Cred_8526 vout.$130.Metal1 vss.$521.Metal2 0.000106615f
Cred_8527 vout.$130.Metal1 vss.$851.Metal3 6.94156e-05f
Cred_8528 vout.$130.Metal1 vss.P0.GatPoly 5.74453e-07f
Cred_8529 vout.$130.Metal1 vss.P0.pSD 0.00225757f
Cred_8530 vout.$130.Metal1 vss.P21.nSD 0.032688f
Cred_8531 vout.$130.Metal1 vss.P23.nSD 0.03209f
Cred_8532 vout.$130.Metal1 vss.P25.nSD 3.05809e-05f
Cred_8533 vout.$1313.Metal4 vref 0.0987568f
Cred_8534 vout.$1313.Metal4 vref.P0.GatPoly 0.00383696f
Cred_8535 vout.$1313.Metal4 vref.P0.nSD 0.0208146f
Cred_8536 vout.$1313.Metal4 vref.P0.pSD 0.0600291f
Cred_8537 vout.$1313.Metal4 vss 0.229366f
Cred_8538 vout.$1313.Metal4 vss.$1211.Metal5 0.0836952f
Cred_8539 vout.$1313.Metal4 vss.$1229.Metal5 0.0836952f
Cred_8540 vout.$1313.Metal4 vss.$127.Metal1 3.16826e-06f
Cred_8541 vout.$1313.Metal4 vss.$1281.Metal5 0.320368f
Cred_8542 vout.$1313.Metal4 vss.$1299.Metal5 0.320368f
Cred_8543 vout.$1313.Metal4 vss.$406.Metal1 0.000120062f
Cred_8544 vout.$1313.Metal4 vss.$457.Metal2 4.6272e-08f
Cred_8545 vout.$1313.Metal4 vss.P0.GatPoly 1.13268e-07f
Cred_8546 vout.$1313.Metal4 vss.P0.pSD 0.000317294f
Cred_8547 vout.$1323.Metal4 vref 0.0139526f
Cred_8548 vout.$1323.Metal4 vref.P0.GatPoly 0.000544073f
Cred_8549 vout.$1323.Metal4 vref.P0.nSD 0.00311899f
Cred_8550 vout.$1323.Metal4 vref.P0.pSD 0.00931176f
Cred_8551 vout.$1323.Metal4 vss 0.0316821f
Cred_8552 vout.$1323.Metal4 vss.$1211.Metal5 0.0115606f
Cred_8553 vout.$1323.Metal4 vss.$1229.Metal5 0.0115606f
Cred_8554 vout.$1323.Metal4 vss.$1281.Metal5 0.0442518f
Cred_8555 vout.$1323.Metal4 vss.$1299.Metal5 0.0442518f
Cred_8556 vout.$1328.Metal4 vref 0.00449729f
Cred_8557 vout.$1328.Metal4 vref.P0.GatPoly 0.000175369f
Cred_8558 vout.$1328.Metal4 vref.P0.nSD 0.00100533f
Cred_8559 vout.$1328.Metal4 vref.P0.pSD 0.00306408f
Cred_8560 vout.$1328.Metal4 vss 0.0317379f
Cred_8561 vout.$1328.Metal4 vss.$1211.Metal5 0.0120669f
Cred_8562 vout.$1328.Metal4 vss.$1229.Metal5 0.0120669f
Cred_8563 vout.$1328.Metal4 vss.$1281.Metal5 0.0461897f
Cred_8564 vout.$1328.Metal4 vss.$1299.Metal5 0.0461897f
Cred_8565 vout.$1329.Metal4 vref 0.00566278f
Cred_8566 vout.$1329.Metal4 vref.P0.GatPoly 0.000220817f
Cred_8567 vout.$1329.Metal4 vref.P0.nSD 0.00126587f
Cred_8568 vout.$1329.Metal4 vref.P0.pSD 0.0038574f
Cred_8569 vout.$1329.Metal4 vss 0.024355f
Cred_8570 vout.$1329.Metal4 vss.$1211.Metal5 0.00937292f
Cred_8571 vout.$1329.Metal4 vss.$1229.Metal5 0.00937292f
Cred_8572 vout.$1329.Metal4 vss.$1281.Metal5 0.0358776f
Cred_8573 vout.$1329.Metal4 vss.$1299.Metal5 0.0358776f
Cred_8574 vout.$1330.Metal4 vref 0.00765627f
Cred_8575 vout.$1330.Metal4 vref.P0.GatPoly 0.000298552f
Cred_8576 vout.$1330.Metal4 vref.P0.nSD 0.0017115f
Cred_8577 vout.$1330.Metal4 vref.P0.pSD 0.00521408f
Cred_8578 vout.$1330.Metal4 vss 0.0253508f
Cred_8579 vout.$1330.Metal4 vss.$1211.Metal5 0.00925037f
Cred_8580 vout.$1330.Metal4 vss.$1229.Metal5 0.00925037f
Cred_8581 vout.$1330.Metal4 vss.$1281.Metal5 0.0354085f
Cred_8582 vout.$1330.Metal4 vss.$1299.Metal5 0.0354085f
Cred_8583 vout.$1331.Metal4 vref 0.0118211f
Cred_8584 vout.$1331.Metal4 vref.P0.GatPoly 0.000460957f
Cred_8585 vout.$1331.Metal4 vref.P0.nSD 0.00264252f
Cred_8586 vout.$1331.Metal4 vref.P0.pSD 0.00804648f
Cred_8587 vout.$1331.Metal4 vss 0.0253512f
Cred_8588 vout.$1331.Metal4 vss.$1211.Metal5 0.00925052f
Cred_8589 vout.$1331.Metal4 vss.$1229.Metal5 0.00925052f
Cred_8590 vout.$1331.Metal4 vss.$1281.Metal5 0.0354091f
Cred_8591 vout.$1331.Metal4 vss.$1299.Metal5 0.0354091f
Cred_8592 vout.$1332.Metal4 vref 0.0581015f
Cred_8593 vout.$1332.Metal4 vref.P0.GatPoly 0.00226563f
Cred_8594 vout.$1332.Metal4 vref.P0.nSD 0.0129881f
Cred_8595 vout.$1332.Metal4 vref.P0.pSD 0.0406436f
Cred_8596 vout.$1332.Metal4 vss 0.024151f
Cred_8597 vout.$1332.Metal4 vss.$1211.Metal5 0.00881258f
Cred_8598 vout.$1332.Metal4 vss.$1229.Metal5 0.00881258f
Cred_8599 vout.$1332.Metal4 vss.$1281.Metal5 0.0337327f
Cred_8600 vout.$1332.Metal4 vss.$1299.Metal5 0.0337327f
Cred_8601 vout.$1333.Metal4 vref 0.0139429f
Cred_8602 vout.$1333.Metal4 vref.P0.GatPoly 0.000543696f
Cred_8603 vout.$1333.Metal4 vref.P0.nSD 0.00311683f
Cred_8604 vout.$1333.Metal4 vref.P0.pSD 0.00952747f
Cred_8605 vout.$1333.Metal4 vss 0.0317093f
Cred_8606 vout.$1333.Metal4 vss.$1211.Metal5 0.0115706f
Cred_8607 vout.$1333.Metal4 vss.$1229.Metal5 0.0115706f
Cred_8608 vout.$1333.Metal4 vss.$1281.Metal5 0.0442897f
Cred_8609 vout.$1333.Metal4 vss.$1299.Metal5 0.0442897f
Cred_8610 vout.$1343.Metal4 vref 0.011154f
Cred_8611 vout.$1343.Metal4 vref.P0.GatPoly 0.000434944f
Cred_8612 vout.$1343.Metal4 vref.P0.nSD 0.00249339f
Cred_8613 vout.$1343.Metal4 vref.P0.pSD 0.00778607f
Cred_8614 vout.$1343.Metal4 vss 0.0320339f
Cred_8615 vout.$1343.Metal4 vss.$1211.Metal5 0.011689f
Cred_8616 vout.$1343.Metal4 vss.$1229.Metal5 0.011689f
Cred_8617 vout.$1343.Metal4 vss.$1281.Metal5 0.0447431f
Cred_8618 vout.$1343.Metal4 vss.$1299.Metal5 0.0447431f
Cred_8619 vout.$1353.Metal4 vref 0.0115253f
Cred_8620 vout.$1353.Metal4 vref.P0.GatPoly 0.000449422f
Cred_8621 vout.$1353.Metal4 vref.P0.nSD 0.00257639f
Cred_8622 vout.$1353.Metal4 vref.P0.pSD 0.00831122f
Cred_8623 vout.$1353.Metal4 vss 0.0318913f
Cred_8624 vout.$1353.Metal4 vss.$1211.Metal5 0.011637f
Cred_8625 vout.$1353.Metal4 vss.$1229.Metal5 0.011637f
Cred_8626 vout.$1353.Metal4 vss.$1281.Metal5 0.044544f
Cred_8627 vout.$1353.Metal4 vss.$1299.Metal5 0.044544f
Cred_8628 vout.$1363.Metal4 vref 0.00985081f
Cred_8629 vout.$1363.Metal4 vref.P0.GatPoly 0.000384126f
Cred_8630 vout.$1363.Metal4 vref.P0.nSD 0.00220207f
Cred_8631 vout.$1363.Metal4 vref.P0.pSD 0.00716165f
Cred_8632 vout.$1363.Metal4 vss 0.031816f
Cred_8633 vout.$1363.Metal4 vss.$1211.Metal5 0.0116095f
Cred_8634 vout.$1363.Metal4 vss.$1229.Metal5 0.0116095f
Cred_8635 vout.$1363.Metal4 vss.$1281.Metal5 0.0444387f
Cred_8636 vout.$1363.Metal4 vss.$1299.Metal5 0.0444387f
Cred_8637 vout.$1368.Metal4 vref 0.00139213f
Cred_8638 vout.$1368.Metal4 vref.P0.GatPoly 5.42852e-05f
Cred_8639 vout.$1368.Metal4 vref.P0.nSD 0.000311199f
Cred_8640 vout.$1368.Metal4 vref.P0.pSD 0.0010013f
Cred_8641 vout.$1368.Metal4 vss 0.0411093f
Cred_8642 vout.$1368.Metal4 vss.$1211.Metal5 0.0102293f
Cred_8643 vout.$1368.Metal4 vss.$1229.Metal5 0.0102293f
Cred_8644 vout.$1368.Metal4 vss.$1281.Metal5 0.0391556f
Cred_8645 vout.$1368.Metal4 vss.$1299.Metal5 0.0391556f
Cred_8646 vout.$1369.Metal4 vref 0.00174757f
Cred_8647 vout.$1369.Metal4 vref.P0.GatPoly 6.81454e-05f
Cred_8648 vout.$1369.Metal4 vref.P0.nSD 0.000390655f
Cred_8649 vout.$1369.Metal4 vref.P0.pSD 0.00125695f
Cred_8650 vout.$1369.Metal4 vss 0.117824f
Cred_8651 vout.$1369.Metal4 vss.$1211.Metal5 0.0162703f
Cred_8652 vout.$1369.Metal4 vss.$1229.Metal5 0.0162703f
Cred_8653 vout.$1369.Metal4 vss.$1281.Metal5 0.0622794f
Cred_8654 vout.$1369.Metal4 vss.$1299.Metal5 0.0622794f
Cred_8655 vout.$1370.Metal4 vref 0.00233392f
Cred_8656 vout.$1370.Metal4 vref.P0.GatPoly 9.10099e-05f
Cred_8657 vout.$1370.Metal4 vref.P0.nSD 0.00052173f
Cred_8658 vout.$1370.Metal4 vref.P0.pSD 0.00167869f
Cred_8659 vout.$1370.Metal4 vss 0.0906825f
Cred_8660 vout.$1370.Metal4 vss.$1211.Metal5 0.0183788f
Cred_8661 vout.$1370.Metal4 vss.$1229.Metal5 0.0183788f
Cred_8662 vout.$1370.Metal4 vss.$1281.Metal5 0.0703502f
Cred_8663 vout.$1370.Metal4 vss.$1299.Metal5 0.0703502f
Cred_8664 vout.$1371.Metal4 vref 0.00351244f
Cred_8665 vout.$1371.Metal4 vref.P0.GatPoly 0.000136965f
Cred_8666 vout.$1371.Metal4 vref.P0.nSD 0.000785177f
Cred_8667 vout.$1371.Metal4 vref.P0.pSD 0.00252635f
Cred_8668 vout.$1371.Metal4 vss 0.0679812f
Cred_8669 vout.$1371.Metal4 vss.$1211.Metal5 0.0207299f
Cred_8670 vout.$1371.Metal4 vss.$1229.Metal5 0.0207299f
Cred_8671 vout.$1371.Metal4 vss.$1281.Metal5 0.0793497f
Cred_8672 vout.$1371.Metal4 vss.$1299.Metal5 0.0793497f
Cred_8673 vout.$1372.Metal4 vref 0.0294016f
Cred_8674 vout.$1372.Metal4 vref.P0.GatPoly 0.0011465f
Cred_8675 vout.$1372.Metal4 vref.P0.nSD 0.00657249f
Cred_8676 vout.$1372.Metal4 vref.P0.pSD 0.0347519f
Cred_8677 vout.$1372.Metal4 vss 0.0961336f
Cred_8678 vout.$1372.Metal4 vss.$1211.Metal5 0.0350787f
Cred_8679 vout.$1372.Metal4 vss.$1229.Metal5 0.0350787f
Cred_8680 vout.$1372.Metal4 vss.$1281.Metal5 0.134274f
Cred_8681 vout.$1372.Metal4 vss.$1299.Metal5 0.134274f
Cred_8682 vout.$1373.Metal4 vref 0.0101193f
Cred_8683 vout.$1373.Metal4 vref.P0.GatPoly 0.000394598f
Cred_8684 vout.$1373.Metal4 vref.P0.nSD 0.0022621f
Cred_8685 vout.$1373.Metal4 vref.P0.pSD 0.00833243f
Cred_8686 vout.$1373.Metal4 vss 0.0393255f
Cred_8687 vout.$1373.Metal4 vss.$1211.Metal5 0.0143497f
Cred_8688 vout.$1373.Metal4 vss.$1229.Metal5 0.0143497f
Cred_8689 vout.$1373.Metal4 vss.$1281.Metal5 0.0549276f
Cred_8690 vout.$1373.Metal4 vss.$1299.Metal5 0.0549276f
Cred_8691 vout.$1383.Metal4 vref 0.003239f
Cred_8692 vout.$1383.Metal4 vref.P0.GatPoly 0.000126303f
Cred_8693 vout.$1383.Metal4 vref.P0.nSD 0.000724053f
Cred_8694 vout.$1383.Metal4 vref.P0.pSD 0.0073629f
Cred_8695 vout.$1383.Metal4 vss 0.0479164f
Cred_8696 vout.$1383.Metal4 vss.$1211.Metal5 0.0174844f
Cred_8697 vout.$1383.Metal4 vss.$1229.Metal5 0.0174844f
Cred_8698 vout.$1383.Metal4 vss.$1281.Metal5 0.0669269f
Cred_8699 vout.$1383.Metal4 vss.$1299.Metal5 0.0669269f
Cred_8700 vout.$1384.Metal4 vss 0.0261794f
Cred_8701 vout.$1384.Metal4 vss.$1211.Metal5 0.00955272f
Cred_8702 vout.$1384.Metal4 vss.$1229.Metal5 0.00955272f
Cred_8703 vout.$1384.Metal4 vss.$1281.Metal5 0.0365658f
Cred_8704 vout.$1384.Metal4 vss.$1299.Metal5 0.0365658f
Cred_8705 vout.$1394.Metal4 vss 0.0314871f
Cred_8706 vout.$1394.Metal4 vss.$1211.Metal5 0.0114895f
Cred_8707 vout.$1394.Metal4 vss.$1229.Metal5 0.0114895f
Cred_8708 vout.$1394.Metal4 vss.$1281.Metal5 0.0439794f
Cred_8709 vout.$1394.Metal4 vss.$1299.Metal5 0.0439794f
Cred_8710 vout.$1395.Metal4 vss 0.0199421f
Cred_8711 vout.$1395.Metal4 vss.$1211.Metal5 0.00727676f
Cred_8712 vout.$1395.Metal4 vss.$1229.Metal5 0.00727676f
Cred_8713 vout.$1395.Metal4 vss.$1281.Metal5 0.027854f
Cred_8714 vout.$1395.Metal4 vss.$1299.Metal5 0.027854f
Cred_8715 vout.$14.Metal1 vss.$1281.Metal5 1.0906e-06f
Cred_8716 vout.$14.Metal1 vss.$136.Metal1 4.98837e-05f
Cred_8717 vout.$14.Metal1 vss.$138.Metal1 0.00398408f
Cred_8718 vout.$14.Metal1 vss.$140.Metal1 6.09837e-05f
Cred_8719 vout.$14.Metal1 vss.$475.Metal2 0.00423071f
Cred_8720 vout.$14.Metal1 vss.$479.Metal2 0.0347207f
Cred_8721 vout.$14.Metal1 vss.$483.Metal2 0.0337665f
Cred_8722 vout.$14.Metal1 vss.$487.Metal2 0.00517212f
Cred_8723 vout.$14.Metal1 vss.$811.Metal3 4.98837e-05f
Cred_8724 vout.$14.Metal1 vss.$815.Metal3 6.89002e-06f
Cred_8725 vout.$14.Metal1 vss.$819.Metal3 6.09837e-05f
Cred_8726 vout.$14.Metal1 vss.P10.nSD 0.0321944f
Cred_8727 vout.$14.Metal1 vss.P7.nSD 0.0321804f
Cred_8728 vout.$1405.Metal4 vss 0.0199641f
Cred_8729 vout.$1405.Metal4 vss.$1211.Metal5 0.00728478f
Cred_8730 vout.$1405.Metal4 vss.$1229.Metal5 0.00728478f
Cred_8731 vout.$1405.Metal4 vss.$1281.Metal5 0.0278847f
Cred_8732 vout.$1405.Metal4 vss.$1299.Metal5 0.0278847f
Cred_8733 vout.$1408.Metal4 vss 0.0889584f
Cred_8734 vout.$1408.Metal4 vss.$1211.Metal5 0.00729467f
Cred_8735 vout.$1408.Metal4 vss.$1229.Metal5 0.00729467f
Cred_8736 vout.$1408.Metal4 vss.$1281.Metal5 0.0279225f
Cred_8737 vout.$1408.Metal4 vss.$1299.Metal5 0.0279225f
Cred_8738 vout.$1415.Metal4 vss 0.031639f
Cred_8739 vout.$1415.Metal4 vss.$1211.Metal5 0.0115449f
Cred_8740 vout.$1415.Metal4 vss.$1229.Metal5 0.0115449f
Cred_8741 vout.$1415.Metal4 vss.$1281.Metal5 0.0441916f
Cred_8742 vout.$1415.Metal4 vss.$1299.Metal5 0.0441916f
Cred_8743 vout.$1416.Metal4 vss 0.028465f
Cred_8744 vout.$1416.Metal4 vss.$1211.Metal5 0.0103867f
Cred_8745 vout.$1416.Metal4 vss.$1229.Metal5 0.0103867f
Cred_8746 vout.$1416.Metal4 vss.$1281.Metal5 0.0397582f
Cred_8747 vout.$1416.Metal4 vss.$1299.Metal5 0.0397582f
Cred_8748 vout.$15.Metal1 vss.$1281.Metal5 1.0906e-06f
Cred_8749 vout.$15.Metal1 vss.$140.Metal1 0.00454447f
Cred_8750 vout.$15.Metal1 vss.$143.Metal1 0.00090914f
Cred_8751 vout.$15.Metal1 vss.$483.Metal2 0.0337223f
Cred_8752 vout.$15.Metal1 vss.$487.Metal2 0.0145556f
Cred_8753 vout.$15.Metal1 vss.$489.Metal2 0.0287298f
Cred_8754 vout.$15.Metal1 vss.$493.Metal2 6.39866e-05f
Cred_8755 vout.$15.Metal1 vss.$495.Metal2 2.06408e-05f
Cred_8756 vout.$15.Metal1 vss.$819.Metal3 6.40307e-05f
Cred_8757 vout.$15.Metal1 vss.$821.Metal3 3.67857e-06f
Cred_8758 vout.$15.Metal1 vss.P0.pSD 8.27219e-06f
Cred_8759 vout.$15.Metal1 vss.P10.nSD 0.0321917f
Cred_8760 vout.$15.Metal1 vss.P11.nSD 0.0312983f
Cred_8761 vout.$15.Metal1 vss.P13.nSD 1.12735e-05f
Cred_8762 vout.$156.Metal1 vref 8.1265e-08f
Cred_8763 vout.$156.Metal1 vref.P0.GatPoly 3.16888e-09f
Cred_8764 vout.$156.Metal1 vref.P0.nSD 1.81661e-08f
Cred_8765 vout.$156.Metal1 vref.P0.pSD 5.35543e-08f
Cred_8766 vout.$156.Metal1 vss 1.38152e-05f
Cred_8767 vout.$156.Metal1 vss.$1211.Metal5 7.05409e-06f
Cred_8768 vout.$156.Metal1 vss.$1229.Metal5 7.05409e-06f
Cred_8769 vout.$156.Metal1 vss.$1281.Metal5 2.70016e-05f
Cred_8770 vout.$156.Metal1 vss.$1299.Metal5 2.70016e-05f
Cred_8771 vout.$157.Metal1 vref 1.02767e-07f
Cred_8772 vout.$157.Metal1 vref.P0.GatPoly 4.00734e-09f
Cred_8773 vout.$157.Metal1 vref.P0.nSD 2.29727e-08f
Cred_8774 vout.$157.Metal1 vref.P0.pSD 6.77243e-08f
Cred_8775 vout.$157.Metal1 vss 1.07737e-05f
Cred_8776 vout.$157.Metal1 vss.$1211.Metal5 5.94426e-06f
Cred_8777 vout.$157.Metal1 vss.$1229.Metal5 5.94426e-06f
Cred_8778 vout.$157.Metal1 vss.$1281.Metal5 2.27534e-05f
Cred_8779 vout.$157.Metal1 vss.$1299.Metal5 2.27534e-05f
Cred_8780 vout.$158.Metal1 vref 1.39741e-07f
Cred_8781 vout.$158.Metal1 vref.P0.GatPoly 5.44913e-09f
Cred_8782 vout.$158.Metal1 vref.P0.nSD 3.12381e-08f
Cred_8783 vout.$158.Metal1 vref.P0.pSD 9.20907e-08f
Cred_8784 vout.$158.Metal1 vss 7.47448e-06f
Cred_8785 vout.$158.Metal1 vss.$1211.Metal5 2.7274e-06f
Cred_8786 vout.$158.Metal1 vss.$1229.Metal5 2.7274e-06f
Cred_8787 vout.$158.Metal1 vss.$1281.Metal5 1.04399e-05f
Cred_8788 vout.$158.Metal1 vss.$1299.Metal5 1.04399e-05f
Cred_8789 vout.$159.Metal1 vref 2.18274e-07f
Cred_8790 vout.$159.Metal1 vref.P0.GatPoly 8.51146e-09f
Cred_8791 vout.$159.Metal1 vref.P0.nSD 4.87934e-08f
Cred_8792 vout.$159.Metal1 vref.P0.pSD 1.43844e-07f
Cred_8793 vout.$159.Metal1 vss 1.18601e-05f
Cred_8794 vout.$159.Metal1 vss.$1211.Metal5 4.32771e-06f
Cred_8795 vout.$159.Metal1 vss.$1229.Metal5 4.32771e-06f
Cred_8796 vout.$159.Metal1 vss.$1281.Metal5 1.65656e-05f
Cred_8797 vout.$159.Metal1 vss.$1299.Metal5 1.65656e-05f
Cred_8798 vout.$16.Metal1 vss.$1299.Metal5 1.0906e-06f
Cred_8799 vout.$16.Metal1 vss.$143.Metal1 0.00090914f
Cred_8800 vout.$16.Metal1 vss.$146.Metal1 0.00379239f
Cred_8801 vout.$16.Metal1 vss.$487.Metal2 2.06408e-05f
Cred_8802 vout.$16.Metal1 vss.$489.Metal2 6.39866e-05f
Cred_8803 vout.$16.Metal1 vss.$493.Metal2 0.030317f
Cred_8804 vout.$16.Metal1 vss.$495.Metal2 0.0150704f
Cred_8805 vout.$16.Metal1 vss.$499.Metal2 0.0337403f
Cred_8806 vout.$16.Metal1 vss.$829.Metal3 3.67857e-06f
Cred_8807 vout.$16.Metal1 vss.$831.Metal3 6.40631e-05f
Cred_8808 vout.$16.Metal1 vss.P0.pSD 8.27219e-06f
Cred_8809 vout.$16.Metal1 vss.P11.nSD 1.12735e-05f
Cred_8810 vout.$16.Metal1 vss.P13.nSD 0.0330625f
Cred_8811 vout.$16.Metal1 vss.P15.nSD 0.0321944f
Cred_8812 vout.$160.Metal1 vref 1.6756e-05f
Cred_8813 vout.$160.Metal1 vref.P0.GatPoly 6.53389e-07f
Cred_8814 vout.$160.Metal1 vref.P0.nSD 3.74566e-06f
Cred_8815 vout.$160.Metal1 vref.P0.pSD 2.07851e-05f
Cred_8816 vout.$160.Metal1 vss 1.15693e-05f
Cred_8817 vout.$160.Metal1 vss.$1211.Metal5 4.22158e-06f
Cred_8818 vout.$160.Metal1 vss.$1229.Metal5 4.22158e-06f
Cred_8819 vout.$160.Metal1 vss.$1281.Metal5 1.61593e-05f
Cred_8820 vout.$160.Metal1 vss.$1299.Metal5 1.61593e-05f
Cred_8821 vout.$161.Metal1 vref 2.57575e-06f
Cred_8822 vout.$161.Metal1 vref.P0.GatPoly 1.0044e-07f
Cred_8823 vout.$161.Metal1 vref.P0.nSD 5.75788e-07f
Cred_8824 vout.$161.Metal1 vref.P0.pSD 3.26178e-06f
Cred_8825 vout.$161.Metal1 vss 1.52321e-07f
Cred_8826 vout.$161.Metal1 vss.$1211.Metal5 5.55812e-08f
Cred_8827 vout.$161.Metal1 vss.$1229.Metal5 5.55812e-08f
Cred_8828 vout.$161.Metal1 vss.$1281.Metal5 2.12754e-07f
Cred_8829 vout.$161.Metal1 vss.$1299.Metal5 2.12754e-07f
Cred_8830 vout.$165.Metal1 vss 7.18419e-07f
Cred_8831 vout.$165.Metal1 vss.$1211.Metal5 2.62147e-07f
Cred_8832 vout.$165.Metal1 vss.$1229.Metal5 2.62147e-07f
Cred_8833 vout.$165.Metal1 vss.$1281.Metal5 1.00345e-06f
Cred_8834 vout.$165.Metal1 vss.$1299.Metal5 1.00345e-06f
Cred_8835 vout.$17.Metal1 vss.$1299.Metal5 1.0906e-06f
Cred_8836 vout.$17.Metal1 vss.$146.Metal1 6.09514e-05f
Cred_8837 vout.$17.Metal1 vss.$148.Metal1 0.00398408f
Cred_8838 vout.$17.Metal1 vss.$150.Metal1 5.0026e-05f
Cred_8839 vout.$17.Metal1 vss.$495.Metal2 0.00516938f
Cred_8840 vout.$17.Metal1 vss.$499.Metal2 0.0337486f
Cred_8841 vout.$17.Metal1 vss.$503.Metal2 0.0348196f
Cred_8842 vout.$17.Metal1 vss.$507.Metal2 0.00424278f
Cred_8843 vout.$17.Metal1 vss.$831.Metal3 6.09514e-05f
Cred_8844 vout.$17.Metal1 vss.$835.Metal3 6.89002e-06f
Cred_8845 vout.$17.Metal1 vss.$839.Metal3 5.0026e-05f
Cred_8846 vout.$17.Metal1 vss.P15.nSD 0.0321916f
Cred_8847 vout.$17.Metal1 vss.P17.nSD 0.0322594f
Cred_8848 vout.$18.Metal1 vss.$1299.Metal5 4.13819e-07f
Cred_8849 vout.$18.Metal1 vss.$150.Metal1 0.00420016f
Cred_8850 vout.$18.Metal1 vss.$153.Metal1 0.000555891f
Cred_8851 vout.$18.Metal1 vss.$503.Metal2 0.0346947f
Cred_8852 vout.$18.Metal1 vss.$507.Metal2 0.0157416f
Cred_8853 vout.$18.Metal1 vss.$509.Metal2 0.027614f
Cred_8854 vout.$18.Metal1 vss.$839.Metal3 5.16569e-05f
Cred_8855 vout.$18.Metal1 vss.$841.Metal3 9.49992e-07f
Cred_8856 vout.$18.Metal1 vss.P0.pSD 5.26863e-06f
Cred_8857 vout.$18.Metal1 vss.P17.nSD 0.0321796f
Cred_8858 vout.$18.Metal1 vss.P19.nSD 0.0321997f
Cred_8859 vout.$19.Metal1 vss.$1053.Metal4 5.81581e-08f
Cred_8860 vout.$19.Metal1 vss.$1055.Metal4 7.33687e-08f
Cred_8861 vout.$19.Metal1 vss.$1057.Metal4 5.10003e-08f
Cred_8862 vout.$19.Metal1 vss.$1299.Metal5 7.16029e-07f
Cred_8863 vout.$19.Metal1 vss.$153.Metal1 0.00398408f
Cred_8864 vout.$19.Metal1 vss.$507.Metal2 0.0114123f
Cred_8865 vout.$19.Metal1 vss.$509.Metal2 0.02763f
Cred_8866 vout.$19.Metal1 vss.$513.Metal2 0.0312534f
Cred_8867 vout.$19.Metal1 vss.$515.Metal2 0.00756443f
Cred_8868 vout.$19.Metal1 vss.$845.Metal3 2.98652e-06f
Cred_8869 vout.$19.Metal1 vss.P19.nSD 0.0321832f
Cred_8870 vout.$19.Metal1 vss.P21.nSD 0.0319557f
Cred_8871 vout.$20.Metal1 vss 3.03625e-10f
Cred_8872 vout.$20.Metal1 vss.$1057.Metal4 9.70492e-09f
Cred_8873 vout.$20.Metal1 vss.$1059.Metal4 3.10619e-08f
Cred_8874 vout.$20.Metal1 vss.$1061.Metal4 4.79307e-09f
Cred_8875 vout.$20.Metal1 vss.$1211.Metal5 3.13131e-10f
Cred_8876 vout.$20.Metal1 vss.$1229.Metal5 3.13131e-10f
Cred_8877 vout.$20.Metal1 vss.$1281.Metal5 1.1986e-09f
Cred_8878 vout.$20.Metal1 vss.$1299.Metal5 2.47616e-05f
Cred_8879 vout.$20.Metal1 vss.$153.Metal1 0.00104795f
Cred_8880 vout.$20.Metal1 vss.$156.Metal1 0.00370224f
Cred_8881 vout.$20.Metal1 vss.$513.Metal2 0.031621f
Cred_8882 vout.$20.Metal1 vss.$515.Metal2 0.0137191f
Cred_8883 vout.$20.Metal1 vss.$519.Metal2 0.0318795f
Cred_8884 vout.$20.Metal1 vss.$521.Metal2 0.000123436f
Cred_8885 vout.$20.Metal1 vss.$849.Metal3 1.39715e-06f
Cred_8886 vout.$20.Metal1 vss.$851.Metal3 7.11451e-05f
Cred_8887 vout.$20.Metal1 vss.P0.pSD 9.53556e-06f
Cred_8888 vout.$20.Metal1 vss.P21.nSD 0.0323826f
Cred_8889 vout.$20.Metal1 vss.P23.nSD 0.0313199f
Cred_8890 vout.$20.Metal1 vss.P25.nSD 1.75476e-05f
Cred_8891 vout.$206.Metal1 vss 2.02075e-06f
Cred_8892 vout.$206.Metal1 vss.$1211.Metal5 7.37362e-07f
Cred_8893 vout.$206.Metal1 vss.$1229.Metal5 7.37362e-07f
Cred_8894 vout.$206.Metal1 vss.$1281.Metal5 2.82247e-06f
Cred_8895 vout.$206.Metal1 vss.$1299.Metal5 2.82247e-06f
Cred_8896 vout.$207.Metal1 vss 2.02075e-06f
Cred_8897 vout.$207.Metal1 vss.$1211.Metal5 7.37362e-07f
Cred_8898 vout.$207.Metal1 vss.$1229.Metal5 7.37362e-07f
Cred_8899 vout.$207.Metal1 vss.$1281.Metal5 2.82247e-06f
Cred_8900 vout.$207.Metal1 vss.$1299.Metal5 2.82247e-06f
Cred_8901 vout.$208.Metal1 vss 2.02075e-06f
Cred_8902 vout.$208.Metal1 vss.$1211.Metal5 7.37362e-07f
Cred_8903 vout.$208.Metal1 vss.$1229.Metal5 7.37362e-07f
Cred_8904 vout.$208.Metal1 vss.$1281.Metal5 2.82247e-06f
Cred_8905 vout.$208.Metal1 vss.$1299.Metal5 2.82247e-06f
Cred_8906 vout.$209.Metal1 vss 2.02075e-06f
Cred_8907 vout.$209.Metal1 vss.$1211.Metal5 7.37362e-07f
Cred_8908 vout.$209.Metal1 vss.$1229.Metal5 7.37362e-07f
Cred_8909 vout.$209.Metal1 vss.$1281.Metal5 2.82247e-06f
Cred_8910 vout.$209.Metal1 vss.$1299.Metal5 2.82247e-06f
Cred_8911 vout.$210.Metal1 vss 2.02075e-06f
Cred_8912 vout.$210.Metal1 vss.$1211.Metal5 7.37362e-07f
Cred_8913 vout.$210.Metal1 vss.$1229.Metal5 7.37362e-07f
Cred_8914 vout.$210.Metal1 vss.$1281.Metal5 2.82247e-06f
Cred_8915 vout.$210.Metal1 vss.$1299.Metal5 2.82247e-06f
Cred_8916 vout.$226.Metal1 vss 2.14322e-07f
Cred_8917 vout.$226.Metal1 vss.$1211.Metal5 7.82051e-08f
Cred_8918 vout.$226.Metal1 vss.$1229.Metal5 7.82051e-08f
Cred_8919 vout.$226.Metal1 vss.$1281.Metal5 2.99353e-07f
Cred_8920 vout.$226.Metal1 vss.$1299.Metal5 2.99353e-07f
Cred_8921 vout.$227.Metal1 vss 2.14322e-07f
Cred_8922 vout.$227.Metal1 vss.$1211.Metal5 7.82051e-08f
Cred_8923 vout.$227.Metal1 vss.$1229.Metal5 7.82051e-08f
Cred_8924 vout.$227.Metal1 vss.$1281.Metal5 2.99353e-07f
Cred_8925 vout.$227.Metal1 vss.$1299.Metal5 2.99353e-07f
Cred_8926 vout.$228.Metal1 vss 2.14322e-07f
Cred_8927 vout.$228.Metal1 vss.$1211.Metal5 7.82051e-08f
Cred_8928 vout.$228.Metal1 vss.$1229.Metal5 7.82051e-08f
Cred_8929 vout.$228.Metal1 vss.$1281.Metal5 2.99353e-07f
Cred_8930 vout.$228.Metal1 vss.$1299.Metal5 2.99353e-07f
Cred_8931 vout.$229.Metal1 vss 2.14322e-07f
Cred_8932 vout.$229.Metal1 vss.$1211.Metal5 7.82051e-08f
Cred_8933 vout.$229.Metal1 vss.$1229.Metal5 7.82051e-08f
Cred_8934 vout.$229.Metal1 vss.$1281.Metal5 2.99353e-07f
Cred_8935 vout.$229.Metal1 vss.$1299.Metal5 2.99353e-07f
Cred_8936 vout.$230.Metal1 vss 2.14322e-07f
Cred_8937 vout.$230.Metal1 vss.$1211.Metal5 7.82051e-08f
Cred_8938 vout.$230.Metal1 vss.$1229.Metal5 7.82051e-08f
Cred_8939 vout.$230.Metal1 vss.$1281.Metal5 2.99353e-07f
Cred_8940 vout.$230.Metal1 vss.$1299.Metal5 2.99353e-07f
Cred_8941 vout.$396.Metal1 vss 1.06972e-05f
Cred_8942 vout.$396.Metal1 vss.$1211.Metal5 7.06712e-07f
Cred_8943 vout.$396.Metal1 vss.$1229.Metal5 7.06712e-07f
Cred_8944 vout.$396.Metal1 vss.$1281.Metal5 2.70515e-06f
Cred_8945 vout.$396.Metal1 vss.$1299.Metal5 2.70515e-06f
Cred_8946 vout.$404.Metal1 vss 4.82308e-08f
Cred_8947 vout.$404.Metal1 vss.$1211.Metal5 1.75992e-08f
Cred_8948 vout.$404.Metal1 vss.$1229.Metal5 1.75992e-08f
Cred_8949 vout.$404.Metal1 vss.$1281.Metal5 6.7366e-08f
Cred_8950 vout.$404.Metal1 vss.$1299.Metal5 6.7366e-08f
Cred_8951 vout.$405.Metal1 vss 2.21745e-06f
Cred_8952 vout.$405.Metal1 vss.$1211.Metal5 8.09137e-07f
Cred_8953 vout.$405.Metal1 vss.$1229.Metal5 8.09137e-07f
Cred_8954 vout.$405.Metal1 vss.$1281.Metal5 3.09721e-06f
Cred_8955 vout.$405.Metal1 vss.$1299.Metal5 3.09721e-06f
Cred_8956 vout.$436.Metal2 vss 2.21058e-06f
Cred_8957 vout.$436.Metal2 vss.$10.Metal1 0.000171631f
Cred_8958 vout.$436.Metal2 vss.$1009.Metal4 9.28158e-06f
Cred_8959 vout.$436.Metal2 vss.$1011.Metal4 6.01502e-05f
Cred_8960 vout.$436.Metal2 vss.$1013.Metal4 1.8804e-05f
Cred_8961 vout.$436.Metal2 vss.$1211.Metal5 2.27979e-06f
Cred_8962 vout.$436.Metal2 vss.$1229.Metal5 2.27979e-06f
Cred_8963 vout.$436.Metal2 vss.$1281.Metal5 0.00237605f
Cred_8964 vout.$436.Metal2 vss.$1299.Metal5 8.72657e-06f
Cred_8965 vout.$436.Metal2 vss.$13.Metal1 8.06894e-06f
Cred_8966 vout.$436.Metal2 vss.$461.Metal2 0.0136224f
Cred_8967 vout.$436.Metal2 vss.$463.Metal2 0.0625311f
Cred_8968 vout.$436.Metal2 vss.$467.Metal2 0.0297373f
Cred_8969 vout.$436.Metal2 vss.$469.Metal2 0.0590123f
Cred_8970 vout.$436.Metal2 vss.$799.Metal3 0.000264927f
Cred_8971 vout.$436.Metal2 vss.$801.Metal3 0.000206147f
Cred_8972 vout.$436.Metal2 vss.$805.Metal3 9.18546e-07f
Cred_8973 vout.$436.Metal2 vss.P0.nSD 0.00220566f
Cred_8974 vout.$436.Metal2 vss.P0.pSD 7.34212e-08f
Cred_8975 vout.$436.Metal2 vss.P1.nSD 0.0112334f
Cred_8976 vout.$436.Metal2 vss.P3.nSD 0.011338f
Cred_8977 vout.$438.Metal2 vss.$1281.Metal5 9.16037e-05f
Cred_8978 vout.$438.Metal2 vss.$13.Metal1 5.87859e-05f
Cred_8979 vout.$438.Metal2 vss.$467.Metal2 0.013877f
Cred_8980 vout.$438.Metal2 vss.$469.Metal2 0.0597666f
Cred_8981 vout.$438.Metal2 vss.$473.Metal2 0.0541238f
Cred_8982 vout.$438.Metal2 vss.$475.Metal2 0.0213516f
Cred_8983 vout.$438.Metal2 vss.$805.Metal3 0.000558783f
Cred_8984 vout.$438.Metal2 vss.P3.nSD 0.0110063f
Cred_8985 vout.$438.Metal2 vss.P5.nSD 0.0113092f
Cred_8986 vout.$440.Metal2 vss.$1281.Metal5 9.16037e-05f
Cred_8987 vout.$440.Metal2 vss.$13.Metal1 5.83487e-06f
Cred_8988 vout.$440.Metal2 vss.$136.Metal1 0.000144264f
Cred_8989 vout.$440.Metal2 vss.$473.Metal2 0.0502844f
Cred_8990 vout.$440.Metal2 vss.$475.Metal2 0.0323435f
Cred_8991 vout.$440.Metal2 vss.$479.Metal2 0.0663064f
Cred_8992 vout.$440.Metal2 vss.$809.Metal3 0.000210292f
Cred_8993 vout.$440.Metal2 vss.$811.Metal3 0.000429157f
Cred_8994 vout.$440.Metal2 vss.P0.pSD 5.53018e-08f
Cred_8995 vout.$440.Metal2 vss.P5.nSD 0.0110342f
Cred_8996 vout.$440.Metal2 vss.P7.nSD 0.0113049f
Cred_8997 vout.$442.Metal2 vss.$1281.Metal5 9.16037e-05f
Cred_8998 vout.$442.Metal2 vss.$136.Metal1 9.09373e-05f
Cred_8999 vout.$442.Metal2 vss.$138.Metal1 5.87859e-05f
Cred_9000 vout.$442.Metal2 vss.$140.Metal1 0.00011402f
Cred_9001 vout.$442.Metal2 vss.$475.Metal2 0.00771253f
Cred_9002 vout.$442.Metal2 vss.$479.Metal2 0.0657279f
Cred_9003 vout.$442.Metal2 vss.$483.Metal2 0.0655629f
Cred_9004 vout.$442.Metal2 vss.$487.Metal2 0.00967023f
Cred_9005 vout.$442.Metal2 vss.$811.Metal3 9.09373e-05f
Cred_9006 vout.$442.Metal2 vss.$815.Metal3 0.000558783f
Cred_9007 vout.$442.Metal2 vss.$819.Metal3 0.00011402f
Cred_9008 vout.$442.Metal2 vss.P10.nSD 0.0113234f
Cred_9009 vout.$442.Metal2 vss.P7.nSD 0.0110276f
Cred_9010 vout.$444.Metal2 vss.$1281.Metal5 9.16037e-05f
Cred_9011 vout.$444.Metal2 vss.$140.Metal1 0.000157927f
Cred_9012 vout.$444.Metal2 vss.$143.Metal1 6.62437e-06f
Cred_9013 vout.$444.Metal2 vss.$483.Metal2 0.0626363f
Cred_9014 vout.$444.Metal2 vss.$487.Metal2 0.031983f
Cred_9015 vout.$444.Metal2 vss.$489.Metal2 0.0549505f
Cred_9016 vout.$444.Metal2 vss.$493.Metal2 0.007016f
Cred_9017 vout.$444.Metal2 vss.$495.Metal2 0.00226323f
Cred_9018 vout.$444.Metal2 vss.$819.Metal3 0.000360292f
Cred_9019 vout.$444.Metal2 vss.$821.Metal3 0.000308977f
Cred_9020 vout.$444.Metal2 vss.P0.pSD 6.02746e-08f
Cred_9021 vout.$444.Metal2 vss.P10.nSD 0.0110524f
Cred_9022 vout.$444.Metal2 vss.P11.nSD 0.011228f
Cred_9023 vout.$444.Metal2 vss.P13.nSD 0.00140476f
Cred_9024 vout.$446.Metal2 vss.$1299.Metal5 9.16037e-05f
Cred_9025 vout.$446.Metal2 vss.$143.Metal1 6.62437e-06f
Cred_9026 vout.$446.Metal2 vss.$146.Metal1 0.000155368f
Cred_9027 vout.$446.Metal2 vss.$487.Metal2 0.00226323f
Cred_9028 vout.$446.Metal2 vss.$489.Metal2 0.007016f
Cred_9029 vout.$446.Metal2 vss.$493.Metal2 0.0551287f
Cred_9030 vout.$446.Metal2 vss.$495.Metal2 0.0322884f
Cred_9031 vout.$446.Metal2 vss.$499.Metal2 0.0642518f
Cred_9032 vout.$446.Metal2 vss.$829.Metal3 0.000308977f
Cred_9033 vout.$446.Metal2 vss.$831.Metal3 0.000363214f
Cred_9034 vout.$446.Metal2 vss.P0.pSD 6.02746e-08f
Cred_9035 vout.$446.Metal2 vss.P11.nSD 0.00140476f
Cred_9036 vout.$446.Metal2 vss.P13.nSD 0.0112928f
Cred_9037 vout.$446.Metal2 vss.P15.nSD 0.0113291f
Cred_9038 vout.$448.Metal2 vss.$1299.Metal5 9.16037e-05f
Cred_9039 vout.$448.Metal2 vss.$146.Metal1 0.000111114f
Cred_9040 vout.$448.Metal2 vss.$148.Metal1 5.87859e-05f
Cred_9041 vout.$448.Metal2 vss.$150.Metal1 9.33181e-05f
Cred_9042 vout.$448.Metal2 vss.$495.Metal2 0.00942371f
Cred_9043 vout.$448.Metal2 vss.$499.Metal2 0.0639558f
Cred_9044 vout.$448.Metal2 vss.$503.Metal2 0.0673826f
Cred_9045 vout.$448.Metal2 vss.$507.Metal2 0.00791445f
Cred_9046 vout.$448.Metal2 vss.$831.Metal3 0.000111114f
Cred_9047 vout.$448.Metal2 vss.$835.Metal3 0.000558783f
Cred_9048 vout.$448.Metal2 vss.$839.Metal3 9.33181e-05f
Cred_9049 vout.$448.Metal2 vss.P15.nSD 0.0110481f
Cred_9050 vout.$448.Metal2 vss.P17.nSD 0.0113036f
Cred_9051 vout.$450.Metal2 vss.$1299.Metal5 2.08013e-05f
Cred_9052 vout.$450.Metal2 vss.$150.Metal1 0.000137531f
Cred_9053 vout.$450.Metal2 vss.$153.Metal1 4.04534e-06f
Cred_9054 vout.$450.Metal2 vss.$503.Metal2 0.0641692f
Cred_9055 vout.$450.Metal2 vss.$507.Metal2 0.0324787f
Cred_9056 vout.$450.Metal2 vss.$509.Metal2 0.051252f
Cred_9057 vout.$450.Metal2 vss.$839.Metal3 0.000179709f
Cred_9058 vout.$450.Metal2 vss.$841.Metal3 4.77529e-05f
Cred_9059 vout.$450.Metal2 vss.P0.pSD 3.83409e-08f
Cred_9060 vout.$450.Metal2 vss.P17.nSD 0.0109434f
Cred_9061 vout.$450.Metal2 vss.P19.nSD 0.0112317f
Cred_9062 vout.$452.Metal2 vss.$1053.Metal4 2.92341e-06f
Cred_9063 vout.$452.Metal2 vss.$1055.Metal4 3.688e-06f
Cred_9064 vout.$452.Metal2 vss.$1057.Metal4 2.56361e-06f
Cred_9065 vout.$452.Metal2 vss.$1299.Metal5 3.59924e-05f
Cred_9066 vout.$452.Metal2 vss.$153.Metal1 5.87116e-05f
Cred_9067 vout.$452.Metal2 vss.$507.Metal2 0.020649f
Cred_9068 vout.$452.Metal2 vss.$509.Metal2 0.0524227f
Cred_9069 vout.$452.Metal2 vss.$513.Metal2 0.0608048f
Cred_9070 vout.$452.Metal2 vss.$515.Metal2 0.0141295f
Cred_9071 vout.$452.Metal2 vss.$845.Metal3 0.000150122f
Cred_9072 vout.$452.Metal2 vss.P19.nSD 0.0109477f
Cred_9073 vout.$452.Metal2 vss.P21.nSD 0.0111893f
Cred_9074 vout.$454.Metal2 vss 1.52622e-08f
Cred_9075 vout.$454.Metal2 vss.$1057.Metal4 4.87833e-07f
Cred_9076 vout.$454.Metal2 vss.$1059.Metal4 1.56138e-06f
Cred_9077 vout.$454.Metal2 vss.$1061.Metal4 2.40931e-07f
Cred_9078 vout.$454.Metal2 vss.$1211.Metal5 1.574e-08f
Cred_9079 vout.$454.Metal2 vss.$1229.Metal5 1.574e-08f
Cred_9080 vout.$454.Metal2 vss.$1281.Metal5 6.02496e-08f
Cred_9081 vout.$454.Metal2 vss.$1299.Metal5 0.00124468f
Cred_9082 vout.$454.Metal2 vss.$153.Metal1 7.62616e-06f
Cred_9083 vout.$454.Metal2 vss.$156.Metal1 0.0001693f
Cred_9084 vout.$454.Metal2 vss.$513.Metal2 0.0568081f
Cred_9085 vout.$454.Metal2 vss.$515.Metal2 0.029077f
Cred_9086 vout.$454.Metal2 vss.$519.Metal2 0.0618751f
Cred_9087 vout.$454.Metal2 vss.$521.Metal2 0.0135114f
Cred_9088 vout.$454.Metal2 vss.$849.Metal3 7.02298e-05f
Cred_9089 vout.$454.Metal2 vss.$851.Metal3 0.000185007f
Cred_9090 vout.$454.Metal2 vss.P0.pSD 6.93923e-08f
Cred_9091 vout.$454.Metal2 vss.P21.nSD 0.0109214f
Cred_9092 vout.$454.Metal2 vss.P23.nSD 0.0110842f
Cred_9093 vout.$454.Metal2 vss.P25.nSD 0.00218788f
Cred_9094 vout.$456.Metal2 vss.$10.Metal1 7.10536e-05f
Cred_9095 vout.$456.Metal2 vss.$461.Metal2 0.00712913f
Cred_9096 vout.$456.Metal2 vss.$463.Metal2 0.0328539f
Cred_9097 vout.$456.Metal2 vss.$467.Metal2 0.0136575f
Cred_9098 vout.$456.Metal2 vss.$469.Metal2 0.0314792f
Cred_9099 vout.$456.Metal2 vss.$799.Metal3 7.10536e-05f
Cred_9100 vout.$456.Metal2 vss.P0.nSD 0.00149747f
Cred_9101 vout.$456.Metal2 vss.P1.nSD 0.00781367f
Cred_9102 vout.$456.Metal2 vss.P3.nSD 0.00789535f
Cred_9103 vout.$458.Metal2 vss.$1281.Metal5 1.803e-05f
Cred_9104 vout.$458.Metal2 vss.$13.Metal1 1.89035e-08f
Cred_9105 vout.$458.Metal2 vss.$467.Metal2 0.0107711f
Cred_9106 vout.$458.Metal2 vss.$469.Metal2 0.0444317f
Cred_9107 vout.$458.Metal2 vss.$473.Metal2 0.0397229f
Cred_9108 vout.$458.Metal2 vss.$475.Metal2 0.0164367f
Cred_9109 vout.$458.Metal2 vss.$805.Metal3 0.000104135f
Cred_9110 vout.$458.Metal2 vss.P3.nSD 0.0114462f
Cred_9111 vout.$458.Metal2 vss.P5.nSD 0.0116638f
Cred_9112 vout.$460.Metal2 vss.$1281.Metal5 1.803e-05f
Cred_9113 vout.$460.Metal2 vss.$13.Metal1 1.87629e-09f
Cred_9114 vout.$460.Metal2 vss.$136.Metal1 7.18522e-05f
Cred_9115 vout.$460.Metal2 vss.$473.Metal2 0.03903f
Cred_9116 vout.$460.Metal2 vss.$475.Metal2 0.022244f
Cred_9117 vout.$460.Metal2 vss.$479.Metal2 0.0499283f
Cred_9118 vout.$460.Metal2 vss.$809.Metal3 4.13911e-05f
Cred_9119 vout.$460.Metal2 vss.$811.Metal3 0.000134576f
Cred_9120 vout.$460.Metal2 vss.P0.pSD 1.77831e-11f
Cred_9121 vout.$460.Metal2 vss.P5.nSD 0.0114679f
Cred_9122 vout.$460.Metal2 vss.P7.nSD 0.0116586f
Cred_9123 vout.$462.Metal2 vss.$1281.Metal5 1.803e-05f
Cred_9124 vout.$462.Metal2 vss.$136.Metal1 7.05843e-05f
Cred_9125 vout.$462.Metal2 vss.$138.Metal1 1.89035e-08f
Cred_9126 vout.$462.Metal2 vss.$140.Metal1 8.77741e-05f
Cred_9127 vout.$462.Metal2 vss.$475.Metal2 0.00598636f
Cred_9128 vout.$462.Metal2 vss.$479.Metal2 0.0490588f
Cred_9129 vout.$462.Metal2 vss.$483.Metal2 0.0485288f
Cred_9130 vout.$462.Metal2 vss.$487.Metal2 0.00744425f
Cred_9131 vout.$462.Metal2 vss.$811.Metal3 7.05843e-05f
Cred_9132 vout.$462.Metal2 vss.$815.Metal3 0.000104135f
Cred_9133 vout.$462.Metal2 vss.$819.Metal3 8.77741e-05f
Cred_9134 vout.$462.Metal2 vss.P10.nSD 0.0116748f
Cred_9135 vout.$462.Metal2 vss.P7.nSD 0.0114627f
Cred_9136 vout.$464.Metal2 vss.$1281.Metal5 1.803e-05f
Cred_9137 vout.$464.Metal2 vss.$140.Metal1 8.62846e-05f
Cred_9138 vout.$464.Metal2 vss.$143.Metal1 2.13016e-09f
Cred_9139 vout.$464.Metal2 vss.$483.Metal2 0.0476966f
Cred_9140 vout.$464.Metal2 vss.$487.Metal2 0.0208868f
Cred_9141 vout.$464.Metal2 vss.$489.Metal2 0.0420627f
Cred_9142 vout.$464.Metal2 vss.$493.Metal2 0.00544272f
Cred_9143 vout.$464.Metal2 vss.$495.Metal2 0.00175572f
Cred_9144 vout.$464.Metal2 vss.$819.Metal3 0.000132535f
Cred_9145 vout.$464.Metal2 vss.$821.Metal3 6.08149e-05f
Cred_9146 vout.$464.Metal2 vss.P0.pSD 1.93822e-11f
Cred_9147 vout.$464.Metal2 vss.P10.nSD 0.011482f
Cred_9148 vout.$464.Metal2 vss.P11.nSD 0.0115436f
Cred_9149 vout.$464.Metal2 vss.P13.nSD 0.00146362f
Cred_9150 vout.$466.Metal2 vss.$1299.Metal5 1.803e-05f
Cred_9151 vout.$466.Metal2 vss.$143.Metal1 2.13016e-09f
Cred_9152 vout.$466.Metal2 vss.$146.Metal1 8.78117e-05f
Cred_9153 vout.$466.Metal2 vss.$487.Metal2 0.00175572f
Cred_9154 vout.$466.Metal2 vss.$489.Metal2 0.00544272f
Cred_9155 vout.$466.Metal2 vss.$493.Metal2 0.0427238f
Cred_9156 vout.$466.Metal2 vss.$495.Metal2 0.0212297f
Cred_9157 vout.$466.Metal2 vss.$499.Metal2 0.0485419f
Cred_9158 vout.$466.Metal2 vss.$829.Metal3 6.08149e-05f
Cred_9159 vout.$466.Metal2 vss.$831.Metal3 0.000134064f
Cred_9160 vout.$466.Metal2 vss.P0.pSD 1.93822e-11f
Cred_9161 vout.$466.Metal2 vss.P11.nSD 0.00146362f
Cred_9162 vout.$466.Metal2 vss.P13.nSD 0.0117387f
Cred_9163 vout.$466.Metal2 vss.P15.nSD 0.011678f
Cred_9164 vout.$468.Metal2 vss.$1299.Metal5 1.803e-05f
Cred_9165 vout.$468.Metal2 vss.$146.Metal1 8.62617e-05f
Cred_9166 vout.$468.Metal2 vss.$148.Metal1 1.89035e-08f
Cred_9167 vout.$468.Metal2 vss.$150.Metal1 7.26401e-05f
Cred_9168 vout.$468.Metal2 vss.$495.Metal2 0.00731599f
Cred_9169 vout.$468.Metal2 vss.$499.Metal2 0.0476927f
Cred_9170 vout.$468.Metal2 vss.$503.Metal2 0.0504876f
Cred_9171 vout.$468.Metal2 vss.$507.Metal2 0.00616072f
Cred_9172 vout.$468.Metal2 vss.$831.Metal3 8.62617e-05f
Cred_9173 vout.$468.Metal2 vss.$835.Metal3 0.000104135f
Cred_9174 vout.$468.Metal2 vss.$839.Metal3 7.26401e-05f
Cred_9175 vout.$468.Metal2 vss.P15.nSD 0.0114811f
Cred_9176 vout.$468.Metal2 vss.P17.nSD 0.0117828f
Cred_9177 vout.$470.Metal2 vss.$150.Metal1 7.04216e-05f
Cred_9178 vout.$470.Metal2 vss.$503.Metal2 0.0489449f
Cred_9179 vout.$470.Metal2 vss.$507.Metal2 0.0223804f
Cred_9180 vout.$470.Metal2 vss.$509.Metal2 0.0396522f
Cred_9181 vout.$470.Metal2 vss.$839.Metal3 7.04216e-05f
Cred_9182 vout.$470.Metal2 vss.P17.nSD 0.0114431f
Cred_9183 vout.$470.Metal2 vss.P19.nSD 0.0116502f
Cred_9184 vout.$472.Metal2 vss.$507.Metal2 0.0161131f
Cred_9185 vout.$472.Metal2 vss.$509.Metal2 0.03894f
Cred_9186 vout.$472.Metal2 vss.$513.Metal2 0.0451114f
Cred_9187 vout.$472.Metal2 vss.$515.Metal2 0.0109361f
Cred_9188 vout.$472.Metal2 vss.P19.nSD 0.0114482f
Cred_9189 vout.$472.Metal2 vss.P21.nSD 0.0116213f
Cred_9190 vout.$474.Metal2 vss 1.1046e-05f
Cred_9191 vout.$474.Metal2 vss.$1211.Metal5 1.13918e-05f
Cred_9192 vout.$474.Metal2 vss.$1229.Metal5 1.13918e-05f
Cred_9193 vout.$474.Metal2 vss.$1281.Metal5 4.36055e-05f
Cred_9194 vout.$474.Metal2 vss.$1299.Metal5 4.36055e-05f
Cred_9195 vout.$474.Metal2 vss.$156.Metal1 0.000101734f
Cred_9196 vout.$474.Metal2 vss.$513.Metal2 0.0443234f
Cred_9197 vout.$474.Metal2 vss.$515.Metal2 0.0193733f
Cred_9198 vout.$474.Metal2 vss.$519.Metal2 0.0470642f
Cred_9199 vout.$474.Metal2 vss.$521.Metal2 0.0105134f
Cred_9200 vout.$474.Metal2 vss.$851.Metal3 0.000101734f
Cred_9201 vout.$474.Metal2 vss.P21.nSD 0.0114254f
Cred_9202 vout.$474.Metal2 vss.P23.nSD 0.0114716f
Cred_9203 vout.$474.Metal2 vss.P25.nSD 0.00229461f
Cred_9204 vout.$476.Metal2 vss 1.20256e-05f
Cred_9205 vout.$476.Metal2 vss.$10.Metal1 6.62281e-05f
Cred_9206 vout.$476.Metal2 vss.$1211.Metal5 1.24021e-05f
Cred_9207 vout.$476.Metal2 vss.$1229.Metal5 1.24021e-05f
Cred_9208 vout.$476.Metal2 vss.$1281.Metal5 4.74725e-05f
Cred_9209 vout.$476.Metal2 vss.$1299.Metal5 4.74725e-05f
Cred_9210 vout.$476.Metal2 vss.$461.Metal2 0.00688718f
Cred_9211 vout.$476.Metal2 vss.$463.Metal2 0.0306418f
Cred_9212 vout.$476.Metal2 vss.$467.Metal2 0.0125944f
Cred_9213 vout.$476.Metal2 vss.$469.Metal2 0.0287821f
Cred_9214 vout.$476.Metal2 vss.$799.Metal3 6.62281e-05f
Cred_9215 vout.$476.Metal2 vss.P0.nSD 0.00162297f
Cred_9216 vout.$476.Metal2 vss.P1.nSD 0.00789754f
Cred_9217 vout.$476.Metal2 vss.P3.nSD 0.00784077f
Cred_9218 vout.$496.Metal2 vss 9.40729e-05f
Cred_9219 vout.$496.Metal2 vss.$10.Metal1 6.34189e-05f
Cred_9220 vout.$496.Metal2 vss.$1211.Metal5 9.70181e-05f
Cred_9221 vout.$496.Metal2 vss.$1229.Metal5 9.70181e-05f
Cred_9222 vout.$496.Metal2 vss.$1281.Metal5 0.000371365f
Cred_9223 vout.$496.Metal2 vss.$1299.Metal5 0.000371365f
Cred_9224 vout.$496.Metal2 vss.$461.Metal2 0.00663082f
Cred_9225 vout.$496.Metal2 vss.$463.Metal2 0.0293449f
Cred_9226 vout.$496.Metal2 vss.$467.Metal2 0.0119988f
Cred_9227 vout.$496.Metal2 vss.$469.Metal2 0.027308f
Cred_9228 vout.$496.Metal2 vss.$799.Metal3 6.34189e-05f
Cred_9229 vout.$496.Metal2 vss.P0.nSD 0.00173084f
Cred_9230 vout.$496.Metal2 vss.P1.nSD 0.00861158f
Cred_9231 vout.$496.Metal2 vss.P3.nSD 0.00847065f
Cred_9232 vout.$498.Metal2 vref 5.91809e-06f
Cred_9233 vout.$498.Metal2 vref.P0.GatPoly 2.30772e-07f
Cred_9234 vout.$498.Metal2 vref.P0.nSD 1.92305e-06f
Cred_9235 vout.$498.Metal2 vref.P0.pSD 2.31877e-06f
Cred_9236 vout.$498.Metal2 vss 0.000135426f
Cred_9237 vout.$498.Metal2 vss.$1211.Metal5 0.000139666f
Cred_9238 vout.$498.Metal2 vss.$1229.Metal5 0.000139666f
Cred_9239 vout.$498.Metal2 vss.$127.Metal1 4.25733e-10f
Cred_9240 vout.$498.Metal2 vss.$1281.Metal5 0.000534612f
Cred_9241 vout.$498.Metal2 vss.$1299.Metal5 0.000534612f
Cred_9242 vout.$498.Metal2 vss.$406.Metal1 3.45591e-10f
Cred_9243 vout.$498.Metal2 vss.$457.Metal2 6.21777e-12f
Cred_9244 vout.$498.Metal2 vss.$467.Metal2 0.0100244f
Cred_9245 vout.$498.Metal2 vss.$469.Metal2 0.0413505f
Cred_9246 vout.$498.Metal2 vss.$473.Metal2 0.0364584f
Cred_9247 vout.$498.Metal2 vss.$475.Metal2 0.0150862f
Cred_9248 vout.$498.Metal2 vss.P0.GatPoly 1.52204e-11f
Cred_9249 vout.$498.Metal2 vss.P0.pSD 7.90567e-09f
Cred_9250 vout.$498.Metal2 vss.P3.nSD 0.0123005f
Cred_9251 vout.$498.Metal2 vss.P5.nSD 0.0123625f
Cred_9252 vout.$500.Metal2 vref 7.99308e-06f
Cred_9253 vout.$500.Metal2 vref.P0.GatPoly 3.11685e-07f
Cred_9254 vout.$500.Metal2 vref.P0.nSD 2.59701e-06f
Cred_9255 vout.$500.Metal2 vref.P0.pSD 3.13177e-06f
Cred_9256 vout.$500.Metal2 vss 0.000132151f
Cred_9257 vout.$500.Metal2 vss.$1211.Metal5 0.000136289f
Cred_9258 vout.$500.Metal2 vss.$1229.Metal5 0.000136289f
Cred_9259 vout.$500.Metal2 vss.$127.Metal1 3.29936e-10f
Cred_9260 vout.$500.Metal2 vss.$1281.Metal5 0.00055639f
Cred_9261 vout.$500.Metal2 vss.$1299.Metal5 0.000521685f
Cred_9262 vout.$500.Metal2 vss.$136.Metal1 6.59337e-05f
Cred_9263 vout.$500.Metal2 vss.$406.Metal1 4.46943e-10f
Cred_9264 vout.$500.Metal2 vss.$457.Metal2 4.81867e-12f
Cred_9265 vout.$500.Metal2 vss.$473.Metal2 0.036324f
Cred_9266 vout.$500.Metal2 vss.$475.Metal2 0.0206226f
Cred_9267 vout.$500.Metal2 vss.$479.Metal2 0.0458257f
Cred_9268 vout.$500.Metal2 vss.$811.Metal3 6.59337e-05f
Cred_9269 vout.$500.Metal2 vss.P0.GatPoly 1.17955e-11f
Cred_9270 vout.$500.Metal2 vss.P0.pSD 7.90494e-09f
Cred_9271 vout.$500.Metal2 vss.P5.nSD 0.0123207f
Cred_9272 vout.$500.Metal2 vss.P7.nSD 0.0123577f
Cred_9273 vout.$502.Metal2 vref 1.23147e-05f
Cred_9274 vout.$502.Metal2 vref.P0.GatPoly 4.80204e-07f
Cred_9275 vout.$502.Metal2 vref.P0.nSD 4.00021e-06f
Cred_9276 vout.$502.Metal2 vref.P0.pSD 4.82503e-06f
Cred_9277 vout.$502.Metal2 vss 1.70177e-05f
Cred_9278 vout.$502.Metal2 vss.$1211.Metal5 1.75505e-05f
Cred_9279 vout.$502.Metal2 vss.$1229.Metal5 1.75505e-05f
Cred_9280 vout.$502.Metal2 vss.$127.Metal1 2.56021e-10f
Cred_9281 vout.$502.Metal2 vss.$1281.Metal5 0.00136423f
Cred_9282 vout.$502.Metal2 vss.$1299.Metal5 6.71797e-05f
Cred_9283 vout.$502.Metal2 vss.$136.Metal1 6.4602e-05f
Cred_9284 vout.$502.Metal2 vss.$140.Metal1 8.18928e-05f
Cred_9285 vout.$502.Metal2 vss.$406.Metal1 5.77938e-10f
Cred_9286 vout.$502.Metal2 vss.$457.Metal2 3.73915e-12f
Cred_9287 vout.$502.Metal2 vss.$475.Metal2 0.00547899f
Cred_9288 vout.$502.Metal2 vss.$479.Metal2 0.0449001f
Cred_9289 vout.$502.Metal2 vss.$483.Metal2 0.0452764f
Cred_9290 vout.$502.Metal2 vss.$487.Metal2 0.00694545f
Cred_9291 vout.$502.Metal2 vss.$811.Metal3 6.4602e-05f
Cred_9292 vout.$502.Metal2 vss.$819.Metal3 8.18928e-05f
Cred_9293 vout.$502.Metal2 vss.P0.GatPoly 9.15299e-12f
Cred_9294 vout.$502.Metal2 vss.P0.pSD 7.85158e-09f
Cred_9295 vout.$502.Metal2 vss.P10.nSD 0.0125878f
Cred_9296 vout.$502.Metal2 vss.P7.nSD 0.0121009f
Cred_9297 vout.$504.Metal2 vref 0.000481372f
Cred_9298 vout.$504.Metal2 vref.P0.GatPoly 1.87708e-05f
Cred_9299 vout.$504.Metal2 vref.P0.nSD 0.000407478f
Cred_9300 vout.$504.Metal2 vref.P0.pSD 0.000188607f
Cred_9301 vout.$504.Metal2 vss 1.33953e-06f
Cred_9302 vout.$504.Metal2 vss.$1033.Metal4 4.8022e-09f
Cred_9303 vout.$504.Metal2 vss.$1037.Metal4 4.8022e-09f
Cred_9304 vout.$504.Metal2 vss.$1211.Metal5 1.38147e-06f
Cred_9305 vout.$504.Metal2 vss.$1229.Metal5 1.38147e-06f
Cred_9306 vout.$504.Metal2 vss.$1246.Metal5 1.26051e-06f
Cred_9307 vout.$504.Metal2 vss.$127.Metal1 1.99086e-10f
Cred_9308 vout.$504.Metal2 vss.$1281.Metal5 0.00144879f
Cred_9309 vout.$504.Metal2 vss.$1299.Metal5 5.28798e-06f
Cred_9310 vout.$504.Metal2 vss.$140.Metal1 8.02824e-05f
Cred_9311 vout.$504.Metal2 vss.$406.Metal1 7.47263e-10f
Cred_9312 vout.$504.Metal2 vss.$457.Metal2 2.90762e-12f
Cred_9313 vout.$504.Metal2 vss.$483.Metal2 0.0443861f
Cred_9314 vout.$504.Metal2 vss.$487.Metal2 0.0193248f
Cred_9315 vout.$504.Metal2 vss.$489.Metal2 0.0387994f
Cred_9316 vout.$504.Metal2 vss.$493.Metal2 0.00174639f
Cred_9317 vout.$504.Metal2 vss.$495.Metal2 0.000563353f
Cred_9318 vout.$504.Metal2 vss.$819.Metal3 8.02824e-05f
Cred_9319 vout.$504.Metal2 vss.$825.Metal3 5.6622e-11f
Cred_9320 vout.$504.Metal2 vss.P0.GatPoly 7.1175e-12f
Cred_9321 vout.$504.Metal2 vss.P0.pSD 7.74206e-09f
Cred_9322 vout.$504.Metal2 vss.P10.nSD 0.0123331f
Cred_9323 vout.$504.Metal2 vss.P11.nSD 0.0122849f
Cred_9324 vout.$504.Metal2 vss.P13.nSD 0.000507049f
Cred_9325 vout.$506.Metal2 vref 7.19511e-05f
Cred_9326 vout.$506.Metal2 vref.P0.GatPoly 2.80569e-06f
Cred_9327 vout.$506.Metal2 vref.P0.nSD 6.75413e-05f
Cred_9328 vout.$506.Metal2 vref.P0.pSD 2.81912e-05f
Cred_9329 vout.$506.Metal2 vss.$1299.Metal5 2.53533e-05f
Cred_9330 vout.$506.Metal2 vss.$146.Metal1 7.91146e-05f
Cred_9331 vout.$506.Metal2 vss.$487.Metal2 0.000563353f
Cred_9332 vout.$506.Metal2 vss.$489.Metal2 0.00174639f
Cred_9333 vout.$506.Metal2 vss.$493.Metal2 0.040346f
Cred_9334 vout.$506.Metal2 vss.$495.Metal2 0.0197247f
Cred_9335 vout.$506.Metal2 vss.$499.Metal2 0.0437404f
Cred_9336 vout.$506.Metal2 vss.$831.Metal3 7.91146e-05f
Cred_9337 vout.$506.Metal2 vss.P11.nSD 0.000507049f
Cred_9338 vout.$506.Metal2 vss.P13.nSD 0.0127878f
Cred_9339 vout.$506.Metal2 vss.P15.nSD 0.0121451f
Cred_9340 vout.$508.Metal2 vss.$146.Metal1 8.14521e-05f
Cred_9341 vout.$508.Metal2 vss.$150.Metal1 6.47488e-05f
Cred_9342 vout.$508.Metal2 vss.$495.Metal2 0.00690808f
Cred_9343 vout.$508.Metal2 vss.$499.Metal2 0.0450328f
Cred_9344 vout.$508.Metal2 vss.$503.Metal2 0.0450022f
Cred_9345 vout.$508.Metal2 vss.$507.Metal2 0.00549145f
Cred_9346 vout.$508.Metal2 vss.$831.Metal3 8.14521e-05f
Cred_9347 vout.$508.Metal2 vss.$839.Metal3 6.47488e-05f
Cred_9348 vout.$508.Metal2 vss.P15.nSD 0.0125137f
Cred_9349 vout.$508.Metal2 vss.P17.nSD 0.0121305f
Cred_9350 vout.$510.Metal2 vss.$150.Metal1 6.66618e-05f
Cred_9351 vout.$510.Metal2 vss.$503.Metal2 0.0463318f
Cred_9352 vout.$510.Metal2 vss.$507.Metal2 0.0204688f
Cred_9353 vout.$510.Metal2 vss.$509.Metal2 0.0358032f
Cred_9354 vout.$510.Metal2 vss.$839.Metal3 6.66618e-05f
Cred_9355 vout.$510.Metal2 vss.P17.nSD 0.0124987f
Cred_9356 vout.$510.Metal2 vss.P19.nSD 0.0121353f
Cred_9357 vout.$512.Metal2 vss.$507.Metal2 0.0152529f
Cred_9358 vout.$512.Metal2 vss.$509.Metal2 0.0368611f
Cred_9359 vout.$512.Metal2 vss.$513.Metal2 0.0407511f
Cred_9360 vout.$512.Metal2 vss.$515.Metal2 0.00987906f
Cred_9361 vout.$512.Metal2 vss.P19.nSD 0.0125036f
Cred_9362 vout.$512.Metal2 vss.P21.nSD 0.0121084f
Cred_9363 vout.$514.Metal2 vss 1.14674e-05f
Cred_9364 vout.$514.Metal2 vss.$1211.Metal5 1.18264e-05f
Cred_9365 vout.$514.Metal2 vss.$1229.Metal5 1.18264e-05f
Cred_9366 vout.$514.Metal2 vss.$1281.Metal5 4.52691e-05f
Cred_9367 vout.$514.Metal2 vss.$1299.Metal5 4.52691e-05f
Cred_9368 vout.$514.Metal2 vss.$156.Metal1 9.37329e-05f
Cred_9369 vout.$514.Metal2 vss.$513.Metal2 0.0419614f
Cred_9370 vout.$514.Metal2 vss.$515.Metal2 0.0181221f
Cred_9371 vout.$514.Metal2 vss.$519.Metal2 0.0433883f
Cred_9372 vout.$514.Metal2 vss.$521.Metal2 0.0100113f
Cred_9373 vout.$514.Metal2 vss.$851.Metal3 9.37329e-05f
Cred_9374 vout.$514.Metal2 vss.P21.nSD 0.012488f
Cred_9375 vout.$514.Metal2 vss.P23.nSD 0.0121917f
Cred_9376 vout.$514.Metal2 vss.P25.nSD 0.00252773f
Cred_9377 vout.$516.Metal2 vref 9.93283e-06f
Cred_9378 vout.$516.Metal2 vref.P0.GatPoly 3.87324e-07f
Cred_9379 vout.$516.Metal2 vref.P0.nSD 3.22203e-06f
Cred_9380 vout.$516.Metal2 vref.P0.pSD 3.89178e-06f
Cred_9381 vout.$516.Metal2 vss 0.000458645f
Cred_9382 vout.$516.Metal2 vss.$10.Metal1 0.000112995f
Cred_9383 vout.$516.Metal2 vss.$1211.Metal5 0.000473004f
Cred_9384 vout.$516.Metal2 vss.$1229.Metal5 0.000473004f
Cred_9385 vout.$516.Metal2 vss.$127.Metal1 1.69205e-06f
Cred_9386 vout.$516.Metal2 vss.$1281.Metal5 0.00181056f
Cred_9387 vout.$516.Metal2 vss.$1299.Metal5 0.00181056f
Cred_9388 vout.$516.Metal2 vss.$406.Metal1 8.22252e-07f
Cred_9389 vout.$516.Metal2 vss.$457.Metal2 2.47121e-08f
Cred_9390 vout.$516.Metal2 vss.$461.Metal2 0.0119804f
Cred_9391 vout.$516.Metal2 vss.$463.Metal2 0.0522976f
Cred_9392 vout.$516.Metal2 vss.$467.Metal2 0.021493f
Cred_9393 vout.$516.Metal2 vss.$469.Metal2 0.0491277f
Cred_9394 vout.$516.Metal2 vss.$799.Metal3 0.000112995f
Cred_9395 vout.$516.Metal2 vss.P0.GatPoly 6.04923e-08f
Cred_9396 vout.$516.Metal2 vss.P0.nSD 0.00337948f
Cred_9397 vout.$516.Metal2 vss.P0.pSD 2.41721e-05f
Cred_9398 vout.$516.Metal2 vss.P1.nSD 0.0163395f
Cred_9399 vout.$516.Metal2 vss.P3.nSD 0.0162389f
Cred_9400 vout.$518.Metal2 vref 2.31299e-05f
Cred_9401 vout.$518.Metal2 vref.P0.GatPoly 9.01937e-07f
Cred_9402 vout.$518.Metal2 vref.P0.nSD 7.50865e-06f
Cred_9403 vout.$518.Metal2 vref.P0.pSD 9.06254e-06f
Cred_9404 vout.$518.Metal2 vss 0.000471526f
Cred_9405 vout.$518.Metal2 vss.$1211.Metal5 0.000486288f
Cred_9406 vout.$518.Metal2 vss.$1229.Metal5 0.000486288f
Cred_9407 vout.$518.Metal2 vss.$127.Metal1 1.31107e-06f
Cred_9408 vout.$518.Metal2 vss.$1281.Metal5 0.00186141f
Cred_9409 vout.$518.Metal2 vss.$1299.Metal5 0.00186141f
Cred_9410 vout.$518.Metal2 vss.$406.Metal1 1.06426e-06f
Cred_9411 vout.$518.Metal2 vss.$457.Metal2 1.91479e-08f
Cred_9412 vout.$518.Metal2 vss.$467.Metal2 0.0118734f
Cred_9413 vout.$518.Metal2 vss.$469.Metal2 0.0489776f
Cred_9414 vout.$518.Metal2 vss.$473.Metal2 0.0437581f
Cred_9415 vout.$518.Metal2 vss.$475.Metal2 0.0181068f
Cred_9416 vout.$518.Metal2 vss.P0.GatPoly 4.68719e-08f
Cred_9417 vout.$518.Metal2 vss.P0.pSD 2.43459e-05f
Cred_9418 vout.$518.Metal2 vss.P3.nSD 0.0161846f
Cred_9419 vout.$518.Metal2 vss.P5.nSD 0.016488f
Cred_9420 vout.$520.Metal2 vref 3.12516e-05f
Cred_9421 vout.$520.Metal2 vref.P0.GatPoly 1.21864e-06f
Cred_9422 vout.$520.Metal2 vref.P0.nSD 1.01441e-05f
Cred_9423 vout.$520.Metal2 vref.P0.pSD 1.22447e-05f
Cred_9424 vout.$520.Metal2 vss 0.000356999f
Cred_9425 vout.$520.Metal2 vss.$1211.Metal5 0.000368176f
Cred_9426 vout.$520.Metal2 vss.$1229.Metal5 0.000368176f
Cred_9427 vout.$520.Metal2 vss.$127.Metal1 1.01605e-06f
Cred_9428 vout.$520.Metal2 vss.$1281.Metal5 0.00148046f
Cred_9429 vout.$520.Metal2 vss.$1299.Metal5 0.0014093f
Cred_9430 vout.$520.Metal2 vss.$136.Metal1 7.91348e-05f
Cred_9431 vout.$520.Metal2 vss.$406.Metal1 1.37638e-06f
Cred_9432 vout.$520.Metal2 vss.$457.Metal2 1.48393e-08f
Cred_9433 vout.$520.Metal2 vss.$473.Metal2 0.042971f
Cred_9434 vout.$520.Metal2 vss.$475.Metal2 0.0244926f
Cred_9435 vout.$520.Metal2 vss.$479.Metal2 0.0550008f
Cred_9436 vout.$520.Metal2 vss.$811.Metal3 7.91348e-05f
Cred_9437 vout.$520.Metal2 vss.P0.GatPoly 3.63249e-08f
Cred_9438 vout.$520.Metal2 vss.P0.pSD 2.43436e-05f
Cred_9439 vout.$520.Metal2 vss.P5.nSD 0.0161885f
Cred_9440 vout.$520.Metal2 vss.P7.nSD 0.0164823f
Cred_9441 vout.$522.Metal2 vref 4.8186e-05f
Cred_9442 vout.$522.Metal2 vref.P0.GatPoly 1.87898e-06f
Cred_9443 vout.$522.Metal2 vref.P0.nSD 1.56374e-05f
Cred_9444 vout.$522.Metal2 vref.P0.pSD 1.88798e-05f
Cred_9445 vout.$522.Metal2 vss 0.000216952f
Cred_9446 vout.$522.Metal2 vss.$1211.Metal5 0.000223744f
Cred_9447 vout.$522.Metal2 vss.$1229.Metal5 0.000223744f
Cred_9448 vout.$522.Metal2 vss.$127.Metal1 7.88428e-07f
Cred_9449 vout.$522.Metal2 vss.$1281.Metal5 0.00172578f
Cred_9450 vout.$522.Metal2 vss.$1299.Metal5 0.000856448f
Cred_9451 vout.$522.Metal2 vss.$136.Metal1 7.6828e-05f
Cred_9452 vout.$522.Metal2 vss.$140.Metal1 9.80087e-05f
Cred_9453 vout.$522.Metal2 vss.$406.Metal1 1.77979e-06f
Cred_9454 vout.$522.Metal2 vss.$457.Metal2 1.15149e-08f
Cred_9455 vout.$522.Metal2 vss.$475.Metal2 0.0065159f
Cred_9456 vout.$522.Metal2 vss.$479.Metal2 0.0533975f
Cred_9457 vout.$522.Metal2 vss.$483.Metal2 0.0541865f
Cred_9458 vout.$522.Metal2 vss.$487.Metal2 0.00831227f
Cred_9459 vout.$522.Metal2 vss.$811.Metal3 7.6828e-05f
Cred_9460 vout.$522.Metal2 vss.$819.Metal3 9.80087e-05f
Cred_9461 vout.$522.Metal2 vss.P0.GatPoly 2.81871e-08f
Cred_9462 vout.$522.Metal2 vss.P0.pSD 2.41793e-05f
Cred_9463 vout.$522.Metal2 vss.P10.nSD 0.0167248f
Cred_9464 vout.$522.Metal2 vss.P7.nSD 0.0159985f
Cred_9465 vout.$524.Metal2 vref 0.00174436f
Cred_9466 vout.$524.Metal2 vref.P0.GatPoly 6.80202e-05f
Cred_9467 vout.$524.Metal2 vref.P0.nSD 0.00145373f
Cred_9468 vout.$524.Metal2 vref.P0.pSD 0.000683458f
Cred_9469 vout.$524.Metal2 vss 5.50377e-06f
Cred_9470 vout.$524.Metal2 vss.$1033.Metal4 1.68148e-08f
Cred_9471 vout.$524.Metal2 vss.$1037.Metal4 1.68148e-08f
Cred_9472 vout.$524.Metal2 vss.$1211.Metal5 5.67608e-06f
Cred_9473 vout.$524.Metal2 vss.$1229.Metal5 5.67608e-06f
Cred_9474 vout.$524.Metal2 vss.$1246.Metal5 4.41364e-06f
Cred_9475 vout.$524.Metal2 vss.$127.Metal1 6.13094e-07f
Cred_9476 vout.$524.Metal2 vss.$1281.Metal5 0.00350801f
Cred_9477 vout.$524.Metal2 vss.$1299.Metal5 2.17269e-05f
Cred_9478 vout.$524.Metal2 vss.$140.Metal1 9.51928e-05f
Cred_9479 vout.$524.Metal2 vss.$406.Metal1 2.30123e-06f
Cred_9480 vout.$524.Metal2 vss.$457.Metal2 8.95415e-09f
Cred_9481 vout.$524.Metal2 vss.$483.Metal2 0.0526297f
Cred_9482 vout.$524.Metal2 vss.$487.Metal2 0.0228779f
Cred_9483 vout.$524.Metal2 vss.$489.Metal2 0.0458937f
Cred_9484 vout.$524.Metal2 vss.$819.Metal3 9.51928e-05f
Cred_9485 vout.$524.Metal2 vss.$825.Metal3 1.9826e-10f
Cred_9486 vout.$524.Metal2 vss.P0.GatPoly 2.19187e-08f
Cred_9487 vout.$524.Metal2 vss.P0.pSD 2.3842e-05f
Cred_9488 vout.$524.Metal2 vss.P10.nSD 0.0162421f
Cred_9489 vout.$524.Metal2 vss.P11.nSD 0.0161578f
Cred_9490 vout.$526.Metal2 vref 0.000142037f
Cred_9491 vout.$526.Metal2 vref.P0.GatPoly 5.53865e-06f
Cred_9492 vout.$526.Metal2 vref.P0.nSD 0.000123589f
Cred_9493 vout.$526.Metal2 vref.P0.pSD 5.56516e-05f
Cred_9494 vout.$526.Metal2 vss.$127.Metal1 3.74227e-07f
Cred_9495 vout.$526.Metal2 vss.$1299.Metal5 3.4594e-05f
Cred_9496 vout.$526.Metal2 vss.$146.Metal1 9.41789e-05f
Cred_9497 vout.$526.Metal2 vss.$406.Metal1 3.71714e-06f
Cred_9498 vout.$526.Metal2 vss.$457.Metal2 5.46554e-09f
Cred_9499 vout.$526.Metal2 vss.$493.Metal2 0.0465721f
Cred_9500 vout.$526.Metal2 vss.$495.Metal2 0.0230107f
Cred_9501 vout.$526.Metal2 vss.$499.Metal2 0.0520691f
Cred_9502 vout.$526.Metal2 vss.$831.Metal3 9.41789e-05f
Cred_9503 vout.$526.Metal2 vss.P0.GatPoly 1.3379e-08f
Cred_9504 vout.$526.Metal2 vss.P0.pSD 2.26429e-05f
Cred_9505 vout.$526.Metal2 vss.P13.nSD 0.0164057f
Cred_9506 vout.$526.Metal2 vss.P15.nSD 0.0160727f
Cred_9507 vout.$528.Metal2 vss.$127.Metal1 2.85834e-07f
Cred_9508 vout.$528.Metal2 vss.$146.Metal1 9.45857e-05f
Cred_9509 vout.$528.Metal2 vss.$150.Metal1 7.70777e-05f
Cred_9510 vout.$528.Metal2 vss.$406.Metal1 4.76669e-06f
Cred_9511 vout.$528.Metal2 vss.$457.Metal2 4.17457e-09f
Cred_9512 vout.$528.Metal2 vss.$495.Metal2 0.00802196f
Cred_9513 vout.$528.Metal2 vss.$499.Metal2 0.052294f
Cred_9514 vout.$528.Metal2 vss.$503.Metal2 0.0535711f
Cred_9515 vout.$528.Metal2 vss.$507.Metal2 0.00653708f
Cred_9516 vout.$528.Metal2 vss.$831.Metal3 9.45857e-05f
Cred_9517 vout.$528.Metal2 vss.$839.Metal3 7.70777e-05f
Cred_9518 vout.$528.Metal2 vss.P0.GatPoly 1.02189e-08f
Cred_9519 vout.$528.Metal2 vss.P0.pSD 2.16862e-05f
Cred_9520 vout.$528.Metal2 vss.P15.nSD 0.0161401f
Cred_9521 vout.$528.Metal2 vss.P17.nSD 0.0160553f
Cred_9522 vout.$530.Metal2 vss.$127.Metal1 1.86562e-07f
Cred_9523 vout.$530.Metal2 vss.$150.Metal1 7.74106e-05f
Cred_9524 vout.$530.Metal2 vss.$406.Metal1 5.28685e-06f
Cred_9525 vout.$530.Metal2 vss.$457.Metal2 2.72472e-09f
Cred_9526 vout.$530.Metal2 vss.$503.Metal2 0.0538025f
Cred_9527 vout.$530.Metal2 vss.$507.Metal2 0.0242014f
Cred_9528 vout.$530.Metal2 vss.$509.Metal2 0.0426206f
Cred_9529 vout.$530.Metal2 vss.$839.Metal3 7.74106e-05f
Cred_9530 vout.$530.Metal2 vss.P0.GatPoly 6.66978e-09f
Cred_9531 vout.$530.Metal2 vss.P0.pSD 1.75816e-05f
Cred_9532 vout.$530.Metal2 vss.P17.nSD 0.0161227f
Cred_9533 vout.$530.Metal2 vss.P19.nSD 0.016061f
Cred_9534 vout.$532.Metal2 vss.$127.Metal1 1.39074e-07f
Cred_9535 vout.$532.Metal2 vss.$406.Metal1 6.81488e-06f
Cred_9536 vout.$532.Metal2 vss.$457.Metal2 2.03115e-09f
Cred_9537 vout.$532.Metal2 vss.$507.Metal2 0.0177123f
Cred_9538 vout.$532.Metal2 vss.$509.Metal2 0.0428047f
Cred_9539 vout.$532.Metal2 vss.$513.Metal2 0.0485158f
Cred_9540 vout.$532.Metal2 vss.$515.Metal2 0.0117614f
Cred_9541 vout.$532.Metal2 vss.P0.GatPoly 4.97203e-09f
Cred_9542 vout.$532.Metal2 vss.P0.pSD 1.61035e-05f
Cred_9543 vout.$532.Metal2 vss.P19.nSD 0.0161283f
Cred_9544 vout.$532.Metal2 vss.P21.nSD 0.0160345f
Cred_9545 vout.$534.Metal2 vss 1.7708e-05f
Cred_9546 vout.$534.Metal2 vss.$1211.Metal5 1.82624e-05f
Cred_9547 vout.$534.Metal2 vss.$1229.Metal5 1.82624e-05f
Cred_9548 vout.$534.Metal2 vss.$127.Metal1 1.16932e-07f
Cred_9549 vout.$534.Metal2 vss.$1281.Metal5 6.99046e-05f
Cred_9550 vout.$534.Metal2 vss.$1299.Metal5 6.99046e-05f
Cred_9551 vout.$534.Metal2 vss.$156.Metal1 0.000110063f
Cred_9552 vout.$534.Metal2 vss.$406.Metal1 1.02014e-05f
Cred_9553 vout.$534.Metal2 vss.$457.Metal2 1.70777e-09f
Cred_9554 vout.$534.Metal2 vss.$513.Metal2 0.0487305f
Cred_9555 vout.$534.Metal2 vss.$515.Metal2 0.021148f
Cred_9556 vout.$534.Metal2 vss.$519.Metal2 0.0509592f
Cred_9557 vout.$534.Metal2 vss.$521.Metal2 0.0119061f
Cred_9558 vout.$534.Metal2 vss.$851.Metal3 0.000110063f
Cred_9559 vout.$534.Metal2 vss.P0.GatPoly 4.18042e-09f
Cred_9560 vout.$534.Metal2 vss.P0.pSD 1.64288e-05f
Cred_9561 vout.$534.Metal2 vss.P21.nSD 0.0161073f
Cred_9562 vout.$534.Metal2 vss.P23.nSD 0.0159106f
Cred_9563 vout.$534.Metal2 vss.P25.nSD 0.00335853f
Cred_9564 vout.$584.Metal2 vref 7.32869e-06f
Cred_9565 vout.$584.Metal2 vref.P0.GatPoly 2.85778e-07f
Cred_9566 vout.$584.Metal2 vref.P0.nSD 1.63827e-06f
Cred_9567 vout.$584.Metal2 vref.P0.pSD 4.83063e-06f
Cred_9568 vout.$584.Metal2 vss 0.00117931f
Cred_9569 vout.$584.Metal2 vss.$1211.Metal5 0.000532435f
Cred_9570 vout.$584.Metal2 vss.$1229.Metal5 0.000532435f
Cred_9571 vout.$584.Metal2 vss.$1281.Metal5 0.00203805f
Cred_9572 vout.$584.Metal2 vss.$1299.Metal5 0.00203805f
Cred_9573 vout.$586.Metal2 vref 9.2678e-06f
Cred_9574 vout.$586.Metal2 vref.P0.GatPoly 3.61392e-07f
Cred_9575 vout.$586.Metal2 vref.P0.nSD 2.07174e-06f
Cred_9576 vout.$586.Metal2 vref.P0.pSD 6.10877e-06f
Cred_9577 vout.$586.Metal2 vss 0.00089156f
Cred_9578 vout.$586.Metal2 vss.$1211.Metal5 0.000427435f
Cred_9579 vout.$586.Metal2 vss.$1229.Metal5 0.000427435f
Cred_9580 vout.$586.Metal2 vss.$1281.Metal5 0.00163613f
Cred_9581 vout.$586.Metal2 vss.$1299.Metal5 0.00163613f
Cred_9582 vout.$588.Metal2 vref 1.26022e-05f
Cred_9583 vout.$588.Metal2 vref.P0.GatPoly 4.91417e-07f
Cred_9584 vout.$588.Metal2 vref.P0.nSD 2.81713e-06f
Cred_9585 vout.$588.Metal2 vref.P0.pSD 8.30664e-06f
Cred_9586 vout.$588.Metal2 vss 0.000727798f
Cred_9587 vout.$588.Metal2 vss.$1211.Metal5 0.00026557f
Cred_9588 vout.$588.Metal2 vss.$1229.Metal5 0.00026557f
Cred_9589 vout.$588.Metal2 vss.$1281.Metal5 0.00101655f
Cred_9590 vout.$588.Metal2 vss.$1299.Metal5 0.00101655f
Cred_9591 vout.$590.Metal2 vref 1.96845e-05f
Cred_9592 vout.$590.Metal2 vref.P0.GatPoly 7.67586e-07f
Cred_9593 vout.$590.Metal2 vref.P0.nSD 4.40031e-06f
Cred_9594 vout.$590.Metal2 vref.P0.pSD 1.29748e-05f
Cred_9595 vout.$590.Metal2 vss 0.000948141f
Cred_9596 vout.$590.Metal2 vss.$1211.Metal5 0.000345972f
Cred_9597 vout.$590.Metal2 vss.$1229.Metal5 0.000345972f
Cred_9598 vout.$590.Metal2 vss.$1281.Metal5 0.00132431f
Cred_9599 vout.$590.Metal2 vss.$1299.Metal5 0.00132431f
Cred_9600 vout.$592.Metal2 vref 0.00159282f
Cred_9601 vout.$592.Metal2 vref.P0.GatPoly 6.21111e-05f
Cred_9602 vout.$592.Metal2 vref.P0.nSD 0.000356062f
Cred_9603 vout.$592.Metal2 vref.P0.pSD 0.00198051f
Cred_9604 vout.$592.Metal2 vss 0.000920693f
Cred_9605 vout.$592.Metal2 vss.$1211.Metal5 0.000335956f
Cred_9606 vout.$592.Metal2 vss.$1229.Metal5 0.000335956f
Cred_9607 vout.$592.Metal2 vss.$1281.Metal5 0.00128597f
Cred_9608 vout.$592.Metal2 vss.$1299.Metal5 0.00128597f
Cred_9609 vout.$594.Metal2 vref 0.000129325f
Cred_9610 vout.$594.Metal2 vref.P0.GatPoly 5.04294e-06f
Cred_9611 vout.$594.Metal2 vref.P0.nSD 2.89095e-05f
Cred_9612 vout.$594.Metal2 vref.P0.pSD 0.000163769f
Cred_9613 vout.$594.Metal2 vss 7.64782e-06f
Cred_9614 vout.$594.Metal2 vss.$1211.Metal5 2.79065e-06f
Cred_9615 vout.$594.Metal2 vss.$1229.Metal5 2.79065e-06f
Cred_9616 vout.$594.Metal2 vss.$1281.Metal5 1.0682e-05f
Cred_9617 vout.$594.Metal2 vss.$1299.Metal5 1.0682e-05f
Cred_9618 vout.$602.Metal2 vss 3.60707e-05f
Cred_9619 vout.$602.Metal2 vss.$1211.Metal5 1.3162e-05f
Cred_9620 vout.$602.Metal2 vss.$1229.Metal5 1.3162e-05f
Cred_9621 vout.$602.Metal2 vss.$1281.Metal5 5.03816e-05f
Cred_9622 vout.$602.Metal2 vss.$1299.Metal5 5.03816e-05f
Cred_9623 vout.$604.Metal2 vref 1.59233e-06f
Cred_9624 vout.$604.Metal2 vref.P0.GatPoly 6.20919e-08f
Cred_9625 vout.$604.Metal2 vref.P0.nSD 3.55952e-07f
Cred_9626 vout.$604.Metal2 vref.P0.pSD 1.04983e-06f
Cred_9627 vout.$604.Metal2 vss 0.000494568f
Cred_9628 vout.$604.Metal2 vss.$1211.Metal5 0.000180975f
Cred_9629 vout.$604.Metal2 vss.$1229.Metal5 0.000180975f
Cred_9630 vout.$604.Metal2 vss.$1281.Metal5 0.000692737f
Cred_9631 vout.$604.Metal2 vss.$1299.Metal5 0.000692737f
Cred_9632 vout.$606.Metal2 vref 2.01365e-06f
Cred_9633 vout.$606.Metal2 vref.P0.GatPoly 7.85209e-08f
Cred_9634 vout.$606.Metal2 vref.P0.nSD 4.50135e-07f
Cred_9635 vout.$606.Metal2 vref.P0.pSD 1.32761e-06f
Cred_9636 vout.$606.Metal2 vss 0.000412189f
Cred_9637 vout.$606.Metal2 vss.$1211.Metal5 0.000150916f
Cred_9638 vout.$606.Metal2 vss.$1229.Metal5 0.000150916f
Cred_9639 vout.$606.Metal2 vss.$1281.Metal5 0.000577675f
Cred_9640 vout.$606.Metal2 vss.$1299.Metal5 0.000577675f
Cred_9641 vout.$608.Metal2 vref 2.73813e-06f
Cred_9642 vout.$608.Metal2 vref.P0.GatPoly 1.06772e-07f
Cred_9643 vout.$608.Metal2 vref.P0.nSD 6.12088e-07f
Cred_9644 vout.$608.Metal2 vref.P0.pSD 1.80526e-06f
Cred_9645 vout.$608.Metal2 vss 0.000413115f
Cred_9646 vout.$608.Metal2 vss.$1211.Metal5 0.000150744f
Cred_9647 vout.$608.Metal2 vss.$1229.Metal5 0.000150744f
Cred_9648 vout.$608.Metal2 vss.$1281.Metal5 0.000577015f
Cred_9649 vout.$608.Metal2 vss.$1299.Metal5 0.000577015f
Cred_9650 vout.$61.Metal1 vss.$10.Metal1 9.40339e-05f
Cred_9651 vout.$61.Metal1 vss.$463.Metal2 0.0427348f
Cred_9652 vout.$61.Metal1 vss.$467.Metal2 0.0177281f
Cred_9653 vout.$61.Metal1 vss.$469.Metal2 0.040231f
Cred_9654 vout.$61.Metal1 vss.$799.Metal3 9.40339e-05f
Cred_9655 vout.$61.Metal1 vss.P1.nSD 0.0446304f
Cred_9656 vout.$61.Metal1 vss.P3.nSD 0.0437677f
Cred_9657 vout.$610.Metal2 vref 4.27692e-06f
Cred_9658 vout.$610.Metal2 vref.P0.GatPoly 1.66776e-07f
Cred_9659 vout.$610.Metal2 vref.P0.nSD 9.56071e-07f
Cred_9660 vout.$610.Metal2 vref.P0.pSD 2.81979e-06f
Cred_9661 vout.$610.Metal2 vss 0.000413186f
Cred_9662 vout.$610.Metal2 vss.$1211.Metal5 0.00015077f
Cred_9663 vout.$610.Metal2 vss.$1229.Metal5 0.00015077f
Cred_9664 vout.$610.Metal2 vss.$1281.Metal5 0.000577115f
Cred_9665 vout.$610.Metal2 vss.$1299.Metal5 0.000577115f
Cred_9666 vout.$612.Metal2 vref 0.00045765f
Cred_9667 vout.$612.Metal2 vref.P0.GatPoly 1.78458e-05f
Cred_9668 vout.$612.Metal2 vref.P0.nSD 0.000102304f
Cred_9669 vout.$612.Metal2 vref.P0.pSD 0.000574258f
Cred_9670 vout.$612.Metal2 vss 0.000405427f
Cred_9671 vout.$612.Metal2 vss.$1211.Metal5 0.000147938f
Cred_9672 vout.$612.Metal2 vss.$1229.Metal5 0.000147938f
Cred_9673 vout.$612.Metal2 vss.$1281.Metal5 0.000566278f
Cred_9674 vout.$612.Metal2 vss.$1299.Metal5 0.000566278f
Cred_9675 vout.$614.Metal2 vref 7.99826e-05f
Cred_9676 vout.$614.Metal2 vref.P0.GatPoly 3.11887e-06f
Cred_9677 vout.$614.Metal2 vref.P0.nSD 1.78795e-05f
Cred_9678 vout.$614.Metal2 vref.P0.pSD 0.000102503f
Cred_9679 vout.$614.Metal2 vss 4.74821e-06f
Cred_9680 vout.$614.Metal2 vss.$1211.Metal5 1.7326e-06f
Cred_9681 vout.$614.Metal2 vss.$1229.Metal5 1.7326e-06f
Cred_9682 vout.$614.Metal2 vss.$1281.Metal5 6.63203e-06f
Cred_9683 vout.$614.Metal2 vss.$1299.Metal5 6.63203e-06f
Cred_9684 vout.$62.Metal1 vss.$467.Metal2 0.00979697f
Cred_9685 vout.$62.Metal1 vss.$469.Metal2 0.0404125f
Cred_9686 vout.$62.Metal1 vss.$473.Metal2 0.0355028f
Cred_9687 vout.$62.Metal1 vss.$475.Metal2 0.0146908f
Cred_9688 vout.$62.Metal1 vss.P3.nSD 0.0437408f
Cred_9689 vout.$62.Metal1 vss.P5.nSD 0.0437614f
Cred_9690 vout.$622.Metal2 vss 2.23948e-05f
Cred_9691 vout.$622.Metal2 vss.$1211.Metal5 8.17173e-06f
Cred_9692 vout.$622.Metal2 vss.$1229.Metal5 8.17173e-06f
Cred_9693 vout.$622.Metal2 vss.$1281.Metal5 3.12797e-05f
Cred_9694 vout.$622.Metal2 vss.$1299.Metal5 3.12797e-05f
Cred_9695 vout.$63.Metal1 vss.$136.Metal1 6.42054e-05f
Cred_9696 vout.$63.Metal1 vss.$473.Metal2 0.0355001f
Cred_9697 vout.$63.Metal1 vss.$475.Metal2 0.020135f
Cred_9698 vout.$63.Metal1 vss.$479.Metal2 0.0446245f
Cred_9699 vout.$63.Metal1 vss.$811.Metal3 6.42054e-05f
Cred_9700 vout.$63.Metal1 vss.P5.nSD 0.0437605f
Cred_9701 vout.$63.Metal1 vss.P7.nSD 0.0437567f
Cred_9702 vout.$64.Metal1 vss.$136.Metal1 6.34343e-05f
Cred_9703 vout.$64.Metal1 vss.$140.Metal1 7.93868e-05f
Cred_9704 vout.$64.Metal1 vss.$475.Metal2 0.00537996f
Cred_9705 vout.$64.Metal1 vss.$479.Metal2 0.0440886f
Cred_9706 vout.$64.Metal1 vss.$483.Metal2 0.0438909f
Cred_9707 vout.$64.Metal1 vss.$487.Metal2 0.00673291f
Cred_9708 vout.$64.Metal1 vss.$811.Metal3 6.34343e-05f
Cred_9709 vout.$64.Metal1 vss.$819.Metal3 7.93868e-05f
Cred_9710 vout.$64.Metal1 vss.P10.nSD 0.0442887f
Cred_9711 vout.$64.Metal1 vss.P7.nSD 0.0432385f
Cred_9712 vout.$644.Metal2 vref 3.75834e-07f
Cred_9713 vout.$644.Metal2 vref.P0.GatPoly 1.46554e-08f
Cred_9714 vout.$644.Metal2 vref.P0.nSD 8.40146e-08f
Cred_9715 vout.$644.Metal2 vref.P0.pSD 2.68851e-07f
Cred_9716 vout.$644.Metal2 vss 0.000370721f
Cred_9717 vout.$644.Metal2 vss.$1211.Metal5 0.000135274f
Cred_9718 vout.$644.Metal2 vss.$1229.Metal5 0.000135274f
Cred_9719 vout.$644.Metal2 vss.$1281.Metal5 0.000517802f
Cred_9720 vout.$644.Metal2 vss.$1299.Metal5 0.000517802f
Cred_9721 vout.$646.Metal2 vref 4.68235e-07f
Cred_9722 vout.$646.Metal2 vref.P0.GatPoly 1.82585e-08f
Cred_9723 vout.$646.Metal2 vref.P0.nSD 1.0467e-07f
Cred_9724 vout.$646.Metal2 vref.P0.pSD 3.34942e-07f
Cred_9725 vout.$646.Metal2 vss 0.000354127f
Cred_9726 vout.$646.Metal2 vss.$1211.Metal5 0.000129219f
Cred_9727 vout.$646.Metal2 vss.$1229.Metal5 0.000129219f
Cred_9728 vout.$646.Metal2 vss.$1281.Metal5 0.000494624f
Cred_9729 vout.$646.Metal2 vss.$1299.Metal5 0.000494624f
Cred_9730 vout.$648.Metal2 vref 6.2534e-07f
Cred_9731 vout.$648.Metal2 vref.P0.GatPoly 2.43848e-08f
Cred_9732 vout.$648.Metal2 vref.P0.nSD 1.3979e-07f
Cred_9733 vout.$648.Metal2 vref.P0.pSD 4.47324e-07f
Cred_9734 vout.$648.Metal2 vss 0.000354127f
Cred_9735 vout.$648.Metal2 vss.$1211.Metal5 0.000129219f
Cred_9736 vout.$648.Metal2 vss.$1229.Metal5 0.000129219f
Cred_9737 vout.$648.Metal2 vss.$1281.Metal5 0.000494624f
Cred_9738 vout.$648.Metal2 vss.$1299.Metal5 0.000494624f
Cred_9739 vout.$65.Metal1 vss.$140.Metal1 7.8445e-05f
Cred_9740 vout.$65.Metal1 vss.$483.Metal2 0.0433702f
Cred_9741 vout.$65.Metal1 vss.$487.Metal2 0.018635f
Cred_9742 vout.$65.Metal1 vss.$489.Metal2 0.0371439f
Cred_9743 vout.$65.Metal1 vss.$493.Metal2 3.50055e-05f
Cred_9744 vout.$65.Metal1 vss.$495.Metal2 1.12921e-05f
Cred_9745 vout.$65.Metal1 vss.$819.Metal3 7.8445e-05f
Cred_9746 vout.$65.Metal1 vss.P10.nSD 0.0437704f
Cred_9747 vout.$65.Metal1 vss.P11.nSD 0.0428308f
Cred_9748 vout.$65.Metal1 vss.P13.nSD 1.01635e-05f
Cred_9749 vout.$650.Metal2 vref 9.41105e-07f
Cred_9750 vout.$650.Metal2 vref.P0.GatPoly 3.66978e-08f
Cred_9751 vout.$650.Metal2 vref.P0.nSD 2.10376e-07f
Cred_9752 vout.$650.Metal2 vref.P0.pSD 6.732e-07f
Cred_9753 vout.$650.Metal2 vss 0.000354127f
Cred_9754 vout.$650.Metal2 vss.$1211.Metal5 0.000129219f
Cred_9755 vout.$650.Metal2 vss.$1229.Metal5 0.000129219f
Cred_9756 vout.$650.Metal2 vss.$1281.Metal5 0.000494624f
Cred_9757 vout.$650.Metal2 vss.$1299.Metal5 0.000494624f
Cred_9758 vout.$652.Metal2 vref 8.55438e-05f
Cred_9759 vout.$652.Metal2 vref.P0.GatPoly 3.33573e-06f
Cred_9760 vout.$652.Metal2 vref.P0.nSD 1.91226e-05f
Cred_9761 vout.$652.Metal2 vref.P0.pSD 0.000112888f
Cred_9762 vout.$652.Metal2 vss 0.000353451f
Cred_9763 vout.$652.Metal2 vss.$1211.Metal5 0.000128973f
Cred_9764 vout.$652.Metal2 vss.$1229.Metal5 0.000128973f
Cred_9765 vout.$652.Metal2 vss.$1281.Metal5 0.00049368f
Cred_9766 vout.$652.Metal2 vss.$1299.Metal5 0.00049368f
Cred_9767 vout.$654.Metal2 vref 7.21313e-05f
Cred_9768 vout.$654.Metal2 vref.P0.GatPoly 2.81272e-06f
Cred_9769 vout.$654.Metal2 vref.P0.nSD 1.61244e-05f
Cred_9770 vout.$654.Metal2 vref.P0.pSD 9.74011e-05f
Cred_9771 vout.$654.Metal2 vss 5.58832e-06f
Cred_9772 vout.$654.Metal2 vss.$1211.Metal5 2.03915e-06f
Cred_9773 vout.$654.Metal2 vss.$1229.Metal5 2.03915e-06f
Cred_9774 vout.$654.Metal2 vss.$1281.Metal5 7.80544e-06f
Cred_9775 vout.$654.Metal2 vss.$1299.Metal5 7.80544e-06f
Cred_9776 vout.$66.Metal1 vss.$146.Metal1 7.84509e-05f
Cred_9777 vout.$66.Metal1 vss.$487.Metal2 1.12921e-05f
Cred_9778 vout.$66.Metal1 vss.$489.Metal2 3.50055e-05f
Cred_9779 vout.$66.Metal1 vss.$493.Metal2 0.0387808f
Cred_9780 vout.$66.Metal1 vss.$495.Metal2 0.0191635f
Cred_9781 vout.$66.Metal1 vss.$499.Metal2 0.0433735f
Cred_9782 vout.$66.Metal1 vss.$831.Metal3 7.84509e-05f
Cred_9783 vout.$66.Metal1 vss.P11.nSD 1.01635e-05f
Cred_9784 vout.$66.Metal1 vss.P13.nSD 0.0446767f
Cred_9785 vout.$66.Metal1 vss.P15.nSD 0.0437712f
Cred_9786 vout.$666.Metal2 vss 0.000227897f
Cred_9787 vout.$666.Metal2 vss.$1211.Metal5 8.31584e-05f
Cred_9788 vout.$666.Metal2 vss.$1229.Metal5 8.31584e-05f
Cred_9789 vout.$666.Metal2 vss.$1281.Metal5 0.000318313f
Cred_9790 vout.$666.Metal2 vss.$1299.Metal5 0.000318313f
Cred_9791 vout.$668.Metal2 vss 0.000227897f
Cred_9792 vout.$668.Metal2 vss.$1211.Metal5 8.31584e-05f
Cred_9793 vout.$668.Metal2 vss.$1229.Metal5 8.31584e-05f
Cred_9794 vout.$668.Metal2 vss.$1281.Metal5 0.000318313f
Cred_9795 vout.$668.Metal2 vss.$1299.Metal5 0.000318313f
Cred_9796 vout.$67.Metal1 vss.$146.Metal1 7.8445e-05f
Cred_9797 vout.$67.Metal1 vss.$150.Metal1 6.42746e-05f
Cred_9798 vout.$67.Metal1 vss.$495.Metal2 0.00665304f
Cred_9799 vout.$67.Metal1 vss.$499.Metal2 0.0433702f
Cred_9800 vout.$67.Metal1 vss.$503.Metal2 0.0446725f
Cred_9801 vout.$67.Metal1 vss.$507.Metal2 0.00545122f
Cred_9802 vout.$67.Metal1 vss.$831.Metal3 7.8445e-05f
Cred_9803 vout.$67.Metal1 vss.$839.Metal3 6.42746e-05f
Cred_9804 vout.$67.Metal1 vss.P15.nSD 0.0437704f
Cred_9805 vout.$67.Metal1 vss.P17.nSD 0.0438022f
Cred_9806 vout.$670.Metal2 vss 0.000227897f
Cred_9807 vout.$670.Metal2 vss.$1211.Metal5 8.31584e-05f
Cred_9808 vout.$670.Metal2 vss.$1229.Metal5 8.31584e-05f
Cred_9809 vout.$670.Metal2 vss.$1281.Metal5 0.000318313f
Cred_9810 vout.$670.Metal2 vss.$1299.Metal5 0.000318313f
Cred_9811 vout.$672.Metal2 vss 0.000227897f
Cred_9812 vout.$672.Metal2 vss.$1211.Metal5 8.31584e-05f
Cred_9813 vout.$672.Metal2 vss.$1229.Metal5 8.31584e-05f
Cred_9814 vout.$672.Metal2 vss.$1281.Metal5 0.000318313f
Cred_9815 vout.$672.Metal2 vss.$1299.Metal5 0.000318313f
Cred_9816 vout.$68.Metal1 vss.$150.Metal1 6.42008e-05f
Cred_9817 vout.$68.Metal1 vss.$503.Metal2 0.0446213f
Cred_9818 vout.$68.Metal1 vss.$507.Metal2 0.0201382f
Cred_9819 vout.$68.Metal1 vss.$509.Metal2 0.0355087f
Cred_9820 vout.$68.Metal1 vss.$839.Metal3 6.42008e-05f
Cred_9821 vout.$68.Metal1 vss.P17.nSD 0.0437559f
Cred_9822 vout.$68.Metal1 vss.P19.nSD 0.0437683f
Cred_9823 vout.$682.Metal2 vss 2.1986e-05f
Cred_9824 vout.$682.Metal2 vss.$1211.Metal5 8.02256e-06f
Cred_9825 vout.$682.Metal2 vss.$1229.Metal5 8.02256e-06f
Cred_9826 vout.$682.Metal2 vss.$1281.Metal5 3.07087e-05f
Cred_9827 vout.$682.Metal2 vss.$1299.Metal5 3.07087e-05f
Cred_9828 vout.$684.Metal2 vss 2.50157e-05f
Cred_9829 vout.$684.Metal2 vss.$1211.Metal5 9.1281e-06f
Cred_9830 vout.$684.Metal2 vss.$1229.Metal5 9.1281e-06f
Cred_9831 vout.$684.Metal2 vss.$1281.Metal5 3.49405e-05f
Cred_9832 vout.$684.Metal2 vss.$1299.Metal5 3.49405e-05f
Cred_9833 vout.$686.Metal2 vss 6.05955e-06f
Cred_9834 vout.$686.Metal2 vss.$1211.Metal5 2.2111e-06f
Cred_9835 vout.$686.Metal2 vss.$1229.Metal5 2.2111e-06f
Cred_9836 vout.$686.Metal2 vss.$1281.Metal5 8.46363e-06f
Cred_9837 vout.$686.Metal2 vss.$1299.Metal5 8.46363e-06f
Cred_9838 vout.$688.Metal2 vss 6.05955e-06f
Cred_9839 vout.$688.Metal2 vss.$1211.Metal5 2.2111e-06f
Cred_9840 vout.$688.Metal2 vss.$1229.Metal5 2.2111e-06f
Cred_9841 vout.$688.Metal2 vss.$1281.Metal5 8.46363e-06f
Cred_9842 vout.$688.Metal2 vss.$1299.Metal5 8.46363e-06f
Cred_9843 vout.$69.Metal1 vss.$507.Metal2 0.0146897f
Cred_9844 vout.$69.Metal1 vss.$509.Metal2 0.0355002f
Cred_9845 vout.$69.Metal1 vss.$513.Metal2 0.0401444f
Cred_9846 vout.$69.Metal1 vss.$515.Metal2 0.00973196f
Cred_9847 vout.$69.Metal1 vss.P19.nSD 0.0437606f
Cred_9848 vout.$69.Metal1 vss.P21.nSD 0.0434515f
Cred_9849 vout.$690.Metal2 vss 6.05955e-06f
Cred_9850 vout.$690.Metal2 vss.$1211.Metal5 2.2111e-06f
Cred_9851 vout.$690.Metal2 vss.$1229.Metal5 2.2111e-06f
Cred_9852 vout.$690.Metal2 vss.$1281.Metal5 8.46363e-06f
Cred_9853 vout.$690.Metal2 vss.$1299.Metal5 8.46363e-06f
Cred_9854 vout.$694.Metal2 vss 4.19399e-06f
Cred_9855 vout.$694.Metal2 vss.$1211.Metal5 1.53036e-06f
Cred_9856 vout.$694.Metal2 vss.$1229.Metal5 1.53036e-06f
Cred_9857 vout.$694.Metal2 vss.$1281.Metal5 5.85792e-06f
Cred_9858 vout.$694.Metal2 vss.$1299.Metal5 5.85792e-06f
Cred_9859 vout.$70.Metal1 vss.$156.Metal1 9.06875e-05f
Cred_9860 vout.$70.Metal1 vss.$513.Metal2 0.0406841f
Cred_9861 vout.$70.Metal1 vss.$515.Metal2 0.0175541f
Cred_9862 vout.$70.Metal1 vss.$519.Metal2 0.0412193f
Cred_9863 vout.$70.Metal1 vss.$521.Metal2 6.75445e-05f
Cred_9864 vout.$70.Metal1 vss.$851.Metal3 9.06875e-05f
Cred_9865 vout.$70.Metal1 vss.P21.nSD 0.0440311f
Cred_9866 vout.$70.Metal1 vss.P23.nSD 0.0428606f
Cred_9867 vout.$70.Metal1 vss.P25.nSD 1.5917e-05f
Cred_9868 vout.$722.Metal2 vss 2.1986e-05f
Cred_9869 vout.$722.Metal2 vss.$1211.Metal5 8.02256e-06f
Cred_9870 vout.$722.Metal2 vss.$1229.Metal5 8.02256e-06f
Cred_9871 vout.$722.Metal2 vss.$1281.Metal5 3.07087e-05f
Cred_9872 vout.$722.Metal2 vss.$1299.Metal5 3.07087e-05f
Cred_9873 vout.$724.Metal2 vss 2.68456e-05f
Cred_9874 vout.$724.Metal2 vss.$1211.Metal5 8.70905e-06f
Cred_9875 vout.$724.Metal2 vss.$1229.Metal5 8.70905e-06f
Cred_9876 vout.$724.Metal2 vss.$1281.Metal5 3.33364e-05f
Cred_9877 vout.$724.Metal2 vss.$1299.Metal5 3.33364e-05f
Cred_9878 vout.$762.Metal2 vss 2.1986e-05f
Cred_9879 vout.$762.Metal2 vss.$1211.Metal5 8.02256e-06f
Cred_9880 vout.$762.Metal2 vss.$1229.Metal5 8.02256e-06f
Cred_9881 vout.$762.Metal2 vss.$1281.Metal5 3.07087e-05f
Cred_9882 vout.$762.Metal2 vss.$1299.Metal5 3.07087e-05f
Cred_9883 vout.$764.Metal2 vss 0.000291583f
Cred_9884 vout.$764.Metal2 vss.$1211.Metal5 1.92634e-05f
Cred_9885 vout.$764.Metal2 vss.$1229.Metal5 1.92634e-05f
Cred_9886 vout.$764.Metal2 vss.$1281.Metal5 7.37364e-05f
Cred_9887 vout.$764.Metal2 vss.$1299.Metal5 7.37364e-05f
Cred_9888 vout.$784.Metal2 vss 0.0010124f
Cred_9889 vout.$784.Metal2 vss.$1211.Metal5 6.68845e-05f
Cred_9890 vout.$784.Metal2 vss.$1229.Metal5 6.68845e-05f
Cred_9891 vout.$784.Metal2 vss.$1281.Metal5 0.00025602f
Cred_9892 vout.$784.Metal2 vss.$1299.Metal5 0.00025602f
Cred_9893 vout.$800.Metal2 vss 2.4216e-06f
Cred_9894 vout.$800.Metal2 vss.$1211.Metal5 8.83629e-07f
Cred_9895 vout.$800.Metal2 vss.$1229.Metal5 8.83629e-07f
Cred_9896 vout.$800.Metal2 vss.$1281.Metal5 3.38235e-06f
Cred_9897 vout.$800.Metal2 vss.$1299.Metal5 3.38235e-06f
Cred_9898 vout.$802.Metal2 vss 0.000190478f
Cred_9899 vout.$802.Metal2 vss.$1211.Metal5 6.95045e-05f
Cred_9900 vout.$802.Metal2 vss.$1229.Metal5 6.95045e-05f
Cred_9901 vout.$802.Metal2 vss.$1281.Metal5 0.000266049f
Cred_9902 vout.$802.Metal2 vss.$1299.Metal5 0.000266049f
Cred_9903 vout.$858.Metal3 vss.$1299.Metal5 0.0010792f
Cred_9904 vout.$858.Metal3 vss.$150.Metal1 1.148e-05f
Cred_9905 vout.$858.Metal3 vss.$153.Metal1 7.79612e-08f
Cred_9906 vout.$858.Metal3 vss.$503.Metal2 0.00737339f
Cred_9907 vout.$858.Metal3 vss.$507.Metal2 0.00349001f
Cred_9908 vout.$858.Metal3 vss.$509.Metal2 0.00609955f
Cred_9909 vout.$858.Metal3 vss.$839.Metal3 0.00376594f
Cred_9910 vout.$858.Metal3 vss.$841.Metal3 0.0024775f
Cred_9911 vout.$858.Metal3 vss.P0.pSD 7.38901e-10f
Cred_9912 vout.$858.Metal3 vss.P17.nSD 0.00132087f
Cred_9913 vout.$858.Metal3 vss.P19.nSD 0.00137213f
Cred_9914 vout.$860.Metal3 vss.$1053.Metal4 0.000151671f
Cred_9915 vout.$860.Metal3 vss.$1055.Metal4 0.000191339f
Cred_9916 vout.$860.Metal3 vss.$1057.Metal4 0.000133004f
Cred_9917 vout.$860.Metal3 vss.$1299.Metal5 0.00186734f
Cred_9918 vout.$860.Metal3 vss.$153.Metal1 1.13167e-06f
Cred_9919 vout.$860.Metal3 vss.$507.Metal2 0.00243761f
Cred_9920 vout.$860.Metal3 vss.$509.Metal2 0.00593948f
Cred_9921 vout.$860.Metal3 vss.$513.Metal2 0.00704553f
Cred_9922 vout.$860.Metal3 vss.$515.Metal2 0.00169623f
Cred_9923 vout.$860.Metal3 vss.$845.Metal3 0.0062471f
Cred_9924 vout.$860.Metal3 vss.P19.nSD 0.00132901f
Cred_9925 vout.$860.Metal3 vss.P21.nSD 0.0013761f
Cred_9926 vout.$862.Metal3 vss 0.00163791f
Cred_9927 vout.$862.Metal3 vss.$1057.Metal4 2.53096e-05f
Cred_9928 vout.$862.Metal3 vss.$1059.Metal4 8.10069e-05f
Cred_9929 vout.$862.Metal3 vss.$1061.Metal4 1.24999e-05f
Cred_9930 vout.$862.Metal3 vss.$1211.Metal5 0.00168919f
Cred_9931 vout.$862.Metal3 vss.$1229.Metal5 0.00168919f
Cred_9932 vout.$862.Metal3 vss.$1281.Metal5 0.00646585f
Cred_9933 vout.$862.Metal3 vss.$1299.Metal5 0.0182476f
Cred_9934 vout.$862.Metal3 vss.$153.Metal1 1.46981e-07f
Cred_9935 vout.$862.Metal3 vss.$156.Metal1 1.54569e-05f
Cred_9936 vout.$862.Metal3 vss.$513.Metal2 0.00641919f
Cred_9937 vout.$862.Metal3 vss.$515.Metal2 0.00288534f
Cred_9938 vout.$862.Metal3 vss.$519.Metal2 0.00700232f
Cred_9939 vout.$862.Metal3 vss.$521.Metal2 0.00365634f
Cred_9940 vout.$862.Metal3 vss.$849.Metal3 0.00364364f
Cred_9941 vout.$862.Metal3 vss.$851.Metal3 0.00220113f
Cred_9942 vout.$862.Metal3 vss.P0.pSD 1.33742e-09f
Cred_9943 vout.$862.Metal3 vss.P21.nSD 0.0012596f
Cred_9944 vout.$862.Metal3 vss.P23.nSD 0.00126784f
Cred_9945 vout.$862.Metal3 vss.P25.nSD 0.000624596f
Cred_9946 vout.$864.Metal3 vss 0.000840252f
Cred_9947 vout.$864.Metal3 vss.$10.Metal1 4.03101e-05f
Cred_9948 vout.$864.Metal3 vss.$1009.Metal4 0.00017768f
Cred_9949 vout.$864.Metal3 vss.$1011.Metal4 0.00115147f
Cred_9950 vout.$864.Metal3 vss.$1013.Metal4 0.000360008f
Cred_9951 vout.$864.Metal3 vss.$1211.Metal5 0.000866558f
Cred_9952 vout.$864.Metal3 vss.$1229.Metal5 0.000866558f
Cred_9953 vout.$864.Metal3 vss.$1281.Metal5 0.0413271f
Cred_9954 vout.$864.Metal3 vss.$1299.Metal5 0.00331701f
Cred_9955 vout.$864.Metal3 vss.$13.Metal1 1.00386e-05f
Cred_9956 vout.$864.Metal3 vss.$461.Metal2 0.00495626f
Cred_9957 vout.$864.Metal3 vss.$463.Metal2 0.00934204f
Cred_9958 vout.$864.Metal3 vss.$467.Metal2 0.00389363f
Cred_9959 vout.$864.Metal3 vss.$469.Metal2 0.00865361f
Cred_9960 vout.$864.Metal3 vss.$799.Metal3 0.00205256f
Cred_9961 vout.$864.Metal3 vss.$801.Metal3 0.00350328f
Cred_9962 vout.$864.Metal3 vss.$805.Metal3 2.07895e-05f
Cred_9963 vout.$864.Metal3 vss.P0.nSD 0.000916384f
Cred_9964 vout.$864.Metal3 vss.P0.pSD 9.13432e-08f
Cred_9965 vout.$864.Metal3 vss.P1.nSD 0.00183031f
Cred_9966 vout.$864.Metal3 vss.P3.nSD 0.00182581f
Cred_9967 vout.$886.Metal3 vref 0.000295248f
Cred_9968 vout.$886.Metal3 vref.P0.GatPoly 1.1513e-05f
Cred_9969 vout.$886.Metal3 vref.P0.nSD 9.59394e-05f
Cred_9970 vout.$886.Metal3 vref.P0.pSD 0.000115681f
Cred_9971 vout.$886.Metal3 vss 0.00232401f
Cred_9972 vout.$886.Metal3 vss.$1211.Metal5 0.00239677f
Cred_9973 vout.$886.Metal3 vss.$1229.Metal5 0.00239677f
Cred_9974 vout.$886.Metal3 vss.$127.Metal1 2.12395e-08f
Cred_9975 vout.$886.Metal3 vss.$1281.Metal5 0.0100738f
Cred_9976 vout.$886.Metal3 vss.$1299.Metal5 0.00917433f
Cred_9977 vout.$886.Metal3 vss.$13.Metal1 9.43077e-07f
Cred_9978 vout.$886.Metal3 vss.$406.Metal1 1.72412e-08f
Cred_9979 vout.$886.Metal3 vss.$457.Metal2 3.10199e-10f
Cred_9980 vout.$886.Metal3 vss.$467.Metal2 0.00346654f
Cred_9981 vout.$886.Metal3 vss.$469.Metal2 0.01434f
Cred_9982 vout.$886.Metal3 vss.$473.Metal2 0.013036f
Cred_9983 vout.$886.Metal3 vss.$475.Metal2 0.00537747f
Cred_9984 vout.$886.Metal3 vss.$805.Metal3 0.00519522f
Cred_9985 vout.$886.Metal3 vss.P0.GatPoly 7.59331e-10f
Cred_9986 vout.$886.Metal3 vss.P0.pSD 3.94407e-07f
Cred_9987 vout.$886.Metal3 vss.P3.nSD 0.00366174f
Cred_9988 vout.$886.Metal3 vss.P5.nSD 0.00378784f
Cred_9989 vout.$888.Metal3 vref 0.000398768f
Cred_9990 vout.$888.Metal3 vref.P0.GatPoly 1.55497e-05f
Cred_9991 vout.$888.Metal3 vref.P0.nSD 0.000129563f
Cred_9992 vout.$888.Metal3 vref.P0.pSD 0.000156241f
Cred_9993 vout.$888.Metal3 vss 0.00203017f
Cred_9994 vout.$888.Metal3 vss.$1211.Metal5 0.00209373f
Cred_9995 vout.$888.Metal3 vss.$1229.Metal5 0.00209373f
Cred_9996 vout.$888.Metal3 vss.$127.Metal1 1.64602e-08f
Cred_9997 vout.$888.Metal3 vss.$1281.Metal5 0.012075f
Cred_9998 vout.$888.Metal3 vss.$1299.Metal5 0.00801436f
Cred_9999 vout.$888.Metal3 vss.$13.Metal1 9.36064e-08f
Cred_10000 vout.$888.Metal3 vss.$136.Metal1 2.43193e-05f
Cred_10001 vout.$888.Metal3 vss.$406.Metal1 2.22976e-08f
Cred_10002 vout.$888.Metal3 vss.$457.Metal2 2.40399e-10f
Cred_10003 vout.$888.Metal3 vss.$473.Metal2 0.0125604f
Cred_10004 vout.$888.Metal3 vss.$475.Metal2 0.00724876f
Cred_10005 vout.$888.Metal3 vss.$479.Metal2 0.0163577f
Cred_10006 vout.$888.Metal3 vss.$809.Metal3 0.00206496f
Cred_10007 vout.$888.Metal3 vss.$811.Metal3 0.00315356f
Cred_10008 vout.$888.Metal3 vss.P0.GatPoly 5.88468e-10f
Cred_10009 vout.$888.Metal3 vss.P0.pSD 3.95258e-07f
Cred_10010 vout.$888.Metal3 vss.P5.nSD 0.00366839f
Cred_10011 vout.$888.Metal3 vss.P7.nSD 0.00378617f
Cred_10012 vout.$890.Metal3 vref 0.00061437f
Cred_10013 vout.$890.Metal3 vref.P0.GatPoly 2.3957e-05f
Cred_10014 vout.$890.Metal3 vref.P0.nSD 0.000199567f
Cred_10015 vout.$890.Metal3 vref.P0.pSD 0.000240717f
Cred_10016 vout.$890.Metal3 vss 0.000848999f
Cred_10017 vout.$890.Metal3 vss.$1211.Metal5 0.000875579f
Cred_10018 vout.$890.Metal3 vss.$1229.Metal5 0.000875579f
Cred_10019 vout.$890.Metal3 vss.$127.Metal1 1.27726e-08f
Cred_10020 vout.$890.Metal3 vss.$1281.Metal5 0.0203915f
Cred_10021 vout.$890.Metal3 vss.$1299.Metal5 0.00335154f
Cred_10022 vout.$890.Metal3 vss.$136.Metal1 2.27166e-05f
Cred_10023 vout.$890.Metal3 vss.$138.Metal1 9.43077e-07f
Cred_10024 vout.$890.Metal3 vss.$140.Metal1 2.87172e-05f
Cred_10025 vout.$890.Metal3 vss.$406.Metal1 2.88328e-08f
Cred_10026 vout.$890.Metal3 vss.$457.Metal2 1.86543e-10f
Cred_10027 vout.$890.Metal3 vss.$475.Metal2 0.00192663f
Cred_10028 vout.$890.Metal3 vss.$479.Metal2 0.0158291f
Cred_10029 vout.$890.Metal3 vss.$483.Metal2 0.0159175f
Cred_10030 vout.$890.Metal3 vss.$487.Metal2 0.00243555f
Cred_10031 vout.$890.Metal3 vss.$811.Metal3 2.27166e-05f
Cred_10032 vout.$890.Metal3 vss.$815.Metal3 0.00519522f
Cred_10033 vout.$890.Metal3 vss.$819.Metal3 2.87172e-05f
Cred_10034 vout.$890.Metal3 vss.P0.GatPoly 4.56635e-10f
Cred_10035 vout.$890.Metal3 vss.P0.pSD 3.91709e-07f
Cred_10036 vout.$890.Metal3 vss.P10.nSD 0.00379157f
Cred_10037 vout.$890.Metal3 vss.P7.nSD 0.00366705f
Cred_10038 vout.$892.Metal3 vref 0.0240153f
Cred_10039 vout.$892.Metal3 vref.P0.GatPoly 0.00093646f
Cred_10040 vout.$892.Metal3 vref.P0.nSD 0.0203287f
Cred_10041 vout.$892.Metal3 vref.P0.pSD 0.00940942f
Cred_10042 vout.$892.Metal3 vss 6.68281e-05f
Cred_10043 vout.$892.Metal3 vss.$1033.Metal4 1.07536e-05f
Cred_10044 vout.$892.Metal3 vss.$1037.Metal4 1.07536e-05f
Cred_10045 vout.$892.Metal3 vss.$1211.Metal5 6.89204e-05f
Cred_10046 vout.$892.Metal3 vss.$1229.Metal5 6.89204e-05f
Cred_10047 vout.$892.Metal3 vss.$1246.Metal5 0.00282267f
Cred_10048 vout.$892.Metal3 vss.$127.Metal1 9.93221e-09f
Cred_10049 vout.$892.Metal3 vss.$1281.Metal5 0.0231802f
Cred_10050 vout.$892.Metal3 vss.$1299.Metal5 0.000263813f
Cred_10051 vout.$892.Metal3 vss.$140.Metal1 2.89016e-05f
Cred_10052 vout.$892.Metal3 vss.$143.Metal1 1.06272e-07f
Cred_10053 vout.$892.Metal3 vss.$406.Metal1 3.72803e-08f
Cred_10054 vout.$892.Metal3 vss.$457.Metal2 1.45059e-10f
Cred_10055 vout.$892.Metal3 vss.$483.Metal2 0.0155831f
Cred_10056 vout.$892.Metal3 vss.$487.Metal2 0.00712196f
Cred_10057 vout.$892.Metal3 vss.$489.Metal2 0.0144365f
Cred_10058 vout.$892.Metal3 vss.$493.Metal2 0.0012253f
Cred_10059 vout.$892.Metal3 vss.$495.Metal2 0.000395259f
Cred_10060 vout.$892.Metal3 vss.$819.Metal3 0.00233628f
Cred_10061 vout.$892.Metal3 vss.$821.Metal3 0.003034f
Cred_10062 vout.$892.Metal3 vss.$825.Metal3 1.26794e-07f
Cred_10063 vout.$892.Metal3 vss.P0.GatPoly 3.55086e-10f
Cred_10064 vout.$892.Metal3 vss.P0.pSD 3.87211e-07f
Cred_10065 vout.$892.Metal3 vss.P10.nSD 0.00372175f
Cred_10066 vout.$892.Metal3 vss.P11.nSD 0.00392818f
Cred_10067 vout.$892.Metal3 vss.P13.nSD 0.000292764f
Cred_10068 vout.$894.Metal3 vref 0.00358958f
Cred_10069 vout.$894.Metal3 vref.P0.GatPoly 0.000139973f
Cred_10070 vout.$894.Metal3 vref.P0.nSD 0.00336958f
Cred_10071 vout.$894.Metal3 vref.P0.pSD 0.00140643f
Cred_10072 vout.$894.Metal3 vss.$1033.Metal4 1.0514e-05f
Cred_10073 vout.$894.Metal3 vss.$1037.Metal4 1.0514e-05f
Cred_10074 vout.$894.Metal3 vss.$1246.Metal5 0.00275979f
Cred_10075 vout.$894.Metal3 vss.$1299.Metal5 0.00216436f
Cred_10076 vout.$894.Metal3 vss.$143.Metal1 1.06272e-07f
Cred_10077 vout.$894.Metal3 vss.$146.Metal1 2.27992e-05f
Cred_10078 vout.$894.Metal3 vss.$487.Metal2 0.000395259f
Cred_10079 vout.$894.Metal3 vss.$489.Metal2 0.0012253f
Cred_10080 vout.$894.Metal3 vss.$493.Metal2 0.0102489f
Cred_10081 vout.$894.Metal3 vss.$495.Metal2 0.00526104f
Cred_10082 vout.$894.Metal3 vss.$499.Metal2 0.0122578f
Cred_10083 vout.$894.Metal3 vss.$825.Metal3 1.23969e-07f
Cred_10084 vout.$894.Metal3 vss.$829.Metal3 0.003034f
Cred_10085 vout.$894.Metal3 vss.$831.Metal3 0.00233026f
Cred_10086 vout.$894.Metal3 vss.P0.pSD 9.6696e-10f
Cred_10087 vout.$894.Metal3 vss.P11.nSD 0.000292764f
Cred_10088 vout.$894.Metal3 vss.P13.nSD 0.00254953f
Cred_10089 vout.$894.Metal3 vss.P15.nSD 0.0026571f
Cred_10090 vout.$896.Metal3 vss.$1299.Metal5 0.000899503f
Cred_10091 vout.$896.Metal3 vss.$146.Metal1 2.07417e-05f
Cred_10092 vout.$896.Metal3 vss.$148.Metal1 9.43077e-07f
Cred_10093 vout.$896.Metal3 vss.$150.Metal1 1.73872e-05f
Cred_10094 vout.$896.Metal3 vss.$495.Metal2 0.00175914f
Cred_10095 vout.$896.Metal3 vss.$499.Metal2 0.0115081f
Cred_10096 vout.$896.Metal3 vss.$503.Metal2 0.0121251f
Cred_10097 vout.$896.Metal3 vss.$507.Metal2 0.00147464f
Cred_10098 vout.$896.Metal3 vss.$831.Metal3 2.07417e-05f
Cred_10099 vout.$896.Metal3 vss.$835.Metal3 0.00519522f
Cred_10100 vout.$896.Metal3 vss.$839.Metal3 1.73872e-05f
Cred_10101 vout.$896.Metal3 vss.P15.nSD 0.0025001f
Cred_10102 vout.$896.Metal3 vss.P17.nSD 0.00254032f
Cred_10103 vout.$898.Metal3 vss.$150.Metal1 8.16657e-06f
Cred_10104 vout.$898.Metal3 vss.$503.Metal2 0.00567599f
Cred_10105 vout.$898.Metal3 vss.$507.Metal2 0.0025673f
Cred_10106 vout.$898.Metal3 vss.$509.Metal2 0.00453048f
Cred_10107 vout.$898.Metal3 vss.$839.Metal3 8.16657e-06f
Cred_10108 vout.$898.Metal3 vss.P17.nSD 0.00139538f
Cred_10109 vout.$898.Metal3 vss.P19.nSD 0.00139794f
Cred_10110 vout.$900.Metal3 vss.$507.Metal2 0.00186859f
Cred_10111 vout.$900.Metal3 vss.$509.Metal2 0.00451576f
Cred_10112 vout.$900.Metal3 vss.$513.Metal2 0.0051574f
Cred_10113 vout.$900.Metal3 vss.$515.Metal2 0.00125028f
Cred_10114 vout.$900.Metal3 vss.P19.nSD 0.00139598f
Cred_10115 vout.$900.Metal3 vss.P21.nSD 0.00139542f
Cred_10116 vout.$902.Metal3 vss 0.00226886f
Cred_10117 vout.$902.Metal3 vss.$1211.Metal5 0.00233989f
Cred_10118 vout.$902.Metal3 vss.$1229.Metal5 0.00233989f
Cred_10119 vout.$902.Metal3 vss.$1281.Metal5 0.00895663f
Cred_10120 vout.$902.Metal3 vss.$1299.Metal5 0.00895663f
Cred_10121 vout.$902.Metal3 vss.$156.Metal1 1.04208e-05f
Cred_10122 vout.$902.Metal3 vss.$513.Metal2 0.004545f
Cred_10123 vout.$902.Metal3 vss.$515.Metal2 0.00198562f
Cred_10124 vout.$902.Metal3 vss.$519.Metal2 0.0049422f
Cred_10125 vout.$902.Metal3 vss.$521.Metal2 0.00261374f
Cred_10126 vout.$902.Metal3 vss.$851.Metal3 1.04208e-05f
Cred_10127 vout.$902.Metal3 vss.P21.nSD 0.0012286f
Cred_10128 vout.$902.Metal3 vss.P23.nSD 0.00123311f
Cred_10129 vout.$902.Metal3 vss.P25.nSD 0.000610945f
Cred_10130 vout.$904.Metal3 vref 0.000259793f
Cred_10131 vout.$904.Metal3 vref.P0.GatPoly 1.01305e-05f
Cred_10132 vout.$904.Metal3 vref.P0.nSD 8.44241e-05f
Cred_10133 vout.$904.Metal3 vref.P0.pSD 0.00010179f
Cred_10134 vout.$904.Metal3 vss 0.00487271f
Cred_10135 vout.$904.Metal3 vss.$10.Metal1 1.47692e-05f
Cred_10136 vout.$904.Metal3 vss.$1211.Metal5 0.00502526f
Cred_10137 vout.$904.Metal3 vss.$1229.Metal5 0.00502526f
Cred_10138 vout.$904.Metal3 vss.$127.Metal1 3.03967e-08f
Cred_10139 vout.$904.Metal3 vss.$1281.Metal5 0.0192357f
Cred_10140 vout.$904.Metal3 vss.$1299.Metal5 0.0192357f
Cred_10141 vout.$904.Metal3 vss.$406.Metal1 1.47713e-08f
Cred_10142 vout.$904.Metal3 vss.$457.Metal2 4.4394e-10f
Cred_10143 vout.$904.Metal3 vss.$461.Metal2 0.00364621f
Cred_10144 vout.$904.Metal3 vss.$463.Metal2 0.00699991f
Cred_10145 vout.$904.Metal3 vss.$467.Metal2 0.00281454f
Cred_10146 vout.$904.Metal3 vss.$469.Metal2 0.006443f
Cred_10147 vout.$904.Metal3 vss.$799.Metal3 1.47692e-05f
Cred_10148 vout.$904.Metal3 vss.P0.GatPoly 1.08671e-09f
Cred_10149 vout.$904.Metal3 vss.P0.nSD 0.000976741f
Cred_10150 vout.$904.Metal3 vss.P0.pSD 4.34239e-07f
Cred_10151 vout.$904.Metal3 vss.P1.nSD 0.00200661f
Cred_10152 vout.$904.Metal3 vss.P3.nSD 0.00200082f
Cred_10153 vout.$934.Metal3 vref 0.0194646f
Cred_10154 vout.$934.Metal3 vref.P0.GatPoly 0.000759009f
Cred_10155 vout.$934.Metal3 vref.P0.nSD 0.0177637f
Cred_10156 vout.$934.Metal3 vref.P0.pSD 0.00762642f
Cred_10157 vout.$934.Metal3 vss.$127.Metal1 7.21205e-09f
Cred_10158 vout.$934.Metal3 vss.$1299.Metal5 0.00554946f
Cred_10159 vout.$934.Metal3 vss.$146.Metal1 9.64452e-06f
Cred_10160 vout.$934.Metal3 vss.$406.Metal1 7.16362e-08f
Cred_10161 vout.$934.Metal3 vss.$457.Metal2 1.05331e-10f
Cred_10162 vout.$934.Metal3 vss.$493.Metal2 0.00531148f
Cred_10163 vout.$934.Metal3 vss.$495.Metal2 0.00253135f
Cred_10164 vout.$934.Metal3 vss.$499.Metal2 0.00533221f
Cred_10165 vout.$934.Metal3 vss.$831.Metal3 9.64452e-06f
Cred_10166 vout.$934.Metal3 vss.P0.GatPoly 2.57838e-10f
Cred_10167 vout.$934.Metal3 vss.P0.pSD 4.3637e-07f
Cred_10168 vout.$934.Metal3 vss.P13.nSD 0.00181457f
Cred_10169 vout.$934.Metal3 vss.P15.nSD 0.00160623f
Cred_10170 vout.$936.Metal3 vss.$127.Metal1 5.50856e-09f
Cred_10171 vout.$936.Metal3 vss.$146.Metal1 1.09583e-05f
Cred_10172 vout.$936.Metal3 vss.$150.Metal1 7.89325e-06f
Cred_10173 vout.$936.Metal3 vss.$406.Metal1 9.18629e-08f
Cred_10174 vout.$936.Metal3 vss.$457.Metal2 8.04518e-11f
Cred_10175 vout.$936.Metal3 vss.$495.Metal2 0.000929393f
Cred_10176 vout.$936.Metal3 vss.$499.Metal2 0.00605858f
Cred_10177 vout.$936.Metal3 vss.$503.Metal2 0.00548602f
Cred_10178 vout.$936.Metal3 vss.$507.Metal2 0.000669438f
Cred_10179 vout.$936.Metal3 vss.$831.Metal3 1.09583e-05f
Cred_10180 vout.$936.Metal3 vss.$839.Metal3 7.89325e-06f
Cred_10181 vout.$936.Metal3 vss.P0.GatPoly 1.96936e-10f
Cred_10182 vout.$936.Metal3 vss.P0.pSD 4.17933e-07f
Cred_10183 vout.$936.Metal3 vss.P15.nSD 0.00181388f
Cred_10184 vout.$936.Metal3 vss.P17.nSD 0.00160445f
Cred_10185 vout.$938.Metal3 vss.$127.Metal1 3.5954e-09f
Cred_10186 vout.$938.Metal3 vss.$150.Metal1 8.9685e-06f
Cred_10187 vout.$938.Metal3 vss.$406.Metal1 1.01887e-07f
Cred_10188 vout.$938.Metal3 vss.$457.Metal2 5.25103e-11f
Cred_10189 vout.$938.Metal3 vss.$503.Metal2 0.00623335f
Cred_10190 vout.$938.Metal3 vss.$507.Metal2 0.00256668f
Cred_10191 vout.$938.Metal3 vss.$509.Metal2 0.00436462f
Cred_10192 vout.$938.Metal3 vss.$839.Metal3 8.9685e-06f
Cred_10193 vout.$938.Metal3 vss.P0.GatPoly 1.28539e-10f
Cred_10194 vout.$938.Metal3 vss.P0.pSD 3.3883e-07f
Cred_10195 vout.$938.Metal3 vss.P17.nSD 0.00181185f
Cred_10196 vout.$938.Metal3 vss.P19.nSD 0.00160502f
Cred_10197 vout.$940.Metal3 vss.$127.Metal1 2.68021e-09f
Cred_10198 vout.$940.Metal3 vss.$406.Metal1 1.31335e-07f
Cred_10199 vout.$940.Metal3 vss.$457.Metal2 3.91441e-11f
Cred_10200 vout.$940.Metal3 vss.$507.Metal2 0.00205208f
Cred_10201 vout.$940.Metal3 vss.$509.Metal2 0.00495919f
Cred_10202 vout.$940.Metal3 vss.$513.Metal2 0.00496859f
Cred_10203 vout.$940.Metal3 vss.$515.Metal2 0.00120451f
Cred_10204 vout.$940.Metal3 vss.P0.GatPoly 9.58202e-11f
Cred_10205 vout.$940.Metal3 vss.P0.pSD 3.10344e-07f
Cred_10206 vout.$940.Metal3 vss.P19.nSD 0.00181251f
Cred_10207 vout.$940.Metal3 vss.P21.nSD 0.0016026f
Cred_10208 vout.$942.Metal3 vss 0.00265795f
Cred_10209 vout.$942.Metal3 vss.$1211.Metal5 0.00274116f
Cred_10210 vout.$942.Metal3 vss.$1229.Metal5 0.00274116f
Cred_10211 vout.$942.Metal3 vss.$127.Metal1 2.25349e-09f
Cred_10212 vout.$942.Metal3 vss.$1281.Metal5 0.0104926f
Cred_10213 vout.$942.Metal3 vss.$1299.Metal5 0.0104926f
Cred_10214 vout.$942.Metal3 vss.$156.Metal1 1.05547e-05f
Cred_10215 vout.$942.Metal3 vss.$406.Metal1 1.96601e-07f
Cred_10216 vout.$942.Metal3 vss.$457.Metal2 3.29119e-11f
Cred_10217 vout.$942.Metal3 vss.$513.Metal2 0.00460978f
Cred_10218 vout.$942.Metal3 vss.$515.Metal2 0.00201269f
Cred_10219 vout.$942.Metal3 vss.$519.Metal2 0.00500199f
Cred_10220 vout.$942.Metal3 vss.$521.Metal2 0.00260015f
Cred_10221 vout.$942.Metal3 vss.$851.Metal3 1.05547e-05f
Cred_10222 vout.$942.Metal3 vss.P0.GatPoly 8.05644e-11f
Cred_10223 vout.$942.Metal3 vss.P0.pSD 3.16614e-07f
Cred_10224 vout.$942.Metal3 vss.P21.nSD 0.00148365f
Cred_10225 vout.$942.Metal3 vss.P23.nSD 0.00148607f
Cred_10226 vout.$942.Metal3 vss.P25.nSD 0.000722647f
Cred_10227 vout.P0.GatPoly vref 0.00898592f
Cred_10228 vout.P0.GatPoly vref.P0.GatPoly 0.000341337f
Cred_10229 vout.P0.GatPoly vref.P0.nSD 0.00021315f
Cred_10230 vout.P0.GatPoly vref.P0.pSD 0.000374804f
Cred_10231 vout.P0.GatPoly vss 0.00156402f
Cred_10232 vout.P0.GatPoly vss.$1211.Metal5 0.000576237f
Cred_10233 vout.P0.GatPoly vss.$1229.Metal5 0.000576237f
Cred_10234 vout.P0.GatPoly vss.$127.Metal1 1.09743e-08f
Cred_10235 vout.P0.GatPoly vss.$1281.Metal5 0.00220572f
Cred_10236 vout.P0.GatPoly vss.$1299.Metal5 0.00220572f
Cred_10237 vout.P0.GatPoly vss.$406.Metal1 4.15875e-07f
Cred_10238 vout.P0.GatPoly vss.$457.Metal2 1.60279e-10f
Cred_10239 vout.P0.GatPoly vss.P0.GatPoly 3.92343e-10f
Cred_10240 vout.P0.GatPoly vss.P0.pSD 1.09905e-06f
Cred_10241 vout.P0.nSD vss 0.000302902f
Cred_10242 vout.P0.nSD vss.$10.Metal1 8.62066e-06f
Cred_10243 vout.P0.nSD vss.$1211.Metal5 0.000312385f
Cred_10244 vout.P0.nSD vss.$1229.Metal5 0.000312385f
Cred_10245 vout.P0.nSD vss.$1281.Metal5 0.00119574f
Cred_10246 vout.P0.nSD vss.$1299.Metal5 0.00119574f
Cred_10247 vout.P0.nSD vss.$463.Metal2 0.00164713f
Cred_10248 vout.P0.nSD vss.$467.Metal2 0.00204334f
Cred_10249 vout.P0.nSD vss.$469.Metal2 0.00106422f
Cred_10250 vout.P0.nSD vss.$799.Metal3 0.00100908f
Cred_10251 vout.P0.nSD vss.$801.Metal3 0.00100046f
Cred_10252 vout.P0.nSD vss.P1.nSD 0.00115111f
Cred_10253 vout.P0.nSD vss.P3.nSD 0.00113026f
Cred_10254 vout.P0.pSD vss 0.00184132f
Cred_10255 vout.P0.pSD vss.$1211.Metal5 0.000321701f
Cred_10256 vout.P0.pSD vss.$1229.Metal5 0.000321701f
Cred_10257 vout.P0.pSD vss.$1281.Metal5 0.0012314f
Cred_10258 vout.P0.pSD vss.$1299.Metal5 0.0012314f
Cred_10259 vout.P10.nSD vss.$146.Metal1 8.20208e-06f
Cred_10260 vout.P10.nSD vss.$493.Metal2 0.00101577f
Cred_10261 vout.P10.nSD vss.$495.Metal2 0.0010233f
Cred_10262 vout.P10.nSD vss.$499.Metal2 0.00165957f
Cred_10263 vout.P10.nSD vss.$831.Metal3 0.00100866f
Cred_10264 vout.P10.nSD vss.P13.nSD 0.00114895f
Cred_10265 vout.P10.nSD vss.P15.nSD 0.00112965f
Cred_10266 vout.P10.pSD vss 0.00036411f
Cred_10267 vout.P10.pSD vss.$1211.Metal5 0.000132862f
Cred_10268 vout.P10.pSD vss.$1229.Metal5 0.000132862f
Cred_10269 vout.P10.pSD vss.$1281.Metal5 0.000508568f
Cred_10270 vout.P10.pSD vss.$1299.Metal5 0.000508568f
Cred_10271 vout.P12.nSD vss.$146.Metal1 2.06115e-06f
Cred_10272 vout.P12.nSD vss.$148.Metal1 0.00152767f
Cred_10273 vout.P12.nSD vss.$150.Metal1 1.68888e-06f
Cred_10274 vout.P12.nSD vss.$495.Metal2 0.000174809f
Cred_10275 vout.P12.nSD vss.$499.Metal2 0.0021815f
Cred_10276 vout.P12.nSD vss.$503.Metal2 0.00221576f
Cred_10277 vout.P12.nSD vss.$507.Metal2 0.000143237f
Cred_10278 vout.P12.nSD vss.$831.Metal3 2.06115e-06f
Cred_10279 vout.P12.nSD vss.$835.Metal3 0.00201321f
Cred_10280 vout.P12.nSD vss.$839.Metal3 1.68888e-06f
Cred_10281 vout.P12.nSD vss.P15.nSD 0.00112855f
Cred_10282 vout.P12.nSD vss.P17.nSD 0.00112949f
Cred_10283 vout.P14.nSD vss.$150.Metal1 7.82838e-06f
Cred_10284 vout.P14.nSD vss.$503.Metal2 0.0016926f
Cred_10285 vout.P14.nSD vss.$507.Metal2 0.00210421f
Cred_10286 vout.P14.nSD vss.$509.Metal2 0.000932968f
Cred_10287 vout.P14.nSD vss.$839.Metal3 0.00100829f
Cred_10288 vout.P14.nSD vss.$841.Metal3 0.00100046f
Cred_10289 vout.P14.nSD vss.P17.nSD 0.00112907f
Cred_10290 vout.P14.nSD vss.P19.nSD 0.00112853f
Cred_10291 vout.P16.nSD vss.$153.Metal1 0.0014802f
Cred_10292 vout.P16.nSD vss.$507.Metal2 0.000385974f
Cred_10293 vout.P16.nSD vss.$509.Metal2 0.00196555f
Cred_10294 vout.P16.nSD vss.$513.Metal2 0.00208973f
Cred_10295 vout.P16.nSD vss.$515.Metal2 0.000256232f
Cred_10296 vout.P16.nSD vss.$845.Metal3 0.00195057f
Cred_10297 vout.P16.nSD vss.P19.nSD 0.00112829f
Cred_10298 vout.P16.nSD vss.P21.nSD 0.00112255f
Cred_10299 vout.P18.nSD vss 0.000227601f
Cred_10300 vout.P18.nSD vss.$1211.Metal5 0.000234727f
Cred_10301 vout.P18.nSD vss.$1229.Metal5 0.000234727f
Cred_10302 vout.P18.nSD vss.$1281.Metal5 0.000898487f
Cred_10303 vout.P18.nSD vss.$1299.Metal5 0.000898487f
Cred_10304 vout.P18.nSD vss.$156.Metal1 8.53033e-06f
Cred_10305 vout.P18.nSD vss.$513.Metal2 0.00106674f
Cred_10306 vout.P18.nSD vss.$515.Metal2 0.00203629f
Cred_10307 vout.P18.nSD vss.$519.Metal2 0.00160608f
Cred_10308 vout.P18.nSD vss.$849.Metal3 0.00100046f
Cred_10309 vout.P18.nSD vss.$851.Metal3 0.00100899f
Cred_10310 vout.P18.nSD vss.P21.nSD 0.00113301f
Cred_10311 vout.P18.nSD vss.P23.nSD 0.0011093f
Cred_10312 vout.P18.pSD vss 0.000729681f
Cred_10313 vout.P18.pSD vss.$1211.Metal5 0.000266257f
Cred_10314 vout.P18.pSD vss.$1229.Metal5 0.000266257f
Cred_10315 vout.P18.pSD vss.$1281.Metal5 0.00101918f
Cred_10316 vout.P18.pSD vss.$1299.Metal5 0.00101918f
Cred_10317 vout.P2.nSD vss 0.000150601f
Cred_10318 vout.P2.nSD vss.$1211.Metal5 0.000155316f
Cred_10319 vout.P2.nSD vss.$1229.Metal5 0.000155316f
Cred_10320 vout.P2.nSD vss.$1281.Metal5 0.000594518f
Cred_10321 vout.P2.nSD vss.$1299.Metal5 0.000594518f
Cred_10322 vout.P2.nSD vss.$13.Metal1 0.00148143f
Cred_10323 vout.P2.nSD vss.$467.Metal2 0.000257417f
Cred_10324 vout.P2.nSD vss.$469.Metal2 0.00219928f
Cred_10325 vout.P2.nSD vss.$473.Metal2 0.00207021f
Cred_10326 vout.P2.nSD vss.$475.Metal2 0.000385974f
Cred_10327 vout.P2.nSD vss.$805.Metal3 0.0019518f
Cred_10328 vout.P2.nSD vss.P3.nSD 0.00112778f
Cred_10329 vout.P2.nSD vss.P5.nSD 0.00112829f
Cred_10330 vout.P2.pSD vss 0.000728222f
Cred_10331 vout.P2.pSD vss.$1211.Metal5 0.000265725f
Cred_10332 vout.P2.pSD vss.$1229.Metal5 0.000265725f
Cred_10333 vout.P2.pSD vss.$1281.Metal5 0.00101714f
Cred_10334 vout.P2.pSD vss.$1299.Metal5 0.00101714f
Cred_10335 vout.P4.nSD vss 0.000158068f
Cred_10336 vout.P4.nSD vss.$1211.Metal5 0.000163017f
Cred_10337 vout.P4.nSD vss.$1229.Metal5 0.000163017f
Cred_10338 vout.P4.nSD vss.$1281.Metal5 0.000623994f
Cred_10339 vout.P4.nSD vss.$1299.Metal5 0.000623994f
Cred_10340 vout.P4.nSD vss.$136.Metal1 7.82838e-06f
Cred_10341 vout.P4.nSD vss.$473.Metal2 0.000932771f
Cred_10342 vout.P4.nSD vss.$475.Metal2 0.00210413f
Cred_10343 vout.P4.nSD vss.$479.Metal2 0.0016926f
Cred_10344 vout.P4.nSD vss.$809.Metal3 0.00100046f
Cred_10345 vout.P4.nSD vss.$811.Metal3 0.00100829f
Cred_10346 vout.P4.nSD vss.P5.nSD 0.00112829f
Cred_10347 vout.P4.nSD vss.P7.nSD 0.00112907f
Cred_10348 vout.P4.pSD vss 0.000728222f
Cred_10349 vout.P4.pSD vss.$1211.Metal5 0.000265725f
Cred_10350 vout.P4.pSD vss.$1229.Metal5 0.000265725f
Cred_10351 vout.P4.pSD vss.$1281.Metal5 0.00101714f
Cred_10352 vout.P4.pSD vss.$1299.Metal5 0.00101714f
Cred_10353 vout.P6.nSD vss.$1281.Metal5 0.00130606f
Cred_10354 vout.P6.nSD vss.$136.Metal1 1.66944e-06f
Cred_10355 vout.P6.nSD vss.$138.Metal1 0.00152852f
Cred_10356 vout.P6.nSD vss.$140.Metal1 2.08246e-06f
Cred_10357 vout.P6.nSD vss.$475.Metal2 0.000141588f
Cred_10358 vout.P6.nSD vss.$479.Metal2 0.00227434f
Cred_10359 vout.P6.nSD vss.$483.Metal2 0.00226537f
Cred_10360 vout.P6.nSD vss.$487.Metal2 0.000176616f
Cred_10361 vout.P6.nSD vss.$811.Metal3 1.66944e-06f
Cred_10362 vout.P6.nSD vss.$815.Metal3 0.00201406f
Cred_10363 vout.P6.nSD vss.$819.Metal3 2.08246e-06f
Cred_10364 vout.P6.nSD vss.P10.nSD 0.00114034f
Cred_10365 vout.P6.nSD vss.P7.nSD 0.00111639f
Cred_10366 vout.P6.pSD vss 0.000728222f
Cred_10367 vout.P6.pSD vss.$1211.Metal5 0.000265725f
Cred_10368 vout.P6.pSD vss.$1229.Metal5 0.000265725f
Cred_10369 vout.P6.pSD vss.$1281.Metal5 0.00101714f
Cred_10370 vout.P6.pSD vss.$1299.Metal5 0.00101714f
Cred_10371 vout.P8.nSD vss.$1281.Metal5 0.00179617f
Cred_10372 vout.P8.nSD vss.$140.Metal1 8.20208e-06f
Cred_10373 vout.P8.nSD vss.$483.Metal2 0.00165957f
Cred_10374 vout.P8.nSD vss.$487.Metal2 0.00101137f
Cred_10375 vout.P8.nSD vss.$489.Metal2 0.000978782f
Cred_10376 vout.P8.nSD vss.$819.Metal3 0.00100866f
Cred_10377 vout.P8.nSD vss.P10.nSD 0.00112965f
Cred_10378 vout.P8.nSD vss.P11.nSD 0.00110717f
Cred_10379 vout.P8.pSD vss 0.000728222f
Cred_10380 vout.P8.pSD vss.$1211.Metal5 0.000265725f
Cred_10381 vout.P8.pSD vss.$1229.Metal5 0.000265725f
Cred_10382 vout.P8.pSD vss.$1281.Metal5 0.00101714f
Cred_10383 vout.P8.pSD vss.$1299.Metal5 0.00101714f
Cred_10384 vref vss 0.193671f
Cred_10385 vref vss.$1033.Metal4 0.000178013f
Cred_10386 vref vss.$1037.Metal4 0.000178013f
Cred_10387 vref vss.$1063.Metal4 1.41882e-05f
Cred_10388 vref vss.$1069.Metal4 2.39449e-05f
Cred_10389 vref vss.$1211.Metal5 0.112522f
Cred_10390 vref vss.$1229.Metal5 0.112522f
Cred_10391 vref vss.$1246.Metal5 0.046726f
Cred_10392 vref vss.$127.Metal1 0.000909334f
Cred_10393 vref vss.$1281.Metal5 0.472382f
Cred_10394 vref vss.$1299.Metal5 0.489578f
Cred_10395 vref vss.$143.Metal1 0.000309771f
Cred_10396 vref vss.$159.Metal1 0.00161768f
Cred_10397 vref vss.$406.Metal1 0.0395473f
Cred_10398 vref vss.$457.Metal2 1.32807e-05f
Cred_10399 vref vss.$461.Metal2 0.000486904f
Cred_10400 vref vss.$463.Metal2 3.84398e-05f
Cred_10401 vref vss.$487.Metal2 0.0109028f
Cred_10402 vref vss.$489.Metal2 0.0342069f
Cred_10403 vref vss.$493.Metal2 0.0328367f
Cred_10404 vref vss.$495.Metal2 0.0104608f
Cred_10405 vref vss.$519.Metal2 1.41882e-05f
Cred_10406 vref vss.$525.Metal2 4.75708e-05f
Cred_10407 vref vss.$825.Metal3 0.00181277f
Cred_10408 vref vss.$851.Metal3 0.00120333f
Cred_10409 vref vss.$855.Metal3 0.00363836f
Cred_10410 vref vss.$857.Metal3 0.00446583f
Cred_10411 vref vss.P0.GatPoly 7.089e-05f
Cred_10412 vref vss.P0.nSD 0.000139661f
Cred_10413 vref vss.P0.pSD 0.0445168f
Cred_10414 vref vss.P1.GatPoly 0.0016454f
Cred_10415 vref vss.P11.nSD 0.0203564f
Cred_10416 vref vss.P13.nSD 0.019467f
Cred_10417 vref.P0.GatPoly vss 0.00475894f
Cred_10418 vref.P0.GatPoly vss.$1033.Metal4 6.94152e-06f
Cred_10419 vref.P0.GatPoly vss.$1037.Metal4 6.94152e-06f
Cred_10420 vref.P0.GatPoly vss.$1211.Metal5 0.00267901f
Cred_10421 vref.P0.GatPoly vss.$1229.Metal5 0.00267901f
Cred_10422 vref.P0.GatPoly vss.$1246.Metal5 0.00182205f
Cred_10423 vref.P0.GatPoly vss.$127.Metal1 9.42363e-05f
Cred_10424 vref.P0.GatPoly vss.$1281.Metal5 0.0118797f
Cred_10425 vref.P0.GatPoly vss.$1299.Metal5 0.0125502f
Cred_10426 vref.P0.GatPoly vss.$143.Metal1 1.20793e-05f
Cred_10427 vref.P0.GatPoly vss.$406.Metal1 0.000656162f
Cred_10428 vref.P0.GatPoly vss.$457.Metal2 1.37631e-06f
Cred_10429 vref.P0.GatPoly vss.$461.Metal2 1.89865e-05f
Cred_10430 vref.P0.GatPoly vss.$463.Metal2 1.49894e-06f
Cred_10431 vref.P0.GatPoly vss.$487.Metal2 0.000425147f
Cred_10432 vref.P0.GatPoly vss.$489.Metal2 0.00133388f
Cred_10433 vref.P0.GatPoly vss.$493.Metal2 0.00128045f
Cred_10434 vref.P0.GatPoly vss.$495.Metal2 0.000407911f
Cred_10435 vref.P0.GatPoly vss.$825.Metal3 7.0688e-05f
Cred_10436 vref.P0.GatPoly vss.P0.GatPoly 4.86566e-06f
Cred_10437 vref.P0.GatPoly vss.P0.nSD 5.44598e-06f
Cred_10438 vref.P0.GatPoly vss.P0.pSD 0.00419674f
Cred_10439 vref.P0.GatPoly vss.P11.nSD 0.000793786f
Cred_10440 vref.P0.GatPoly vss.P13.nSD 0.000759105f
Cred_10441 vref.P0.nSD vss 0.0256252f
Cred_10442 vref.P0.nSD vss.$1033.Metal4 5.72153e-05f
Cred_10443 vref.P0.nSD vss.$1037.Metal4 5.72153e-05f
Cred_10444 vref.P0.nSD vss.$1211.Metal5 0.0142231f
Cred_10445 vref.P0.nSD vss.$1229.Metal5 0.0142231f
Cred_10446 vref.P0.nSD vss.$1246.Metal5 0.0150182f
Cred_10447 vref.P0.nSD vss.$127.Metal1 0.00021222f
Cred_10448 vref.P0.nSD vss.$1281.Metal5 0.0694148f
Cred_10449 vref.P0.nSD vss.$1299.Metal5 0.0749062f
Cred_10450 vref.P0.nSD vss.$143.Metal1 0.00422102f
Cred_10451 vref.P0.nSD vss.$406.Metal1 0.000567592f
Cred_10452 vref.P0.nSD vss.$457.Metal2 3.09944e-06f
Cred_10453 vref.P0.nSD vss.$461.Metal2 0.00015566f
Cred_10454 vref.P0.nSD vss.$463.Metal2 1.2289e-05f
Cred_10455 vref.P0.nSD vss.$487.Metal2 0.0408949f
Cred_10456 vref.P0.nSD vss.$489.Metal2 0.129851f
Cred_10457 vref.P0.nSD vss.$493.Metal2 0.124918f
Cred_10458 vref.P0.nSD vss.$495.Metal2 0.0393036f
Cred_10459 vref.P0.nSD vss.$825.Metal3 0.00518515f
Cred_10460 vref.P0.nSD vss.P0.GatPoly 1.9857e-05f
Cred_10461 vref.P0.nSD vss.P0.nSD 4.46486e-05f
Cred_10462 vref.P0.nSD vss.P0.pSD 0.00481806f
Cred_10463 vref.P0.nSD vss.P11.nSD 0.104848f
Cred_10464 vref.P0.nSD vss.P13.nSD 0.100302f
Cred_10465 vref.P0.pSD vss 0.0617683f
Cred_10466 vref.P0.pSD vss.$1033.Metal4 7.00671e-05f
Cred_10467 vref.P0.pSD vss.$1037.Metal4 7.00671e-05f
Cred_10468 vref.P0.pSD vss.$1211.Metal5 0.0309077f
Cred_10469 vref.P0.pSD vss.$1229.Metal5 0.0309077f
Cred_10470 vref.P0.pSD vss.$1246.Metal5 0.0183917f
Cred_10471 vref.P0.pSD vss.$127.Metal1 0.000210554f
Cred_10472 vref.P0.pSD vss.$1281.Metal5 0.134647f
Cred_10473 vref.P0.pSD vss.$1299.Metal5 0.141384f
Cred_10474 vref.P0.pSD vss.$143.Metal1 0.000121371f
Cred_10475 vref.P0.pSD vss.$406.Metal1 0.000452137f
Cred_10476 vref.P0.pSD vss.$457.Metal2 3.07511e-06f
Cred_10477 vref.P0.pSD vss.$461.Metal2 0.000190774f
Cred_10478 vref.P0.pSD vss.$463.Metal2 1.50611e-05f
Cred_10479 vref.P0.pSD vss.$487.Metal2 0.00427182f
Cred_10480 vref.P0.pSD vss.$489.Metal2 0.0134026f
Cred_10481 vref.P0.pSD vss.$493.Metal2 0.0128658f
Cred_10482 vref.P0.pSD vss.$495.Metal2 0.00409864f
Cred_10483 vref.P0.pSD vss.$825.Metal3 0.000710267f
Cred_10484 vref.P0.pSD vss.P0.GatPoly 2.25654e-05f
Cred_10485 vref.P0.pSD vss.P0.nSD 5.47205e-05f
Cred_10486 vref.P0.pSD vss.P0.pSD 0.00361925f
Cred_10487 vref.P0.pSD vss.P11.nSD 0.00797586f
Cred_10488 vref.P0.pSD vss.P13.nSD 0.00762738f
Rred_1 \$I44 \$I44.P0.GatPoly 9.26754456851
Rred_2 \$I47 \$I47.P0.Metal1 9.55014819844
Rred_3 \$I52.$2169.TopMetal1 \$I52.P0.GatPoly 16.1204977046
Rred_4 \$I52.$2169.TopMetal1 \$I52.P1.GatPoly 32.2449650287
Rred_5 \$I52.$2169.TopMetal1 \$I52.P2.GatPoly 37.588516516
Rred_6 \$I52.P0.GatPoly \$I52.P1.GatPoly 62.5890291186
Rred_7 \$I52.P0.GatPoly \$I52.P2.GatPoly 72.9611197484
Rred_8 \$I52.P1.GatPoly \$I52.P2.GatPoly 21.0243075013
Rred_9 \$I66 \$I66.$692.Metal3 16.8159425828
Rred_10 \$I66 \$I66.$748.Metal3 10.9208544722
Rred_11 \$I66.$689.Metal3 \$I66.$692.Metal3 0.121358489314
Rred_12 \$I66.$689.Metal3 \$I66.P21.GatPoly 106.99383009
Rred_13 \$I66.$689.Metal3 \$I66.P22.GatPoly 106.95336707
Rred_14 \$I66.$689.Metal3 \$I66.P23.GatPoly 106.872517496
Rred_15 \$I66.$689.Metal3 \$I66.P24.GatPoly 160.359314873
Rred_16 \$I66.$689.Metal3 \$I66.P25.GatPoly 320.779297515
Rred_17 \$I66.$692.Metal3 \$I66.$696.Metal3 0.161882730028
Rred_18 \$I66.$692.Metal3 \$I66.$748.Metal3 0.769505538787
Rred_19 \$I66.$692.Metal3 \$I66.P24.GatPoly 320.779297515
Rred_20 \$I66.$692.Metal3 \$I66.P25.GatPoly 160.359314873
Rred_21 \$I66.$692.Metal3 \$I66.P26.GatPoly 106.872517496
Rred_22 \$I66.$692.Metal3 \$I66.P27.GatPoly 142.559576961
Rred_23 \$I66.$692.Metal3 \$I66.P28.GatPoly 213.906780019
Rred_24 \$I66.$692.Metal3 \$I66.P29.GatPoly 427.894486094
Rred_25 \$I66.$696.Metal3 \$I66.$700.Metal3 0.242931211455
Rred_26 \$I66.$696.Metal3 \$I66.P27.GatPoly 427.894486094
Rred_27 \$I66.$696.Metal3 \$I66.P28.GatPoly 213.906780019
Rred_28 \$I66.$696.Metal3 \$I66.P29.GatPoly 142.559576961
Rred_29 \$I66.$696.Metal3 \$I66.P30.GatPoly 106.872517496
Rred_30 \$I66.$696.Metal3 \$I66.P31.GatPoly 213.933695891
Rred_31 \$I66.$696.Metal3 \$I66.P32.GatPoly 321.00171031
Rred_32 \$I66.$696.Metal3 \$I66.P33.GatPoly 642.124863253
Rred_33 \$I66.$700.Metal3 \$I66.$704.Metal3 0.161882730028
Rred_34 \$I66.$700.Metal3 \$I66.P31.GatPoly 214.041621085
Rred_35 \$I66.$700.Metal3 \$I66.P32.GatPoly 160.485679132
Rred_36 \$I66.$700.Metal3 \$I66.P33.GatPoly 128.327862624
Rred_37 \$I66.$700.Metal3 \$I66.P34.GatPoly 106.872517496
Rred_38 \$I66.$700.Metal3 \$I66.P35.GatPoly 142.559576961
Rred_39 \$I66.$700.Metal3 \$I66.P36.GatPoly 213.906780019
Rred_40 \$I66.$700.Metal3 \$I66.P37.GatPoly 427.894486094
Rred_41 \$I66.$704.Metal3 \$I66.P35.GatPoly 427.894486094
Rred_42 \$I66.$704.Metal3 \$I66.P36.GatPoly 213.906780019
Rred_43 \$I66.$704.Metal3 \$I66.P37.GatPoly 142.559576961
Rred_44 \$I66.$704.Metal3 \$I66.P38.GatPoly 106.872517496
Rred_45 \$I66.$704.Metal3 \$I66.P39.GatPoly 106.95336707
Rred_46 \$I66.$704.Metal3 \$I66.P40.GatPoly 106.99383009
Rred_47 \$I66.$748.Metal3 \$I66.$758.Metal3 0.945466142238
Rred_48 \$I66.$748.Metal3 \$I66.$760.Metal3 0.945466142238
Rred_49 \$I66.$748.Metal3 \$I66.P0.GatPoly 11.5223057025
Rred_50 \$I66.$748.Metal3 \$I66.P6.GatPoly 4261.87439027
Rred_51 \$I66.$758.Metal3 \$I66.$760.Metal3 0.0844868776627
Rred_52 \$I66.$758.Metal3 \$I66.P1.GatPoly 182.661591764
Rred_53 \$I66.$758.Metal3 \$I66.P2.GatPoly 182.621078592
Rred_54 \$I66.$758.Metal3 \$I66.P3.GatPoly 182.540097162
Rred_55 \$I66.$758.Metal3 \$I66.P4.GatPoly 182.418737174
Rred_56 \$I66.$758.Metal3 \$I66.P5.GatPoly 182.257132881
Rred_57 \$I66.$758.Metal3 \$I66.P6.GatPoly 380.841200059
Rred_58 \$I66.$760.Metal3 \$I66.$764.Metal3 0.2427919586
Rred_59 \$I66.$760.Metal3 \$I66.P10.GatPoly 364.810818106
Rred_60 \$I66.$760.Metal3 \$I66.P6.GatPoly 380.841200059
Rred_61 \$I66.$760.Metal3 \$I66.P7.GatPoly 182.257132881
Rred_62 \$I66.$760.Metal3 \$I66.P8.GatPoly 218.789410693
Rred_63 \$I66.$760.Metal3 \$I66.P9.GatPoly 273.56259766
Rred_64 \$I66.$764.Metal3 \$I66.$767.Metal3 0.121333177863
Rred_65 \$I66.$764.Metal3 \$I66.P10.GatPoly 364.702936496
Rred_66 \$I66.$764.Metal3 \$I66.P11.GatPoly 182.257132881
Rred_67 \$I66.$764.Metal3 \$I66.P12.GatPoly 273.43623874
Rred_68 \$I66.$764.Metal3 \$I66.P13.GatPoly 546.933137341
Rred_69 \$I66.$764.Metal3 \$I66.P8.GatPoly 1094.43245432
Rred_70 \$I66.$764.Metal3 \$I66.P9.GatPoly 547.155535901
Rred_71 \$I66.$767.Metal3 \$I66.$771.Metal3 0.161819438109
Rred_72 \$I66.$767.Metal3 \$I66.P12.GatPoly 546.933137341
Rred_73 \$I66.$767.Metal3 \$I66.P13.GatPoly 273.43623874
Rred_74 \$I66.$767.Metal3 \$I66.P14.GatPoly 182.257132881
Rred_75 \$I66.$767.Metal3 \$I66.P15.GatPoly 243.072400752
Rred_76 \$I66.$767.Metal3 \$I66.P16.GatPoly 364.676004461
Rred_77 \$I66.$767.Metal3 \$I66.P17.GatPoly 729.432909667
Rred_78 \$I66.$771.Metal3 \$I66.P15.GatPoly 729.432909667
Rred_79 \$I66.$771.Metal3 \$I66.P16.GatPoly 364.676004461
Rred_80 \$I66.$771.Metal3 \$I66.P17.GatPoly 243.072400752
Rred_81 \$I66.$771.Metal3 \$I66.P18.GatPoly 182.257132881
Rred_82 \$I66.$771.Metal3 \$I66.P19.GatPoly 182.337988778
Rred_83 \$I66.$771.Metal3 \$I66.P20.GatPoly 182.378439148
Rred_84 \$I66.P1.GatPoly \$I66.P2.GatPoly 274379.840606
Rred_85 \$I66.P1.GatPoly \$I66.P3.GatPoly 411645.845711
Rred_86 \$I66.P1.GatPoly \$I66.P4.GatPoly 823383.012088
Rred_87 \$I66.P10.GatPoly \$I66.P8.GatPoly 1644456.43638
Rred_88 \$I66.P10.GatPoly \$I66.P9.GatPoly 822137.025599
Rred_89 \$I66.P12.GatPoly \$I66.P13.GatPoly 2465408.57159
Rred_90 \$I66.P15.GatPoly \$I66.P16.GatPoly 1643848.73738
Rred_91 \$I66.P15.GatPoly \$I66.P17.GatPoly 3288062.15077
Rred_92 \$I66.P16.GatPoly \$I66.P17.GatPoly 1643848.73738
Rred_93 \$I66.P19.GatPoly \$I66.P20.GatPoly 822106.646041
Rred_94 \$I66.P2.GatPoly \$I66.P3.GatPoly 411554.545299
Rred_95 \$I66.P2.GatPoly \$I66.P4.GatPoly 823200.391009
Rred_96 \$I66.P21.GatPoly \$I66.P22.GatPoly 282810.093046
Rred_97 \$I66.P24.GatPoly \$I66.P25.GatPoly 847895.835686
Rred_98 \$I66.P27.GatPoly \$I66.P28.GatPoly 565406.400625
Rred_99 \$I66.P27.GatPoly \$I66.P29.GatPoly 1131026.70803
Rred_100 \$I66.P28.GatPoly \$I66.P29.GatPoly 565406.400625
Rred_101 \$I66.P3.GatPoly \$I66.P4.GatPoly 822835.351301
Rred_102 \$I66.P31.GatPoly \$I66.P32.GatPoly 282827.908501
Rred_103 \$I66.P31.GatPoly \$I66.P33.GatPoly 565762.817573
Rred_104 \$I66.P32.GatPoly \$I66.P33.GatPoly 424201.74892
Rred_105 \$I66.P35.GatPoly \$I66.P36.GatPoly 565406.400625
Rred_106 \$I66.P35.GatPoly \$I66.P37.GatPoly 1131026.70803
Rred_107 \$I66.P36.GatPoly \$I66.P37.GatPoly 565406.400625
Rred_108 \$I66.P39.GatPoly \$I66.P40.GatPoly 282810.093046
Rred_109 \$I66.P8.GatPoly \$I66.P9.GatPoly 1233137.15533
Rred_110 \$I67 \$I67.$82.Metal2 6.1504951628
Rred_111 \$I67.$82.Metal2 \$I67.P0.GatPoly 10.4419915525
Rred_112 \$I67.$82.Metal2 \$I67.P1.GatPoly 181.785367693
Rred_113 \$I67.$82.Metal2 \$I67.P2.GatPoly 181.785367693
Rred_114 \$I67.$82.Metal2 \$I67.P3.GatPoly 114.663376941
Rred_115 \$I67.$82.Metal2 \$I67.P4.GatPoly 114.663376941
Rred_116 \$I67.P0.GatPoly \$I67.P3.GatPoly 1423.6300523
Rred_117 \$I67.P0.GatPoly \$I67.P4.GatPoly 1423.6300523
Rred_118 \$I67.P1.GatPoly \$I67.P2.GatPoly 26556.3298354
Rred_119 \$I67.P3.GatPoly \$I67.P4.GatPoly 10161.4324816
Rred_120 vdd vdd.$4071.TopMetal1 0.00599424228649
Rred_121 vdd vdd.$4456.TopMetal1 111.778994692
Rred_122 vdd vdd.$4841.TopMetal1 2084424.19529
Rred_123 vdd vdd.$5226.TopMetal1 38867689368
Rred_124 vdd.$2365.Metal1 vdd.$2367.Metal1 0.0883995609059
Rred_125 vdd.$2365.Metal1 vdd.$2399.Metal1 11187.3619533
Rred_126 vdd.$2365.Metal1 vdd.$2745.Metal2 2.03704056652
Rred_127 vdd.$2365.Metal1 vdd.$2979.Metal3 266.50533199
Rred_128 vdd.$2365.Metal1 vdd.$3213.Metal4 23133.8332313
Rred_129 vdd.$2365.Metal1 vdd.$3480.Metal5 1976121.78544
Rred_130 vdd.$2365.Metal1 vdd.P0.nSD 1.31005351693
Rred_131 vdd.$2365.Metal1 vdd.P1.GatPoly 2022.22030307
Rred_132 vdd.$2365.Metal1 vdd.P2.GatPoly 251522.998504
Rred_133 vdd.$2367.Metal1 vdd.$2370.Metal1 0.134559428923
Rred_134 vdd.$2367.Metal1 vdd.$2745.Metal2 6.05286004003
Rred_135 vdd.$2367.Metal1 vdd.$2747.Metal2 3
Rred_136 vdd.$2367.Metal1 vdd.$2749.Metal2 4.56688030678
Rred_137 vdd.$2367.Metal1 vdd.$2751.Metal2 9.21460098846
Rred_138 vdd.$2367.Metal1 vdd.P0.nSD 5.68980792238
Rred_139 vdd.$2370.Metal1 vdd.$2372.Metal1 0.0883994246216
Rred_140 vdd.$2370.Metal1 vdd.$2749.Metal2 9.21488323132
Rred_141 vdd.$2370.Metal1 vdd.$2751.Metal2 2.60648259286
Rred_142 vdd.$2370.Metal1 vdd.$2755.Metal2 3.03408531623
Rred_143 vdd.$2370.Metal1 vdd.$2987.Metal3 514.984633507
Rred_144 vdd.$2370.Metal1 vdd.P0.nSD 5.70533930584
Rred_145 vdd.$2370.Metal1 vdd.P3.pSD 2611.03699336
Rred_146 vdd.$2372.Metal1 vdd.$2375.Metal1 0.134558869576
Rred_147 vdd.$2372.Metal1 vdd.$2755.Metal2 3.03087840479
Rred_148 vdd.$2372.Metal1 vdd.$2759.Metal2 2.60627932701
Rred_149 vdd.$2372.Metal1 vdd.$2761.Metal2 9.21430868178
Rred_150 vdd.$2372.Metal1 vdd.$2991.Metal3 514.869179601
Rred_151 vdd.$2372.Metal1 vdd.P0.nSD 5.67433925472
Rred_152 vdd.$2375.Metal1 vdd.$2377.Metal1 0.0883990157686
Rred_153 vdd.$2375.Metal1 vdd.$2759.Metal2 9.21515541204
Rred_154 vdd.$2375.Metal1 vdd.$2761.Metal2 2.60652642294
Rred_155 vdd.$2375.Metal1 vdd.$2765.Metal2 3.03444908326
Rred_156 vdd.$2375.Metal1 vdd.$2997.Metal3 515.01527609
Rred_157 vdd.$2375.Metal1 vdd.P0.nSD 5.72093407817
Rred_158 vdd.$2375.Metal1 vdd.P7.pSD 2321.45482847
Rred_159 vdd.$2377.Metal1 vdd.$2379.Metal1 0.0883955211654
Rred_160 vdd.$2377.Metal1 vdd.$2765.Metal2 3.03086208958
Rred_161 vdd.$2377.Metal1 vdd.$2769.Metal2 3.03119253422
Rred_162 vdd.$2377.Metal1 vdd.$3001.Metal3 514.869179601
Rred_163 vdd.$2377.Metal1 vdd.P0.nSD 7.07550195699
Rred_164 vdd.$2379.Metal1 vdd.$2382.Metal1 0.134538560711
Rred_165 vdd.$2379.Metal1 vdd.$2769.Metal2 6.05391833738
Rred_166 vdd.$2379.Metal1 vdd.$2771.Metal2 3
Rred_167 vdd.$2379.Metal1 vdd.$2773.Metal2 4.56587429068
Rred_168 vdd.$2379.Metal1 vdd.$2775.Metal2 9.21249473047
Rred_169 vdd.$2379.Metal1 vdd.P0.nSD 5.67230583869
Rred_170 vdd.$2382.Metal1 vdd.$2385.Metal1 0.134538560711
Rred_171 vdd.$2382.Metal1 vdd.$2773.Metal2 9.21269223899
Rred_172 vdd.$2382.Metal1 vdd.$2775.Metal2 2.60594355069
Rred_173 vdd.$2382.Metal1 vdd.$2779.Metal2 2.60594355069
Rred_174 vdd.$2382.Metal1 vdd.$2781.Metal2 9.21269223899
Rred_175 vdd.$2382.Metal1 vdd.$3011.Metal3 514.869179601
Rred_176 vdd.$2382.Metal1 vdd.P0.nSD 5.70077198117
Rred_177 vdd.$2385.Metal1 vdd.$2387.Metal1 0.0883955211654
Rred_178 vdd.$2385.Metal1 vdd.$2779.Metal2 9.21249473047
Rred_179 vdd.$2385.Metal1 vdd.$2781.Metal2 4.56587429068
Rred_180 vdd.$2385.Metal1 vdd.$2783.Metal2 3
Rred_181 vdd.$2385.Metal1 vdd.$2785.Metal2 6.05391833738
Rred_182 vdd.$2385.Metal1 vdd.P0.nSD 5.67230583869
Rred_183 vdd.$2387.Metal1 vdd.$2389.Metal1 0.0883990157686
Rred_184 vdd.$2387.Metal1 vdd.$2785.Metal2 3.03119253422
Rred_185 vdd.$2387.Metal1 vdd.$2789.Metal2 3.03086208958
Rred_186 vdd.$2387.Metal1 vdd.$3021.Metal3 514.869179601
Rred_187 vdd.$2387.Metal1 vdd.P0.nSD 7.07550195699
Rred_188 vdd.$2389.Metal1 vdd.$2392.Metal1 0.134558869576
Rred_189 vdd.$2389.Metal1 vdd.$2789.Metal2 3.03444908326
Rred_190 vdd.$2389.Metal1 vdd.$2793.Metal2 2.60652642294
Rred_191 vdd.$2389.Metal1 vdd.$2795.Metal2 9.21515541204
Rred_192 vdd.$2389.Metal1 vdd.$3025.Metal3 515.01527609
Rred_193 vdd.$2389.Metal1 vdd.P0.nSD 5.72093407817
Rred_194 vdd.$2389.Metal1 vdd.P17.pSD 2321.45482847
Rred_195 vdd.$2392.Metal1 vdd.$2394.Metal1 0.0883994246216
Rred_196 vdd.$2392.Metal1 vdd.$2793.Metal2 9.21430868178
Rred_197 vdd.$2392.Metal1 vdd.$2795.Metal2 2.60627932701
Rred_198 vdd.$2392.Metal1 vdd.$2799.Metal2 3.03087840479
Rred_199 vdd.$2392.Metal1 vdd.$3031.Metal3 514.869179601
Rred_200 vdd.$2392.Metal1 vdd.P0.nSD 5.67433925472
Rred_201 vdd.$2394.Metal1 vdd.$2397.Metal1 0.134559428923
Rred_202 vdd.$2394.Metal1 vdd.$2799.Metal2 3.03408531623
Rred_203 vdd.$2394.Metal1 vdd.$2803.Metal2 2.60648259286
Rred_204 vdd.$2394.Metal1 vdd.$2805.Metal2 9.21488323132
Rred_205 vdd.$2394.Metal1 vdd.$3035.Metal3 514.984633507
Rred_206 vdd.$2394.Metal1 vdd.P0.nSD 5.70533930584
Rred_207 vdd.$2394.Metal1 vdd.P21.pSD 2611.03699336
Rred_208 vdd.$2397.Metal1 vdd.$2399.Metal1 0.0883995609059
Rred_209 vdd.$2397.Metal1 vdd.$2803.Metal2 9.21460098846
Rred_210 vdd.$2397.Metal1 vdd.$2805.Metal2 4.56688030678
Rred_211 vdd.$2397.Metal1 vdd.$2807.Metal2 3
Rred_212 vdd.$2397.Metal1 vdd.$2809.Metal2 6.05286004003
Rred_213 vdd.$2397.Metal1 vdd.P0.nSD 5.68980792238
Rred_214 vdd.$2399.Metal1 vdd.$2809.Metal2 2.03704056652
Rred_215 vdd.$2399.Metal1 vdd.$3043.Metal3 266.50533199
Rred_216 vdd.$2399.Metal1 vdd.$3277.Metal4 23133.8332313
Rred_217 vdd.$2399.Metal1 vdd.$3496.Metal5 1976121.78544
Rred_218 vdd.$2399.Metal1 vdd.P0.nSD 1.31005351693
Rred_219 vdd.$2399.Metal1 vdd.P1.GatPoly 251522.998504
Rred_220 vdd.$2399.Metal1 vdd.P2.GatPoly 2022.22030307
Rred_221 vdd.$2745.Metal2 vdd.$2747.Metal2 0.0353725490196
Rred_222 vdd.$2745.Metal2 vdd.$2979.Metal3 1.53475662457
Rred_223 vdd.$2745.Metal2 vdd.$3213.Metal4 272.767549995
Rred_224 vdd.$2745.Metal2 vdd.$3480.Metal5 23300.1549081
Rred_225 vdd.$2745.Metal2 vdd.P0.nSD 2007.30263827
Rred_226 vdd.$2747.Metal2 vdd.$2749.Metal2 0.0354011932647
Rred_227 vdd.$2747.Metal2 vdd.$2979.Metal3 6.07074509804
Rred_228 vdd.$2747.Metal2 vdd.$2983.Metal3 6.07074509804
Rred_229 vdd.$2747.Metal2 vdd.$3215.Metal4 514.869179601
Rred_230 vdd.$2747.Metal2 vdd.P0.pSD 3.19877928581
Rred_231 vdd.$2749.Metal2 vdd.$2751.Metal2 0.0354620166296
Rred_232 vdd.$2749.Metal2 vdd.$2983.Metal3 3
Rred_233 vdd.$2749.Metal2 vdd.P0.nSD 940.538103734
Rred_234 vdd.$2749.Metal2 vdd.P0.pSD 40.5178709535
Rred_235 vdd.$2749.Metal2 vdd.P1.pSD 4.34890354054
Rred_236 vdd.$2751.Metal2 vdd.$2755.Metal2 0.071729556187
Rred_237 vdd.$2751.Metal2 vdd.$2983.Metal3 6.07074509804
Rred_238 vdd.$2751.Metal2 vdd.$2987.Metal3 3.03571283578
Rred_239 vdd.$2751.Metal2 vdd.$3219.Metal4 514.869179601
Rred_240 vdd.$2751.Metal2 vdd.P0.nSD 946.703200702
Rred_241 vdd.$2751.Metal2 vdd.P1.pSD 9.36686916425
Rred_242 vdd.$2751.Metal2 vdd.P3.pSD 30.7863446799
Rred_243 vdd.$2755.Metal2 vdd.$2759.Metal2 0.0715792428553
Rred_244 vdd.$2755.Metal2 vdd.$2987.Metal3 3.03855628208
Rred_245 vdd.$2755.Metal2 vdd.$2991.Metal3 3.03537254902
Rred_246 vdd.$2755.Metal2 vdd.$3223.Metal4 514.869179601
Rred_247 vdd.$2755.Metal2 vdd.P0.nSD 2007.30172086
Rred_248 vdd.$2755.Metal2 vdd.P3.pSD 3.29361726219
Rred_249 vdd.$2759.Metal2 vdd.$2761.Metal2 0.0354579968404
Rred_250 vdd.$2759.Metal2 vdd.$2991.Metal3 6.07074509804
Rred_251 vdd.$2759.Metal2 vdd.$2993.Metal3 3
Rred_252 vdd.$2759.Metal2 vdd.P0.nSD 934.452661509
Rred_253 vdd.$2759.Metal2 vdd.P5.pSD 4.1984653522
Rred_254 vdd.$2761.Metal2 vdd.$2765.Metal2 0.0717460306383
Rred_255 vdd.$2761.Metal2 vdd.$2993.Metal3 6.07074509804
Rred_256 vdd.$2761.Metal2 vdd.$2997.Metal3 3.03580313836
Rred_257 vdd.$2761.Metal2 vdd.$3229.Metal4 514.869179601
Rred_258 vdd.$2761.Metal2 vdd.P0.nSD 952.94960424
Rred_259 vdd.$2761.Metal2 vdd.P5.pSD 10.1462912678
Rred_260 vdd.$2761.Metal2 vdd.P7.pSD 27.3719249056
Rred_261 vdd.$2765.Metal2 vdd.$2769.Metal2 0.0715792428553
Rred_262 vdd.$2765.Metal2 vdd.$2997.Metal3 3.03890481549
Rred_263 vdd.$2765.Metal2 vdd.$3001.Metal3 3.03537254902
Rred_264 vdd.$2765.Metal2 vdd.$3233.Metal4 514.869179601
Rred_265 vdd.$2765.Metal2 vdd.P0.nSD 2007.29896861
Rred_266 vdd.$2765.Metal2 vdd.P7.pSD 3.34009371786
Rred_267 vdd.$2769.Metal2 vdd.$2771.Metal2 0.0354554665712
Rred_268 vdd.$2769.Metal2 vdd.$3001.Metal3 6.07074509804
Rred_269 vdd.$2769.Metal2 vdd.$3003.Metal3 3
Rred_270 vdd.$2769.Metal2 vdd.P0.nSD 1784.1632144
Rred_271 vdd.$2769.Metal2 vdd.P10.pSD 4.05799886006
Rred_272 vdd.$2771.Metal2 vdd.$2773.Metal2 0.0353725490196
Rred_273 vdd.$2771.Metal2 vdd.$3003.Metal3 6.07074509804
Rred_274 vdd.$2771.Metal2 vdd.$3007.Metal3 6.07074509804
Rred_275 vdd.$2771.Metal2 vdd.$3239.Metal4 514.869179601
Rred_276 vdd.$2771.Metal2 vdd.P10.pSD 11.0672696184
Rred_277 vdd.$2773.Metal2 vdd.$2775.Metal2 0.0354484492076
Rred_278 vdd.$2773.Metal2 vdd.$3007.Metal3 3
Rred_279 vdd.$2773.Metal2 vdd.P0.nSD 1012.44892572
Rred_280 vdd.$2773.Metal2 vdd.P11.pSD 12.17227109
Rred_281 vdd.$2775.Metal2 vdd.$2779.Metal2 0.0715792428553
Rred_282 vdd.$2775.Metal2 vdd.$3007.Metal3 6.07074509804
Rred_283 vdd.$2775.Metal2 vdd.$3011.Metal3 3.03537254902
Rred_284 vdd.$2775.Metal2 vdd.$3243.Metal4 514.869179601
Rred_285 vdd.$2775.Metal2 vdd.P0.nSD 1012.44644602
Rred_286 vdd.$2775.Metal2 vdd.P11.pSD 3.92653906129
Rred_287 vdd.$2779.Metal2 vdd.$2781.Metal2 0.0354484492076
Rred_288 vdd.$2779.Metal2 vdd.$3011.Metal3 3.03537254902
Rred_289 vdd.$2779.Metal2 vdd.$3015.Metal3 6.07074509804
Rred_290 vdd.$2779.Metal2 vdd.$3247.Metal4 514.869179601
Rred_291 vdd.$2779.Metal2 vdd.P0.nSD 1012.44644602
Rred_292 vdd.$2779.Metal2 vdd.P13.pSD 3.92653906129
Rred_293 vdd.$2781.Metal2 vdd.$2783.Metal2 0.0353725490196
Rred_294 vdd.$2781.Metal2 vdd.$3015.Metal3 3
Rred_295 vdd.$2781.Metal2 vdd.P0.nSD 1012.44892572
Rred_296 vdd.$2781.Metal2 vdd.P13.pSD 12.17227109
Rred_297 vdd.$2783.Metal2 vdd.$2785.Metal2 0.0354554665712
Rred_298 vdd.$2783.Metal2 vdd.$3015.Metal3 6.07074509804
Rred_299 vdd.$2783.Metal2 vdd.$3019.Metal3 6.07074509804
Rred_300 vdd.$2783.Metal2 vdd.$3251.Metal4 514.869179601
Rred_301 vdd.$2783.Metal2 vdd.P15.pSD 11.0672696184
Rred_302 vdd.$2785.Metal2 vdd.$2789.Metal2 0.0715792428553
Rred_303 vdd.$2785.Metal2 vdd.$3019.Metal3 3
Rred_304 vdd.$2785.Metal2 vdd.$3021.Metal3 6.07074509804
Rred_305 vdd.$2785.Metal2 vdd.P0.nSD 1784.1632144
Rred_306 vdd.$2785.Metal2 vdd.P15.pSD 4.05799886006
Rred_307 vdd.$2789.Metal2 vdd.$2793.Metal2 0.0717460306383
Rred_308 vdd.$2789.Metal2 vdd.$3021.Metal3 3.03537254902
Rred_309 vdd.$2789.Metal2 vdd.$3025.Metal3 3.03890481549
Rred_310 vdd.$2789.Metal2 vdd.$3257.Metal4 514.869179601
Rred_311 vdd.$2789.Metal2 vdd.P0.nSD 2007.29896861
Rred_312 vdd.$2789.Metal2 vdd.P17.pSD 3.34009371786
Rred_313 vdd.$2793.Metal2 vdd.$2795.Metal2 0.0354579968404
Rred_314 vdd.$2793.Metal2 vdd.$3025.Metal3 3.03580313836
Rred_315 vdd.$2793.Metal2 vdd.$3029.Metal3 6.07074509804
Rred_316 vdd.$2793.Metal2 vdd.$3261.Metal4 514.869179601
Rred_317 vdd.$2793.Metal2 vdd.P0.nSD 952.94960424
Rred_318 vdd.$2793.Metal2 vdd.P17.pSD 27.3719249056
Rred_319 vdd.$2793.Metal2 vdd.P19.pSD 10.1462912678
Rred_320 vdd.$2795.Metal2 vdd.$2799.Metal2 0.0715792428553
Rred_321 vdd.$2795.Metal2 vdd.$3029.Metal3 3
Rred_322 vdd.$2795.Metal2 vdd.$3031.Metal3 6.07074509804
Rred_323 vdd.$2795.Metal2 vdd.P0.nSD 934.452661509
Rred_324 vdd.$2795.Metal2 vdd.P19.pSD 4.1984653522
Rred_325 vdd.$2799.Metal2 vdd.$2803.Metal2 0.071729556187
Rred_326 vdd.$2799.Metal2 vdd.$3031.Metal3 3.03537254902
Rred_327 vdd.$2799.Metal2 vdd.$3035.Metal3 3.03855628208
Rred_328 vdd.$2799.Metal2 vdd.$3267.Metal4 514.869179601
Rred_329 vdd.$2799.Metal2 vdd.P0.nSD 2007.30172086
Rred_330 vdd.$2799.Metal2 vdd.P21.pSD 3.29361726219
Rred_331 vdd.$2803.Metal2 vdd.$2805.Metal2 0.0354620166296
Rred_332 vdd.$2803.Metal2 vdd.$3035.Metal3 3.03571283578
Rred_333 vdd.$2803.Metal2 vdd.$3039.Metal3 6.07074509804
Rred_334 vdd.$2803.Metal2 vdd.$3271.Metal4 514.869179601
Rred_335 vdd.$2803.Metal2 vdd.P0.nSD 946.703200702
Rred_336 vdd.$2803.Metal2 vdd.P21.pSD 30.7863446799
Rred_337 vdd.$2803.Metal2 vdd.P23.pSD 9.36686916425
Rred_338 vdd.$2805.Metal2 vdd.$2807.Metal2 0.0354011932647
Rred_339 vdd.$2805.Metal2 vdd.$3039.Metal3 3
Rred_340 vdd.$2805.Metal2 vdd.P0.nSD 940.538103734
Rred_341 vdd.$2805.Metal2 vdd.P23.pSD 4.34890354054
Rred_342 vdd.$2805.Metal2 vdd.P25.pSD 40.5178709535
Rred_343 vdd.$2807.Metal2 vdd.$2809.Metal2 0.0353725490196
Rred_344 vdd.$2807.Metal2 vdd.$3039.Metal3 6.07074509804
Rred_345 vdd.$2807.Metal2 vdd.$3043.Metal3 6.07074509804
Rred_346 vdd.$2807.Metal2 vdd.$3275.Metal4 514.869179601
Rred_347 vdd.$2807.Metal2 vdd.P25.pSD 3.19877928581
Rred_348 vdd.$2809.Metal2 vdd.$3043.Metal3 1.53475662457
Rred_349 vdd.$2809.Metal2 vdd.$3277.Metal4 272.767549995
Rred_350 vdd.$2809.Metal2 vdd.$3496.Metal5 23300.1549081
Rred_351 vdd.$2809.Metal2 vdd.P0.nSD 2007.30263827
Rred_352 vdd.$2979.Metal3 vdd.$2983.Metal3 0.0715792428553
Rred_353 vdd.$2979.Metal3 vdd.$3213.Metal4 1.53469498509
Rred_354 vdd.$2979.Metal3 vdd.$3215.Metal4 6.07074509804
Rred_355 vdd.$2979.Metal3 vdd.$3480.Metal5 268.399312003
Rred_356 vdd.$2983.Metal3 vdd.$2987.Metal3 0.0715792428553
Rred_357 vdd.$2983.Metal3 vdd.$3215.Metal4 3.03537254902
Rred_358 vdd.$2983.Metal3 vdd.$3219.Metal4 3.03537254902
Rred_359 vdd.$2983.Metal3 vdd.$3448.Metal5 514.869179601
Rred_360 vdd.$2987.Metal3 vdd.$2991.Metal3 0.0715792428553
Rred_361 vdd.$2987.Metal3 vdd.$3219.Metal4 3.03537254902
Rred_362 vdd.$2987.Metal3 vdd.$3223.Metal4 3.03537254902
Rred_363 vdd.$2987.Metal3 vdd.$3450.Metal5 514.869179601
Rred_364 vdd.$2987.Metal3 vdd.P3.pSD 2611.03699336
Rred_365 vdd.$2991.Metal3 vdd.$2993.Metal3 0.0353725490196
Rred_366 vdd.$2991.Metal3 vdd.$3223.Metal4 6.07074509804
Rred_367 vdd.$2991.Metal3 vdd.$3225.Metal4 3
Rred_368 vdd.$2993.Metal3 vdd.$2997.Metal3 0.0715792428553
Rred_369 vdd.$2993.Metal3 vdd.$3225.Metal4 6.07074509804
Rred_370 vdd.$2993.Metal3 vdd.$3229.Metal4 3.03537254902
Rred_371 vdd.$2993.Metal3 vdd.$3453.Metal5 514.869179601
Rred_372 vdd.$2997.Metal3 vdd.$3001.Metal3 0.0715792428553
Rred_373 vdd.$2997.Metal3 vdd.$3229.Metal4 3.03537254902
Rred_374 vdd.$2997.Metal3 vdd.$3233.Metal4 3.03537254902
Rred_375 vdd.$2997.Metal3 vdd.$3455.Metal5 514.869179601
Rred_376 vdd.$2997.Metal3 vdd.P7.pSD 2321.45482847
Rred_377 vdd.$3001.Metal3 vdd.$3003.Metal3 0.0353725490196
Rred_378 vdd.$3001.Metal3 vdd.$3233.Metal4 6.07074509804
Rred_379 vdd.$3001.Metal3 vdd.$3235.Metal4 3
Rred_380 vdd.$3003.Metal3 vdd.$3007.Metal3 0.0715792428553
Rred_381 vdd.$3003.Metal3 vdd.$3235.Metal4 6.07074509804
Rred_382 vdd.$3003.Metal3 vdd.$3239.Metal4 3.03537254902
Rred_383 vdd.$3003.Metal3 vdd.$3458.Metal5 514.869179601
Rred_384 vdd.$3007.Metal3 vdd.$3011.Metal3 0.0715792428553
Rred_385 vdd.$3007.Metal3 vdd.$3239.Metal4 3.03537254902
Rred_386 vdd.$3007.Metal3 vdd.$3243.Metal4 3.03537254902
Rred_387 vdd.$3007.Metal3 vdd.$3460.Metal5 514.869179601
Rred_388 vdd.$3011.Metal3 vdd.$3015.Metal3 0.0715792428553
Rred_389 vdd.$3011.Metal3 vdd.$3243.Metal4 3.03537254902
Rred_390 vdd.$3011.Metal3 vdd.$3247.Metal4 3.03537254902
Rred_391 vdd.$3011.Metal3 vdd.$3462.Metal5 514.869179601
Rred_392 vdd.$3015.Metal3 vdd.$3019.Metal3 0.0715792428553
Rred_393 vdd.$3015.Metal3 vdd.$3247.Metal4 3.03537254902
Rred_394 vdd.$3015.Metal3 vdd.$3251.Metal4 3.03537254902
Rred_395 vdd.$3015.Metal3 vdd.$3464.Metal5 514.869179601
Rred_396 vdd.$3019.Metal3 vdd.$3021.Metal3 0.0353725490196
Rred_397 vdd.$3019.Metal3 vdd.$3251.Metal4 3.03537254902
Rred_398 vdd.$3019.Metal3 vdd.$3255.Metal4 6.07074509804
Rred_399 vdd.$3019.Metal3 vdd.$3466.Metal5 514.869179601
Rred_400 vdd.$3021.Metal3 vdd.$3025.Metal3 0.0715792428553
Rred_401 vdd.$3021.Metal3 vdd.$3255.Metal4 3
Rred_402 vdd.$3021.Metal3 vdd.$3257.Metal4 6.07074509804
Rred_403 vdd.$3025.Metal3 vdd.$3029.Metal3 0.0715792428553
Rred_404 vdd.$3025.Metal3 vdd.$3257.Metal4 3.03537254902
Rred_405 vdd.$3025.Metal3 vdd.$3261.Metal4 3.03537254902
Rred_406 vdd.$3025.Metal3 vdd.$3469.Metal5 514.869179601
Rred_407 vdd.$3025.Metal3 vdd.P17.pSD 2321.45482847
Rred_408 vdd.$3029.Metal3 vdd.$3031.Metal3 0.0353725490196
Rred_409 vdd.$3029.Metal3 vdd.$3261.Metal4 3.03537254902
Rred_410 vdd.$3029.Metal3 vdd.$3265.Metal4 6.07074509804
Rred_411 vdd.$3029.Metal3 vdd.$3471.Metal5 514.869179601
Rred_412 vdd.$3031.Metal3 vdd.$3035.Metal3 0.0715792428553
Rred_413 vdd.$3031.Metal3 vdd.$3265.Metal4 3
Rred_414 vdd.$3031.Metal3 vdd.$3267.Metal4 6.07074509804
Rred_415 vdd.$3035.Metal3 vdd.$3039.Metal3 0.0715792428553
Rred_416 vdd.$3035.Metal3 vdd.$3267.Metal4 3.03537254902
Rred_417 vdd.$3035.Metal3 vdd.$3271.Metal4 3.03537254902
Rred_418 vdd.$3035.Metal3 vdd.$3474.Metal5 514.869179601
Rred_419 vdd.$3035.Metal3 vdd.P21.pSD 2611.03699336
Rred_420 vdd.$3039.Metal3 vdd.$3043.Metal3 0.0715792428553
Rred_421 vdd.$3039.Metal3 vdd.$3271.Metal4 3.03537254902
Rred_422 vdd.$3039.Metal3 vdd.$3275.Metal4 3.03537254902
Rred_423 vdd.$3039.Metal3 vdd.$3476.Metal5 514.869179601
Rred_424 vdd.$3043.Metal3 vdd.$3275.Metal4 6.07074509804
Rred_425 vdd.$3043.Metal3 vdd.$3277.Metal4 1.53469498509
Rred_426 vdd.$3043.Metal3 vdd.$3496.Metal5 268.399312003
Rred_427 vdd.$3213.Metal4 vdd.$3215.Metal4 0.0353717555374
Rred_428 vdd.$3213.Metal4 vdd.$3448.Metal5 18.6594179657
Rred_429 vdd.$3213.Metal4 vdd.$3480.Metal5 1.66407488816
Rred_430 vdd.$3213.Metal4 vdd.$3700.TopMetal1 3399.35651447
Rred_431 vdd.$3215.Metal4 vdd.$3219.Metal4 0.0715792428553
Rred_432 vdd.$3215.Metal4 vdd.$3448.Metal5 2.80679160091
Rred_433 vdd.$3215.Metal4 vdd.$3480.Metal5 7.25548899731
Rred_434 vdd.$3215.Metal4 vdd.$3700.TopMetal1 951.057610429
Rred_435 vdd.$3219.Metal4 vdd.$3223.Metal4 0.0715792428553
Rred_436 vdd.$3219.Metal4 vdd.$3448.Metal5 3.02753881799
Rred_437 vdd.$3219.Metal4 vdd.$3450.Metal5 3.03258210865
Rred_438 vdd.$3219.Metal4 vdd.$3615.TopMetal1 1287.66363749
Rred_439 vdd.$3223.Metal4 vdd.$3225.Metal4 0.0353725490196
Rred_440 vdd.$3223.Metal4 vdd.$3450.Metal5 3.02722132926
Rred_441 vdd.$3223.Metal4 vdd.$3452.Metal5 6.05609398453
Rred_442 vdd.$3223.Metal4 vdd.$3615.TopMetal1 3095.07962723
Rred_443 vdd.$3223.Metal4 vdd.$3617.TopMetal1 3095.07962723
Rred_444 vdd.$3225.Metal4 vdd.$3229.Metal4 0.0715792428553
Rred_445 vdd.$3225.Metal4 vdd.$3452.Metal5 3
Rred_446 vdd.$3225.Metal4 vdd.$3453.Metal5 6.07074509804
Rred_447 vdd.$3229.Metal4 vdd.$3233.Metal4 0.0715792428553
Rred_448 vdd.$3229.Metal4 vdd.$3453.Metal5 3.03814891291
Rred_449 vdd.$3229.Metal4 vdd.$3455.Metal5 3.03432142296
Rred_450 vdd.$3229.Metal4 vdd.$3617.TopMetal1 469.961964784
Rred_451 vdd.$3233.Metal4 vdd.$3235.Metal4 0.0353725490196
Rred_452 vdd.$3233.Metal4 vdd.$3455.Metal5 6.07074509804
Rred_453 vdd.$3233.Metal4 vdd.$3456.Metal5 3
Rred_454 vdd.$3235.Metal4 vdd.$3239.Metal4 0.0715792428553
Rred_455 vdd.$3235.Metal4 vdd.$3456.Metal5 6.03583101049
Rred_456 vdd.$3235.Metal4 vdd.$3458.Metal5 3.02876574442
Rred_457 vdd.$3235.Metal4 vdd.$3619.TopMetal1 3853.28923864
Rred_458 vdd.$3239.Metal4 vdd.$3243.Metal4 0.0715792428553
Rred_459 vdd.$3239.Metal4 vdd.$3458.Metal5 3.02653241378
Rred_460 vdd.$3239.Metal4 vdd.$3460.Metal5 3.0276642599
Rred_461 vdd.$3239.Metal4 vdd.$3620.TopMetal1 7700.98730559
Rred_462 vdd.$3243.Metal4 vdd.$3247.Metal4 0.0715792428553
Rred_463 vdd.$3243.Metal4 vdd.$3460.Metal5 3.02650357323
Rred_464 vdd.$3243.Metal4 vdd.$3462.Metal5 3.02650357323
Rred_465 vdd.$3247.Metal4 vdd.$3251.Metal4 0.0715792428553
Rred_466 vdd.$3247.Metal4 vdd.$3462.Metal5 3.02650357323
Rred_467 vdd.$3247.Metal4 vdd.$3464.Metal5 3.02650357323
Rred_468 vdd.$3251.Metal4 vdd.$3255.Metal4 0.0715792428553
Rred_469 vdd.$3251.Metal4 vdd.$3464.Metal5 3.0276642599
Rred_470 vdd.$3251.Metal4 vdd.$3466.Metal5 3.02653241378
Rred_471 vdd.$3251.Metal4 vdd.$3622.TopMetal1 7700.98730559
Rred_472 vdd.$3255.Metal4 vdd.$3257.Metal4 0.0353725490196
Rred_473 vdd.$3255.Metal4 vdd.$3466.Metal5 3.02876574442
Rred_474 vdd.$3255.Metal4 vdd.$3468.Metal5 6.03583101049
Rred_475 vdd.$3255.Metal4 vdd.$3623.TopMetal1 3853.28923864
Rred_476 vdd.$3257.Metal4 vdd.$3261.Metal4 0.0715792428553
Rred_477 vdd.$3257.Metal4 vdd.$3468.Metal5 3
Rred_478 vdd.$3257.Metal4 vdd.$3469.Metal5 6.07074509804
Rred_479 vdd.$3261.Metal4 vdd.$3265.Metal4 0.0715792428553
Rred_480 vdd.$3261.Metal4 vdd.$3469.Metal5 3.03432142296
Rred_481 vdd.$3261.Metal4 vdd.$3471.Metal5 3.03814891291
Rred_482 vdd.$3261.Metal4 vdd.$3625.TopMetal1 469.961964784
Rred_483 vdd.$3265.Metal4 vdd.$3267.Metal4 0.0353725490196
Rred_484 vdd.$3265.Metal4 vdd.$3471.Metal5 6.07074509804
Rred_485 vdd.$3265.Metal4 vdd.$3472.Metal5 3
Rred_486 vdd.$3267.Metal4 vdd.$3271.Metal4 0.0715792428553
Rred_487 vdd.$3267.Metal4 vdd.$3472.Metal5 6.05609398453
Rred_488 vdd.$3267.Metal4 vdd.$3474.Metal5 3.02722132926
Rred_489 vdd.$3267.Metal4 vdd.$3625.TopMetal1 3095.07962723
Rred_490 vdd.$3267.Metal4 vdd.$3627.TopMetal1 3095.07962723
Rred_491 vdd.$3271.Metal4 vdd.$3275.Metal4 0.0715792428553
Rred_492 vdd.$3271.Metal4 vdd.$3474.Metal5 3.03258210865
Rred_493 vdd.$3271.Metal4 vdd.$3476.Metal5 3.02753881799
Rred_494 vdd.$3271.Metal4 vdd.$3627.TopMetal1 1287.66363749
Rred_495 vdd.$3275.Metal4 vdd.$3277.Metal4 0.0353717555374
Rred_496 vdd.$3275.Metal4 vdd.$3476.Metal5 2.80679160091
Rred_497 vdd.$3275.Metal4 vdd.$3496.Metal5 7.25548899731
Rred_498 vdd.$3275.Metal4 vdd.$3707.TopMetal1 951.057610429
Rred_499 vdd.$3277.Metal4 vdd.$3476.Metal5 18.6594179657
Rred_500 vdd.$3277.Metal4 vdd.$3496.Metal5 1.66407488816
Rred_501 vdd.$3277.Metal4 vdd.$3707.TopMetal1 3399.35651447
Rred_502 vdd.$3448.Metal5 vdd.$3450.Metal5 0.0714477570792
Rred_503 vdd.$3448.Metal5 vdd.$3480.Metal5 0.0858574305423
Rred_504 vdd.$3448.Metal5 vdd.$3615.TopMetal1 15.1826483793
Rred_505 vdd.$3448.Metal5 vdd.$3700.TopMetal1 2.58363226543
Rred_506 vdd.$3450.Metal5 vdd.$3452.Metal5 0.0714064937784
Rred_507 vdd.$3450.Metal5 vdd.$3615.TopMetal1 2.41844190391
Rred_508 vdd.$3450.Metal5 vdd.$3617.TopMetal1 36.4936186112
Rred_509 vdd.$3452.Metal5 vdd.$3453.Metal5 0.0353725490196
Rred_510 vdd.$3452.Metal5 vdd.$3615.TopMetal1 5.04295698518
Rred_511 vdd.$3452.Metal5 vdd.$3617.TopMetal1 5.04295698518
Rred_512 vdd.$3453.Metal5 vdd.$3455.Metal5 0.0717103054915
Rred_513 vdd.$3453.Metal5 vdd.$3617.TopMetal1 3.7246926668
Rred_514 vdd.$3455.Metal5 vdd.$3456.Metal5 0.0354434500539
Rred_515 vdd.$3455.Metal5 vdd.$3617.TopMetal1 4.68190758701
Rred_516 vdd.$3455.Metal5 vdd.$3619.TopMetal1 30.1900588235
Rred_517 vdd.$3456.Metal5 vdd.$3458.Metal5 0.0712683202513
Rred_518 vdd.$3456.Metal5 vdd.$3617.TopMetal1 5.17543865546
Rred_519 vdd.$3456.Metal5 vdd.$3619.TopMetal1 4.64618162452
Rred_520 vdd.$3458.Metal5 vdd.$3460.Metal5 0.0712166146317
Rred_521 vdd.$3458.Metal5 vdd.$3619.TopMetal1 2.3169668379
Rred_522 vdd.$3458.Metal5 vdd.$3620.TopMetal1 90.8011836554
Rred_523 vdd.$3460.Metal5 vdd.$3462.Metal5 0.0711621704472
Rred_524 vdd.$3460.Metal5 vdd.$3620.TopMetal1 2.2570559453
Rred_525 vdd.$3462.Metal5 vdd.$3464.Metal5 0.0711621704472
Rred_526 vdd.$3462.Metal5 vdd.$3620.TopMetal1 4.4092195122
Rred_527 vdd.$3462.Metal5 vdd.$3622.TopMetal1 4.4092195122
Rred_528 vdd.$3464.Metal5 vdd.$3466.Metal5 0.0712166146317
Rred_529 vdd.$3464.Metal5 vdd.$3622.TopMetal1 2.2570559453
Rred_530 vdd.$3466.Metal5 vdd.$3468.Metal5 0.0712683202513
Rred_531 vdd.$3466.Metal5 vdd.$3622.TopMetal1 90.8011836554
Rred_532 vdd.$3466.Metal5 vdd.$3623.TopMetal1 2.3169668379
Rred_533 vdd.$3468.Metal5 vdd.$3469.Metal5 0.0354434500539
Rred_534 vdd.$3468.Metal5 vdd.$3623.TopMetal1 4.64618162452
Rred_535 vdd.$3468.Metal5 vdd.$3625.TopMetal1 5.17543865546
Rred_536 vdd.$3469.Metal5 vdd.$3471.Metal5 0.0717103054915
Rred_537 vdd.$3469.Metal5 vdd.$3623.TopMetal1 30.1900588235
Rred_538 vdd.$3469.Metal5 vdd.$3625.TopMetal1 4.68190758701
Rred_539 vdd.$3471.Metal5 vdd.$3472.Metal5 0.0353725490196
Rred_540 vdd.$3471.Metal5 vdd.$3625.TopMetal1 3.7246926668
Rred_541 vdd.$3472.Metal5 vdd.$3474.Metal5 0.0714064937784
Rred_542 vdd.$3472.Metal5 vdd.$3625.TopMetal1 5.04295698518
Rred_543 vdd.$3472.Metal5 vdd.$3627.TopMetal1 5.04295698518
Rred_544 vdd.$3474.Metal5 vdd.$3476.Metal5 0.0714477570792
Rred_545 vdd.$3474.Metal5 vdd.$3625.TopMetal1 36.4936186112
Rred_546 vdd.$3474.Metal5 vdd.$3627.TopMetal1 2.41844190391
Rred_547 vdd.$3476.Metal5 vdd.$3496.Metal5 0.0858574305423
Rred_548 vdd.$3476.Metal5 vdd.$3627.TopMetal1 15.1826483793
Rred_549 vdd.$3476.Metal5 vdd.$3707.TopMetal1 2.58363226543
Rred_550 vdd.$3480.Metal5 vdd.$3700.TopMetal1 1.93614145079
Rred_551 vdd.$3496.Metal5 vdd.$3707.TopMetal1 1.93614145079
Rred_552 vdd.$3615.TopMetal1 vdd.$3617.TopMetal1 0.0184775280108
Rred_553 vdd.$3615.TopMetal1 vdd.$3700.TopMetal1 0.009
Rred_554 vdd.$3617.TopMetal1 vdd.$3619.TopMetal1 0.0184775830343
Rred_555 vdd.$3619.TopMetal1 vdd.$3620.TopMetal1 0.00921951219512
Rred_556 vdd.$3620.TopMetal1 vdd.$3622.TopMetal1 0.0184776604835
Rred_557 vdd.$3622.TopMetal1 vdd.$3623.TopMetal1 0.00921951219512
Rred_558 vdd.$3623.TopMetal1 vdd.$3625.TopMetal1 0.0184775830343
Rred_559 vdd.$3625.TopMetal1 vdd.$3627.TopMetal1 0.0184775280108
Rred_560 vdd.$3627.TopMetal1 vdd.$3707.TopMetal1 0.009
Rred_561 vdd.$3700.TopMetal1 vdd.$4071.TopMetal1 0.00899136340388
Rred_562 vdd.$3700.TopMetal1 vdd.$4456.TopMetal1 167.668491556
Rred_563 vdd.$3700.TopMetal1 vdd.$4841.TopMetal1 3126636.28394
Rred_564 vdd.$3700.TopMetal1 vdd.$5226.TopMetal1 58301533884.3
Rred_565 vdd.$3707.TopMetal1 vdd.$4071.TopMetal1 0.00899136340388
Rred_566 vdd.$3707.TopMetal1 vdd.$4456.TopMetal1 167.668491556
Rred_567 vdd.$3707.TopMetal1 vdd.$4841.TopMetal1 3126636.28394
Rred_568 vdd.$3707.TopMetal1 vdd.$5226.TopMetal1 58301533884.3
Rred_569 vdd.$4071.TopMetal1 vdd.$4456.TopMetal1 0.00299730869958
Rred_570 vdd.$4071.TopMetal1 vdd.$4841.TopMetal1 55.8929948454
Rred_571 vdd.$4071.TopMetal1 vdd.$5226.TopMetal1 1042221.42806
Rred_572 vdd.$4071.TopMetal1 vdd.P0.GatPoly 10.8655515784
Rred_573 vdd.$4456.TopMetal1 vdd.$4841.TopMetal1 0.00299728186638
Rred_574 vdd.$4456.TopMetal1 vdd.$5226.TopMetal1 55.8894973461
Rred_575 vdd.$4456.TopMetal1 vdd.P0.GatPoly 202617.841281
Rred_576 vdd.$4841.TopMetal1 vdd.$5226.TopMetal1 0.00299712114325
Rred_577 vdd.$4841.TopMetal1 vdd.P0.GatPoly 3778362222.05
Rred_578 vdd.$5226.TopMetal1 vdd.P0.GatPoly 7.04540896705e+13
Rred_579 vdd.P0.nSD vdd.P1.GatPoly 201.533027723
Rred_580 vdd.P0.nSD vdd.P2.GatPoly 201.533027723
Rred_581 vdd.P1.GatPoly vdd.P2.GatPoly 5654936.26119
Rred_582 vout vout.$1299.Metal4 0.135310918038
Rred_583 vout vout.$1313.Metal4 0.0972664728524
Rred_584 vout vout.P0.GatPoly 13.9567379693
Rred_585 vout.$1002.Metal3 vout.$1042.Metal3 0.368032035556
Rred_586 vout.$1002.Metal3 vout.$1313.Metal4 9.3573229307
Rred_587 vout.$1002.Metal3 vout.$1323.Metal4 9
Rred_588 vout.$1002.Metal3 vout.$1333.Metal4 18.3608
Rred_589 vout.$1002.Metal3 vout.$161.Metal1 488.591993839
Rred_590 vout.$1002.Metal3 vout.$594.Metal2 4.67567670365
Rred_591 vout.$1002.Metal3 vout.$614.Metal2 18.3608
Rred_592 vout.$1004.Metal3 vout.$1044.Metal3 0.368032035556
Rred_593 vout.$1004.Metal3 vout.$1313.Metal4 9.3573229307
Rred_594 vout.$1004.Metal3 vout.$1323.Metal4 9
Rred_595 vout.$1004.Metal3 vout.$1333.Metal4 18.3608
Rred_596 vout.$1004.Metal3 vout.$162.Metal1 488.591993839
Rred_597 vout.$1004.Metal3 vout.$596.Metal2 4.67567670365
Rred_598 vout.$1004.Metal3 vout.$616.Metal2 18.3608
Rred_599 vout.$1006.Metal3 vout.$1046.Metal3 0.368032035556
Rred_600 vout.$1006.Metal3 vout.$1313.Metal4 9.3573229307
Rred_601 vout.$1006.Metal3 vout.$1323.Metal4 9
Rred_602 vout.$1006.Metal3 vout.$1333.Metal4 18.3608
Rred_603 vout.$1006.Metal3 vout.$163.Metal1 488.591993839
Rred_604 vout.$1006.Metal3 vout.$598.Metal2 4.67567670365
Rred_605 vout.$1006.Metal3 vout.$618.Metal2 18.3608
Rred_606 vout.$1008.Metal3 vout.$1048.Metal3 0.368032035556
Rred_607 vout.$1008.Metal3 vout.$1313.Metal4 9.3573229307
Rred_608 vout.$1008.Metal3 vout.$1323.Metal4 9
Rred_609 vout.$1008.Metal3 vout.$1333.Metal4 18.3608
Rred_610 vout.$1008.Metal3 vout.$164.Metal1 488.591993839
Rred_611 vout.$1008.Metal3 vout.$600.Metal2 4.67567670365
Rred_612 vout.$1008.Metal3 vout.$620.Metal2 18.3608
Rred_613 vout.$1010.Metal3 vout.$1050.Metal3 0.368032035556
Rred_614 vout.$1010.Metal3 vout.$1313.Metal4 9.3573229307
Rred_615 vout.$1010.Metal3 vout.$1323.Metal4 9
Rred_616 vout.$1010.Metal3 vout.$1333.Metal4 18.3608
Rred_617 vout.$1010.Metal3 vout.$165.Metal1 488.591993839
Rred_618 vout.$1010.Metal3 vout.$602.Metal2 4.67567670365
Rred_619 vout.$1010.Metal3 vout.$622.Metal2 18.3608
Rred_620 vout.$1032.Metal3 vout.$1072.Metal3 0.367747910173
Rred_621 vout.$1032.Metal3 vout.$1328.Metal4 2.62243923231
Rred_622 vout.$1032.Metal3 vout.$1368.Metal4 19.0026802939
Rred_623 vout.$1032.Metal3 vout.$156.Metal1 583.731950859
Rred_624 vout.$1032.Metal3 vout.$206.Metal1 1015.0040217
Rred_625 vout.$1032.Metal3 vout.$226.Metal1 9570.03791892
Rred_626 vout.$1032.Metal3 vout.$584.Metal2 5.58937337602
Rred_627 vout.$1032.Metal3 vout.$604.Metal2 6.47396180006
Rred_628 vout.$1032.Metal3 vout.$644.Metal2 9.17855300614
Rred_629 vout.$1034.Metal3 vout.$1074.Metal3 0.367749602447
Rred_630 vout.$1034.Metal3 vout.$1329.Metal4 2.62349441415
Rred_631 vout.$1034.Metal3 vout.$1369.Metal4 18.9407505429
Rred_632 vout.$1034.Metal3 vout.$157.Metal1 583.731950859
Rred_633 vout.$1034.Metal3 vout.$207.Metal1 1015.0040217
Rred_634 vout.$1034.Metal3 vout.$227.Metal1 9570.03791892
Rred_635 vout.$1034.Metal3 vout.$586.Metal2 5.58937337602
Rred_636 vout.$1034.Metal3 vout.$606.Metal2 6.47396180006
Rred_637 vout.$1034.Metal3 vout.$646.Metal2 9.17855814646
Rred_638 vout.$1036.Metal3 vout.$1076.Metal3 0.367749602447
Rred_639 vout.$1036.Metal3 vout.$1330.Metal4 2.62349441415
Rred_640 vout.$1036.Metal3 vout.$1370.Metal4 18.9407505429
Rred_641 vout.$1036.Metal3 vout.$158.Metal1 583.731950859
Rred_642 vout.$1036.Metal3 vout.$208.Metal1 1015.0040217
Rred_643 vout.$1036.Metal3 vout.$228.Metal1 9570.03791892
Rred_644 vout.$1036.Metal3 vout.$588.Metal2 5.58937337602
Rred_645 vout.$1036.Metal3 vout.$608.Metal2 6.47396180006
Rred_646 vout.$1036.Metal3 vout.$648.Metal2 9.17855814646
Rred_647 vout.$1038.Metal3 vout.$1078.Metal3 0.367749602447
Rred_648 vout.$1038.Metal3 vout.$1331.Metal4 2.62349441415
Rred_649 vout.$1038.Metal3 vout.$1371.Metal4 18.9407505429
Rred_650 vout.$1038.Metal3 vout.$159.Metal1 583.731950859
Rred_651 vout.$1038.Metal3 vout.$209.Metal1 1015.0040217
Rred_652 vout.$1038.Metal3 vout.$229.Metal1 9570.03791892
Rred_653 vout.$1038.Metal3 vout.$590.Metal2 5.58937337602
Rred_654 vout.$1038.Metal3 vout.$610.Metal2 6.47396180006
Rred_655 vout.$1038.Metal3 vout.$650.Metal2 9.17855814646
Rred_656 vout.$1040.Metal3 vout.$1080.Metal3 0.367749602447
Rred_657 vout.$1040.Metal3 vout.$1332.Metal4 2.62349441415
Rred_658 vout.$1040.Metal3 vout.$1372.Metal4 18.9407505429
Rred_659 vout.$1040.Metal3 vout.$160.Metal1 583.731950859
Rred_660 vout.$1040.Metal3 vout.$210.Metal1 1015.0040217
Rred_661 vout.$1040.Metal3 vout.$230.Metal1 9570.03791892
Rred_662 vout.$1040.Metal3 vout.$592.Metal2 5.58937337602
Rred_663 vout.$1040.Metal3 vout.$612.Metal2 6.47396180006
Rred_664 vout.$1040.Metal3 vout.$652.Metal2 9.17855814646
Rred_665 vout.$1042.Metal3 vout.$1082.Metal3 0.368032035556
Rred_666 vout.$1042.Metal3 vout.$1333.Metal4 18.3608
Rred_667 vout.$1042.Metal3 vout.$1343.Metal4 9
Rred_668 vout.$1042.Metal3 vout.$1353.Metal4 18.3608
Rred_669 vout.$1042.Metal3 vout.$614.Metal2 18.3608
Rred_670 vout.$1042.Metal3 vout.$634.Metal2 9
Rred_671 vout.$1042.Metal3 vout.$654.Metal2 18.3608
Rred_672 vout.$1044.Metal3 vout.$1084.Metal3 0.368032035556
Rred_673 vout.$1044.Metal3 vout.$1333.Metal4 18.3608
Rred_674 vout.$1044.Metal3 vout.$1343.Metal4 9
Rred_675 vout.$1044.Metal3 vout.$1353.Metal4 18.3608
Rred_676 vout.$1044.Metal3 vout.$212.Metal1 1015.0040217
Rred_677 vout.$1044.Metal3 vout.$232.Metal1 9570.03791892
Rred_678 vout.$1044.Metal3 vout.$616.Metal2 9.18031709106
Rred_679 vout.$1044.Metal3 vout.$656.Metal2 9.18031709106
Rred_680 vout.$1046.Metal3 vout.$1066.Metal3 0.1804
Rred_681 vout.$1046.Metal3 vout.$1333.Metal4 18.3608
Rred_682 vout.$1046.Metal3 vout.$1343.Metal4 9
Rred_683 vout.$1046.Metal3 vout.$213.Metal1 1015.0040217
Rred_684 vout.$1046.Metal3 vout.$233.Metal1 9570.03791892
Rred_685 vout.$1046.Metal3 vout.$618.Metal2 9.18031709106
Rred_686 vout.$1046.Metal3 vout.$658.Metal2 18.3604683672
Rred_687 vout.$1048.Metal3 vout.$1088.Metal3 0.368032035556
Rred_688 vout.$1048.Metal3 vout.$1333.Metal4 18.3608
Rred_689 vout.$1048.Metal3 vout.$1343.Metal4 9
Rred_690 vout.$1048.Metal3 vout.$1353.Metal4 18.3608
Rred_691 vout.$1048.Metal3 vout.$214.Metal1 1015.0040217
Rred_692 vout.$1048.Metal3 vout.$234.Metal1 9570.03791892
Rred_693 vout.$1048.Metal3 vout.$620.Metal2 9.18031709106
Rred_694 vout.$1048.Metal3 vout.$660.Metal2 9.18031709106
Rred_695 vout.$1050.Metal3 vout.$1070.Metal3 0.1804
Rred_696 vout.$1050.Metal3 vout.$1333.Metal4 18.3608
Rred_697 vout.$1050.Metal3 vout.$1343.Metal4 9
Rred_698 vout.$1050.Metal3 vout.$215.Metal1 1015.0040217
Rred_699 vout.$1050.Metal3 vout.$235.Metal1 9570.03791892
Rred_700 vout.$1050.Metal3 vout.$622.Metal2 9.18031709106
Rred_701 vout.$1050.Metal3 vout.$662.Metal2 18.3604683672
Rred_702 vout.$1066.Metal3 vout.$1106.Metal3 0.368032035556
Rred_703 vout.$1066.Metal3 vout.$1353.Metal4 9
Rred_704 vout.$1066.Metal3 vout.$1363.Metal4 18.3608
Rred_705 vout.$1066.Metal3 vout.$658.Metal2 9
Rred_706 vout.$1066.Metal3 vout.$678.Metal2 18.3608
Rred_707 vout.$1070.Metal3 vout.$1110.Metal3 0.368032035556
Rred_708 vout.$1070.Metal3 vout.$1353.Metal4 9
Rred_709 vout.$1070.Metal3 vout.$1363.Metal4 18.3608
Rred_710 vout.$1070.Metal3 vout.$662.Metal2 9
Rred_711 vout.$1070.Metal3 vout.$682.Metal2 18.3608
Rred_712 vout.$1072.Metal3 vout.$1112.Metal3 0.368032035556
Rred_713 vout.$1072.Metal3 vout.$1328.Metal4 19.0025127797
Rred_714 vout.$1072.Metal3 vout.$1368.Metal4 6.16933091943
Rred_715 vout.$1072.Metal3 vout.$644.Metal2 18.3537448681
Rred_716 vout.$1072.Metal3 vout.$664.Metal2 9
Rred_717 vout.$1072.Metal3 vout.$684.Metal2 18.3608
Rred_718 vout.$1074.Metal3 vout.$1114.Metal3 0.368032035556
Rred_719 vout.$1074.Metal3 vout.$1329.Metal4 19.1164594026
Rred_720 vout.$1074.Metal3 vout.$1369.Metal4 6.15596610874
Rred_721 vout.$1074.Metal3 vout.$646.Metal2 18.3537869052
Rred_722 vout.$1074.Metal3 vout.$666.Metal2 9
Rred_723 vout.$1074.Metal3 vout.$686.Metal2 18.3608
Rred_724 vout.$1076.Metal3 vout.$1116.Metal3 0.368032035556
Rred_725 vout.$1076.Metal3 vout.$1330.Metal4 19.1164594026
Rred_726 vout.$1076.Metal3 vout.$1370.Metal4 6.15596610874
Rred_727 vout.$1076.Metal3 vout.$648.Metal2 18.3537869052
Rred_728 vout.$1076.Metal3 vout.$668.Metal2 9
Rred_729 vout.$1076.Metal3 vout.$688.Metal2 18.3608
Rred_730 vout.$1078.Metal3 vout.$1118.Metal3 0.368032035556
Rred_731 vout.$1078.Metal3 vout.$1331.Metal4 19.1164594026
Rred_732 vout.$1078.Metal3 vout.$1371.Metal4 6.15596610874
Rred_733 vout.$1078.Metal3 vout.$650.Metal2 18.3537869052
Rred_734 vout.$1078.Metal3 vout.$670.Metal2 9
Rred_735 vout.$1078.Metal3 vout.$690.Metal2 18.3608
Rred_736 vout.$1080.Metal3 vout.$1100.Metal3 0.1804
Rred_737 vout.$1080.Metal3 vout.$1332.Metal4 19.1164594026
Rred_738 vout.$1080.Metal3 vout.$1372.Metal4 9.26095869361
Rred_739 vout.$1080.Metal3 vout.$652.Metal2 18.3537869052
Rred_740 vout.$1080.Metal3 vout.$672.Metal2 9
Rred_741 vout.$1082.Metal3 vout.$1122.Metal3 0.368032035556
Rred_742 vout.$1082.Metal3 vout.$1353.Metal4 18.3608
Rred_743 vout.$1082.Metal3 vout.$1363.Metal4 9
Rred_744 vout.$1082.Metal3 vout.$1373.Metal4 18.3608
Rred_745 vout.$1082.Metal3 vout.$654.Metal2 18.3608
Rred_746 vout.$1082.Metal3 vout.$674.Metal2 9
Rred_747 vout.$1082.Metal3 vout.$694.Metal2 18.3608
Rred_748 vout.$1084.Metal3 vout.$1124.Metal3 0.368032035556
Rred_749 vout.$1084.Metal3 vout.$1353.Metal4 18.3608
Rred_750 vout.$1084.Metal3 vout.$1363.Metal4 9
Rred_751 vout.$1084.Metal3 vout.$1373.Metal4 18.3608
Rred_752 vout.$1084.Metal3 vout.$656.Metal2 18.3608
Rred_753 vout.$1084.Metal3 vout.$676.Metal2 9
Rred_754 vout.$1084.Metal3 vout.$696.Metal2 18.3608
Rred_755 vout.$1088.Metal3 vout.$1128.Metal3 0.368032035556
Rred_756 vout.$1088.Metal3 vout.$1353.Metal4 18.3608
Rred_757 vout.$1088.Metal3 vout.$1363.Metal4 9
Rred_758 vout.$1088.Metal3 vout.$1373.Metal4 18.3608
Rred_759 vout.$1088.Metal3 vout.$660.Metal2 18.3608
Rred_760 vout.$1088.Metal3 vout.$680.Metal2 9
Rred_761 vout.$1088.Metal3 vout.$700.Metal2 18.3608
Rred_762 vout.$11.Metal1 vout.$1235.Metal4 10183.3879352
Rred_763 vout.$11.Metal1 vout.$1264.Metal4 82954.0323074
Rred_764 vout.$11.Metal1 vout.$436.Metal2 5.34064323046
Rred_765 vout.$11.Metal1 vout.$456.Metal2 25.1436636536
Rred_766 vout.$11.Metal1 vout.$61.Metal1 0.600729620506
Rred_767 vout.$11.Metal1 vout.$864.Metal3 526.040795624
Rred_768 vout.$11.Metal1 vout.P0.nSD 8.65123602902
Rred_769 vout.$1100.Metal3 vout.$1160.Metal3 0.570418066492
Rred_770 vout.$1100.Metal3 vout.$1372.Metal4 4.5884275195
Rred_771 vout.$1100.Metal3 vout.$270.Metal1 1816.75394379
Rred_772 vout.$1100.Metal3 vout.$290.Metal1 1867.21933112
Rred_773 vout.$1100.Metal3 vout.$672.Metal2 18.3598471625
Rred_774 vout.$1100.Metal3 vout.$712.Metal2 7.92674156761
Rred_775 vout.$1100.Metal3 vout.$732.Metal2 28.4576640711
Rred_776 vout.$1106.Metal3 vout.$1126.Metal3 0.1804
Rred_777 vout.$1106.Metal3 vout.$1363.Metal4 18.3608
Rred_778 vout.$1106.Metal3 vout.$1373.Metal4 9
Rred_779 vout.$1106.Metal3 vout.$273.Metal1 1816.75394379
Rred_780 vout.$1106.Metal3 vout.$293.Metal1 1867.21933112
Rred_781 vout.$1106.Metal3 vout.$678.Metal2 9.18016178444
Rred_782 vout.$1106.Metal3 vout.$718.Metal2 18.3598471625
Rred_783 vout.$1110.Metal3 vout.$1150.Metal3 0.368032035556
Rred_784 vout.$1110.Metal3 vout.$1363.Metal4 18.3608
Rred_785 vout.$1110.Metal3 vout.$1373.Metal4 9
Rred_786 vout.$1110.Metal3 vout.$1384.Metal4 18.3608
Rred_787 vout.$1110.Metal3 vout.$275.Metal1 1816.75394379
Rred_788 vout.$1110.Metal3 vout.$295.Metal1 1867.21933112
Rred_789 vout.$1110.Metal3 vout.$682.Metal2 9.18016178444
Rred_790 vout.$1110.Metal3 vout.$722.Metal2 9.18016178444
Rred_791 vout.$1112.Metal3 vout.$1152.Metal3 0.367835007877
Rred_792 vout.$1112.Metal3 vout.$1368.Metal4 6.25120781147
Rred_793 vout.$1112.Metal3 vout.$1408.Metal4 18.11604913
Rred_794 vout.$1112.Metal3 vout.$684.Metal2 18.3608
Rred_795 vout.$1112.Metal3 vout.$704.Metal2 9
Rred_796 vout.$1112.Metal3 vout.$724.Metal2 18.3534550231
Rred_797 vout.$1114.Metal3 vout.$1154.Metal3 0.368032035556
Rred_798 vout.$1114.Metal3 vout.$1369.Metal4 4.54465248289
Rred_799 vout.$1114.Metal3 vout.$686.Metal2 18.3608
Rred_800 vout.$1114.Metal3 vout.$706.Metal2 9
Rred_801 vout.$1114.Metal3 vout.$726.Metal2 18.3608
Rred_802 vout.$1116.Metal3 vout.$1156.Metal3 0.368032035556
Rred_803 vout.$1116.Metal3 vout.$1370.Metal4 4.54465248289
Rred_804 vout.$1116.Metal3 vout.$688.Metal2 18.3608
Rred_805 vout.$1116.Metal3 vout.$708.Metal2 9
Rred_806 vout.$1116.Metal3 vout.$728.Metal2 18.3608
Rred_807 vout.$1118.Metal3 vout.$1158.Metal3 0.368032035556
Rred_808 vout.$1118.Metal3 vout.$1371.Metal4 4.54465248289
Rred_809 vout.$1118.Metal3 vout.$690.Metal2 18.3608
Rred_810 vout.$1118.Metal3 vout.$710.Metal2 9
Rred_811 vout.$1118.Metal3 vout.$730.Metal2 18.3608
Rred_812 vout.$1122.Metal3 vout.$1162.Metal3 0.368032035556
Rred_813 vout.$1122.Metal3 vout.$1373.Metal4 18.3608
Rred_814 vout.$1122.Metal3 vout.$1383.Metal4 6.03956024678
Rred_815 vout.$1122.Metal3 vout.$694.Metal2 18.3608
Rred_816 vout.$1122.Metal3 vout.$714.Metal2 9
Rred_817 vout.$1122.Metal3 vout.$734.Metal2 18.3608
Rred_818 vout.$1124.Metal3 vout.$1164.Metal3 0.368032035556
Rred_819 vout.$1124.Metal3 vout.$1373.Metal4 18.3608
Rred_820 vout.$1124.Metal3 vout.$1384.Metal4 9
Rred_821 vout.$1124.Metal3 vout.$1394.Metal4 18.3608
Rred_822 vout.$1124.Metal3 vout.$696.Metal2 18.3608
Rred_823 vout.$1124.Metal3 vout.$716.Metal2 9
Rred_824 vout.$1124.Metal3 vout.$736.Metal2 18.3608
Rred_825 vout.$1126.Metal3 vout.$1166.Metal3 0.368032035556
Rred_826 vout.$1126.Metal3 vout.$1384.Metal4 9
Rred_827 vout.$1126.Metal3 vout.$1395.Metal4 18.3608
Rred_828 vout.$1126.Metal3 vout.$718.Metal2 9
Rred_829 vout.$1126.Metal3 vout.$738.Metal2 18.3608
Rred_830 vout.$1128.Metal3 vout.$1168.Metal3 0.368032035556
Rred_831 vout.$1128.Metal3 vout.$1373.Metal4 18.3608
Rred_832 vout.$1128.Metal3 vout.$1384.Metal4 9
Rred_833 vout.$1128.Metal3 vout.$1395.Metal4 18.3608
Rred_834 vout.$1128.Metal3 vout.$700.Metal2 18.3608
Rred_835 vout.$1128.Metal3 vout.$720.Metal2 9
Rred_836 vout.$1128.Metal3 vout.$740.Metal2 18.3608
Rred_837 vout.$1150.Metal3 vout.$1190.Metal3 0.368032035556
Rred_838 vout.$1150.Metal3 vout.$1384.Metal4 18.3608
Rred_839 vout.$1150.Metal3 vout.$1395.Metal4 9
Rred_840 vout.$1150.Metal3 vout.$1405.Metal4 18.3608
Rred_841 vout.$1150.Metal3 vout.$722.Metal2 18.3608
Rred_842 vout.$1150.Metal3 vout.$742.Metal2 9
Rred_843 vout.$1150.Metal3 vout.$762.Metal2 18.3608
Rred_844 vout.$1152.Metal3 vout.$1368.Metal4 31.4531473001
Rred_845 vout.$1152.Metal3 vout.$1408.Metal4 2.42588356797
Rred_846 vout.$1152.Metal3 vout.$326.Metal1 8375.69676643
Rred_847 vout.$1152.Metal3 vout.$346.Metal1 1030.85498664
Rred_848 vout.$1152.Metal3 vout.$396.Metal1 586.201698029
Rred_849 vout.$1152.Metal3 vout.$724.Metal2 9.17902185147
Rred_850 vout.$1152.Metal3 vout.$764.Metal2 6.47988248301
Rred_851 vout.$1152.Metal3 vout.$784.Metal2 5.60977187034
Rred_852 vout.$1154.Metal3 vout.$1369.Metal4 2.23655168381
Rred_853 vout.$1154.Metal3 vout.$327.Metal1 8375.69676643
Rred_854 vout.$1154.Metal3 vout.$347.Metal1 1030.85498664
Rred_855 vout.$1154.Metal3 vout.$397.Metal1 586.201698029
Rred_856 vout.$1154.Metal3 vout.$726.Metal2 9.18030670401
Rred_857 vout.$1154.Metal3 vout.$766.Metal2 6.47988248301
Rred_858 vout.$1154.Metal3 vout.$786.Metal2 5.60977187034
Rred_859 vout.$1156.Metal3 vout.$1370.Metal4 2.23655168381
Rred_860 vout.$1156.Metal3 vout.$328.Metal1 8375.69676643
Rred_861 vout.$1156.Metal3 vout.$348.Metal1 1030.85498664
Rred_862 vout.$1156.Metal3 vout.$398.Metal1 586.201698029
Rred_863 vout.$1156.Metal3 vout.$728.Metal2 9.18030670401
Rred_864 vout.$1156.Metal3 vout.$768.Metal2 6.47988248301
Rred_865 vout.$1156.Metal3 vout.$788.Metal2 5.60977187034
Rred_866 vout.$1158.Metal3 vout.$1371.Metal4 2.23655168381
Rred_867 vout.$1158.Metal3 vout.$329.Metal1 8375.69676643
Rred_868 vout.$1158.Metal3 vout.$349.Metal1 1030.85498664
Rred_869 vout.$1158.Metal3 vout.$399.Metal1 586.201698029
Rred_870 vout.$1158.Metal3 vout.$730.Metal2 9.18030670401
Rred_871 vout.$1158.Metal3 vout.$770.Metal2 6.47988248301
Rred_872 vout.$1158.Metal3 vout.$790.Metal2 5.60977187034
Rred_873 vout.$1160.Metal3 vout.$1372.Metal4 2.00207617872
Rred_874 vout.$1160.Metal3 vout.$330.Metal1 8375.69676643
Rred_875 vout.$1160.Metal3 vout.$350.Metal1 1030.85498664
Rred_876 vout.$1160.Metal3 vout.$400.Metal1 586.201698029
Rred_877 vout.$1160.Metal3 vout.$712.Metal2 28.4576640711
Rred_878 vout.$1160.Metal3 vout.$732.Metal2 7.92684961513
Rred_879 vout.$1160.Metal3 vout.$772.Metal2 6.47988248301
Rred_880 vout.$1160.Metal3 vout.$792.Metal2 5.60977187034
Rred_881 vout.$1162.Metal3 vout.$1383.Metal4 2.23655168381
Rred_882 vout.$1162.Metal3 vout.$331.Metal1 8375.69676643
Rred_883 vout.$1162.Metal3 vout.$351.Metal1 1030.85498664
Rred_884 vout.$1162.Metal3 vout.$401.Metal1 586.201698029
Rred_885 vout.$1162.Metal3 vout.$734.Metal2 9.18030670401
Rred_886 vout.$1162.Metal3 vout.$774.Metal2 6.47988248301
Rred_887 vout.$1162.Metal3 vout.$794.Metal2 5.60977187034
Rred_888 vout.$1164.Metal3 vout.$1394.Metal4 2.23655168381
Rred_889 vout.$1164.Metal3 vout.$332.Metal1 8375.69676643
Rred_890 vout.$1164.Metal3 vout.$352.Metal1 1030.85498664
Rred_891 vout.$1164.Metal3 vout.$402.Metal1 586.201698029
Rred_892 vout.$1164.Metal3 vout.$736.Metal2 9.18030670401
Rred_893 vout.$1164.Metal3 vout.$776.Metal2 6.47988248301
Rred_894 vout.$1164.Metal3 vout.$796.Metal2 5.60977187034
Rred_895 vout.$1166.Metal3 vout.$1395.Metal4 18.3608
Rred_896 vout.$1166.Metal3 vout.$1405.Metal4 9
Rred_897 vout.$1166.Metal3 vout.$1415.Metal4 3.55186910988
Rred_898 vout.$1166.Metal3 vout.$333.Metal1 8375.69676643
Rred_899 vout.$1166.Metal3 vout.$353.Metal1 1030.85498664
Rred_900 vout.$1166.Metal3 vout.$403.Metal1 586.201698029
Rred_901 vout.$1166.Metal3 vout.$738.Metal2 9.18030670401
Rred_902 vout.$1166.Metal3 vout.$778.Metal2 6.47988248301
Rred_903 vout.$1166.Metal3 vout.$798.Metal2 5.60977187034
Rred_904 vout.$1168.Metal3 vout.$1208.Metal3 0.368032035556
Rred_905 vout.$1168.Metal3 vout.$1395.Metal4 18.3608
Rred_906 vout.$1168.Metal3 vout.$1405.Metal4 9
Rred_907 vout.$1168.Metal3 vout.$1416.Metal4 18.3608
Rred_908 vout.$1168.Metal3 vout.$334.Metal1 8375.69676643
Rred_909 vout.$1168.Metal3 vout.$354.Metal1 1030.85498664
Rred_910 vout.$1168.Metal3 vout.$740.Metal2 9.18030670401
Rred_911 vout.$1168.Metal3 vout.$780.Metal2 9.18030670401
Rred_912 vout.$1190.Metal3 vout.$1405.Metal4 18.3608
Rred_913 vout.$1190.Metal3 vout.$1416.Metal4 3.21268039995
Rred_914 vout.$1190.Metal3 vout.$405.Metal1 526.494516111
Rred_915 vout.$1190.Metal3 vout.$762.Metal2 18.3608
Rred_916 vout.$1190.Metal3 vout.$782.Metal2 9
Rred_917 vout.$1190.Metal3 vout.$802.Metal2 5.03912633155
Rred_918 vout.$12.Metal1 vout.$1235.Metal4 4720.73997004
Rred_919 vout.$12.Metal1 vout.$438.Metal2 5.33891199389
Rred_920 vout.$12.Metal1 vout.$458.Metal2 25.1220892469
Rred_921 vout.$12.Metal1 vout.$62.Metal1 0.600729620506
Rred_922 vout.$12.Metal1 vout.$886.Metal3 586.866710802
Rred_923 vout.$12.Metal1 vout.P2.nSD 8.65123602902
Rred_924 vout.$1208.Metal3 vout.$1415.Metal4 4.68192759355
Rred_925 vout.$1208.Metal3 vout.$1416.Metal4 18.3608
Rred_926 vout.$1208.Metal3 vout.$404.Metal1 488.39662632
Rred_927 vout.$1208.Metal3 vout.$780.Metal2 18.3608
Rred_928 vout.$1208.Metal3 vout.$800.Metal2 4.6747782072
Rred_929 vout.$121.Metal1 vout.$1264.Metal4 9611.79131121
Rred_930 vout.$121.Metal1 vout.$496.Metal2 25.1466584076
Rred_931 vout.$121.Metal1 vout.$516.Metal2 5.34087644342
Rred_932 vout.$121.Metal1 vout.$61.Metal1 0.600727890243
Rred_933 vout.$121.Metal1 vout.$904.Metal3 524.380994006
Rred_934 vout.$121.Metal1 vout.P0.nSD 8.61233997275
Rred_935 vout.$122.Metal1 vout.$1235.Metal4 5171.05310945
Rred_936 vout.$122.Metal1 vout.$498.Metal2 25.1248668228
Rred_937 vout.$122.Metal1 vout.$518.Metal2 5.33911247084
Rred_938 vout.$122.Metal1 vout.$62.Metal1 0.600727890243
Rred_939 vout.$122.Metal1 vout.$886.Metal3 581.151359205
Rred_940 vout.$122.Metal1 vout.P2.nSD 8.61233997275
Rred_941 vout.$123.Metal1 vout.$1236.Metal4 5171.05310945
Rred_942 vout.$123.Metal1 vout.$500.Metal2 25.1248668228
Rred_943 vout.$123.Metal1 vout.$520.Metal2 5.33911247084
Rred_944 vout.$123.Metal1 vout.$63.Metal1 0.600727890243
Rred_945 vout.$123.Metal1 vout.$888.Metal3 581.151359205
Rred_946 vout.$123.Metal1 vout.P4.nSD 8.61233997275
Rred_947 vout.$1235.Metal4 vout.$1236.Metal4 0.04488
Rred_948 vout.$1235.Metal4 vout.$1264.Metal4 0.398945437197
Rred_949 vout.$1235.Metal4 vout.$436.Metal2 119.062607855
Rred_950 vout.$1235.Metal4 vout.$438.Metal2 50.1660186734
Rred_951 vout.$1235.Metal4 vout.$458.Metal2 177.199676048
Rred_952 vout.$1235.Metal4 vout.$498.Metal2 192.098391112
Rred_953 vout.$1235.Metal4 vout.$518.Metal2 54.8622650604
Rred_954 vout.$1235.Metal4 vout.$864.Metal3 4.40208808094
Rred_955 vout.$1235.Metal4 vout.$886.Metal3 1.53289787408
Rred_956 vout.$1236.Metal4 vout.$1237.Metal4 0.04488
Rred_957 vout.$1236.Metal4 vout.$13.Metal1 4720.73997004
Rred_958 vout.$1236.Metal4 vout.$440.Metal2 50.1660186734
Rred_959 vout.$1236.Metal4 vout.$460.Metal2 177.199676048
Rred_960 vout.$1236.Metal4 vout.$500.Metal2 192.098391112
Rred_961 vout.$1236.Metal4 vout.$520.Metal2 54.8622650604
Rred_962 vout.$1236.Metal4 vout.$888.Metal3 1.53289787408
Rred_963 vout.$1237.Metal4 vout.$1238.Metal4 0.04488
Rred_964 vout.$1237.Metal4 vout.$124.Metal1 5171.05310945
Rred_965 vout.$1237.Metal4 vout.$14.Metal1 4720.73997004
Rred_966 vout.$1237.Metal4 vout.$442.Metal2 50.1660186734
Rred_967 vout.$1237.Metal4 vout.$462.Metal2 177.199676048
Rred_968 vout.$1237.Metal4 vout.$502.Metal2 192.098391112
Rred_969 vout.$1237.Metal4 vout.$522.Metal2 54.8622650604
Rred_970 vout.$1237.Metal4 vout.$890.Metal3 1.53289787408
Rred_971 vout.$1238.Metal4 vout.$1239.Metal4 0.0897965859267
Rred_972 vout.$1238.Metal4 vout.$125.Metal1 5171.05310945
Rred_973 vout.$1238.Metal4 vout.$15.Metal1 4720.73997004
Rred_974 vout.$1238.Metal4 vout.$444.Metal2 50.1660186734
Rred_975 vout.$1238.Metal4 vout.$464.Metal2 177.199676048
Rred_976 vout.$1238.Metal4 vout.$504.Metal2 192.098391112
Rred_977 vout.$1238.Metal4 vout.$524.Metal2 54.8622650604
Rred_978 vout.$1238.Metal4 vout.$892.Metal3 1.53289787408
Rred_979 vout.$1239.Metal4 vout.$1240.Metal4 0.0500302065794
Rred_980 vout.$1239.Metal4 vout.$16.Metal1 4720.73997004
Rred_981 vout.$1239.Metal4 vout.$446.Metal2 50.1660186734
Rred_982 vout.$1239.Metal4 vout.$466.Metal2 177.199676048
Rred_983 vout.$1239.Metal4 vout.$894.Metal3 3.55186906212
Rred_984 vout.$124.Metal1 vout.$502.Metal2 25.1248668228
Rred_985 vout.$124.Metal1 vout.$522.Metal2 5.33911247084
Rred_986 vout.$124.Metal1 vout.$64.Metal1 0.600727890243
Rred_987 vout.$124.Metal1 vout.$890.Metal3 581.151359205
Rred_988 vout.$124.Metal1 vout.P6.nSD 8.61233997275
Rred_989 vout.$1240.Metal4 vout.$1241.Metal4 0.115861562631
Rred_990 vout.$1240.Metal4 vout.$1252.Metal4 0.201375714667
Rred_991 vout.$1240.Metal4 vout.$1261.Metal4 0.324638296655
Rred_992 vout.$1240.Metal4 vout.$17.Metal1 4720.73997004
Rred_993 vout.$1240.Metal4 vout.$448.Metal2 50.1660186734
Rred_994 vout.$1240.Metal4 vout.$468.Metal2 177.199676048
Rred_995 vout.$1240.Metal4 vout.$896.Metal3 3.55186906212
Rred_996 vout.$1241.Metal4 vout.$1252.Metal4 0.0116694883101
Rred_997 vout.$1241.Metal4 vout.$1261.Metal4 0.0188124114871
Rred_998 vout.$1241.Metal4 vout.$18.Metal1 24403.0849465
Rred_999 vout.$1241.Metal4 vout.$19.Metal1 24616.2134621
Rred_1000 vout.$1241.Metal4 vout.$450.Metal2 485.473124043
Rred_1001 vout.$1241.Metal4 vout.$452.Metal2 489.713086593
Rred_1002 vout.$1241.Metal4 vout.$858.Metal3 4.58759190296
Rred_1003 vout.$1241.Metal4 vout.$860.Metal3 9.43904663312
Rred_1004 vout.$125.Metal1 vout.$504.Metal2 25.1248668228
Rred_1005 vout.$125.Metal1 vout.$524.Metal2 5.33911247084
Rred_1006 vout.$125.Metal1 vout.$65.Metal1 0.600727890243
Rred_1007 vout.$125.Metal1 vout.$892.Metal3 581.151359205
Rred_1008 vout.$125.Metal1 vout.P8.nSD 8.61233997275
Rred_1009 vout.$1252.Metal4 vout.$1261.Metal4 0.0326973218882
Rred_1010 vout.$1252.Metal4 vout.$20.Metal1 24495.0989672
Rred_1011 vout.$1252.Metal4 vout.$454.Metal2 487.303644003
Rred_1012 vout.$1252.Metal4 vout.$860.Metal3 9
Rred_1013 vout.$1252.Metal4 vout.$862.Metal3 4.59605624702
Rred_1014 vout.$126.Metal1 vout.$1299.Metal4 24403.0849465
Rred_1015 vout.$126.Metal1 vout.$506.Metal2 25.1466584076
Rred_1016 vout.$126.Metal1 vout.$526.Metal2 5.34297678449
Rred_1017 vout.$126.Metal1 vout.$66.Metal1 0.600727890243
Rred_1018 vout.$126.Metal1 vout.$934.Metal3 489.146280484
Rred_1019 vout.$126.Metal1 vout.P10.nSD 8.61233997275
Rred_1020 vout.$1261.Metal4 vout.$1269.Metal4 0.00996377037281
Rred_1021 vout.$1261.Metal4 vout.$470.Metal2 916.00443459
Rred_1022 vout.$1261.Metal4 vout.$472.Metal2 916.00443459
Rred_1023 vout.$1261.Metal4 vout.$474.Metal2 916.00443459
Rred_1024 vout.$1261.Metal4 vout.$858.Metal3 18.3608
Rred_1025 vout.$1261.Metal4 vout.$860.Metal3 18.3608
Rred_1026 vout.$1261.Metal4 vout.$862.Metal3 18.3608
Rred_1027 vout.$1261.Metal4 vout.$898.Metal3 18.3608
Rred_1028 vout.$1261.Metal4 vout.$900.Metal3 18.3608
Rred_1029 vout.$1261.Metal4 vout.$902.Metal3 18.3608
Rred_1030 vout.$1264.Metal4 vout.$436.Metal2 969.885806319
Rred_1031 vout.$1264.Metal4 vout.$476.Metal2 916.00443459
Rred_1032 vout.$1264.Metal4 vout.$516.Metal2 112.473090269
Rred_1033 vout.$1264.Metal4 vout.$864.Metal3 7.65131382908
Rred_1034 vout.$1264.Metal4 vout.$904.Metal3 2.92153140177
Rred_1035 vout.$1269.Metal4 vout.$1279.Metal4 0.00842990654206
Rred_1036 vout.$1269.Metal4 vout.$894.Metal3 9
Rred_1037 vout.$1269.Metal4 vout.$896.Metal3 9
Rred_1038 vout.$1269.Metal4 vout.$898.Metal3 9
Rred_1039 vout.$1269.Metal4 vout.$900.Metal3 9
Rred_1040 vout.$1269.Metal4 vout.$902.Metal3 9
Rred_1041 vout.$127.Metal1 vout.$1299.Metal4 24403.0849465
Rred_1042 vout.$127.Metal1 vout.$508.Metal2 25.1466584076
Rred_1043 vout.$127.Metal1 vout.$528.Metal2 5.34297678449
Rred_1044 vout.$127.Metal1 vout.$67.Metal1 0.600727890243
Rred_1045 vout.$127.Metal1 vout.$936.Metal3 489.146280484
Rred_1046 vout.$127.Metal1 vout.P12.nSD 8.61233997275
Rred_1047 vout.$1279.Metal4 vout.$1289.Metal4 0.00842990654206
Rred_1048 vout.$1279.Metal4 vout.$506.Metal2 916.00443459
Rred_1049 vout.$1279.Metal4 vout.$508.Metal2 916.00443459
Rred_1050 vout.$1279.Metal4 vout.$510.Metal2 916.00443459
Rred_1051 vout.$1279.Metal4 vout.$512.Metal2 916.00443459
Rred_1052 vout.$1279.Metal4 vout.$514.Metal2 916.00443459
Rred_1053 vout.$1279.Metal4 vout.$894.Metal3 18.3608
Rred_1054 vout.$1279.Metal4 vout.$896.Metal3 18.3608
Rred_1055 vout.$1279.Metal4 vout.$898.Metal3 18.3608
Rred_1056 vout.$1279.Metal4 vout.$900.Metal3 18.3608
Rred_1057 vout.$1279.Metal4 vout.$902.Metal3 18.3608
Rred_1058 vout.$1279.Metal4 vout.$934.Metal3 18.3608
Rred_1059 vout.$1279.Metal4 vout.$936.Metal3 18.3608
Rred_1060 vout.$1279.Metal4 vout.$938.Metal3 18.3608
Rred_1061 vout.$1279.Metal4 vout.$940.Metal3 18.3608
Rred_1062 vout.$1279.Metal4 vout.$942.Metal3 18.3608
Rred_1063 vout.$128.Metal1 vout.$1299.Metal4 24403.0849465
Rred_1064 vout.$128.Metal1 vout.$510.Metal2 25.1466584076
Rred_1065 vout.$128.Metal1 vout.$530.Metal2 5.34297678449
Rred_1066 vout.$128.Metal1 vout.$68.Metal1 0.600727890243
Rred_1067 vout.$128.Metal1 vout.$938.Metal3 489.146280484
Rred_1068 vout.$128.Metal1 vout.P14.nSD 8.61233997275
Rred_1069 vout.$1289.Metal4 vout.$1299.Metal4 0.00842990654206
Rred_1070 vout.$1289.Metal4 vout.$934.Metal3 9
Rred_1071 vout.$1289.Metal4 vout.$936.Metal3 9
Rred_1072 vout.$1289.Metal4 vout.$938.Metal3 9
Rred_1073 vout.$1289.Metal4 vout.$940.Metal3 9
Rred_1074 vout.$1289.Metal4 vout.$942.Metal3 9
Rred_1075 vout.$129.Metal1 vout.$1299.Metal4 24403.0849465
Rred_1076 vout.$129.Metal1 vout.$512.Metal2 25.1466584076
Rred_1077 vout.$129.Metal1 vout.$532.Metal2 5.34297678449
Rred_1078 vout.$129.Metal1 vout.$69.Metal1 0.600727890243
Rred_1079 vout.$129.Metal1 vout.$940.Metal3 489.146280484
Rred_1080 vout.$129.Metal1 vout.P16.nSD 8.61233997275
Rred_1081 vout.$1299.Metal4 vout.$130.Metal1 24403.0849465
Rred_1082 vout.$1299.Metal4 vout.$1313.Metal4 8077.4858128
Rred_1083 vout.$1299.Metal4 vout.$526.Metal2 485.473124043
Rred_1084 vout.$1299.Metal4 vout.$528.Metal2 485.473124043
Rred_1085 vout.$1299.Metal4 vout.$530.Metal2 485.473124043
Rred_1086 vout.$1299.Metal4 vout.$532.Metal2 485.473124043
Rred_1087 vout.$1299.Metal4 vout.$534.Metal2 485.473124043
Rred_1088 vout.$1299.Metal4 vout.$934.Metal3 9.35732285377
Rred_1089 vout.$1299.Metal4 vout.$936.Metal3 9.35732285377
Rred_1090 vout.$1299.Metal4 vout.$938.Metal3 9.35732285377
Rred_1091 vout.$1299.Metal4 vout.$940.Metal3 9.35732285377
Rred_1092 vout.$1299.Metal4 vout.$942.Metal3 9.35732285377
Rred_1093 vout.$1299.Metal4 vout.P0.GatPoly 862.587108942
Rred_1094 vout.$13.Metal1 vout.$440.Metal2 5.33891199389
Rred_1095 vout.$13.Metal1 vout.$460.Metal2 25.1220892469
Rred_1096 vout.$13.Metal1 vout.$63.Metal1 0.600729620506
Rred_1097 vout.$13.Metal1 vout.$888.Metal3 586.866710802
Rred_1098 vout.$13.Metal1 vout.P4.nSD 8.65123602902
Rred_1099 vout.$130.Metal1 vout.$514.Metal2 25.1466584076
Rred_1100 vout.$130.Metal1 vout.$534.Metal2 5.34297678449
Rred_1101 vout.$130.Metal1 vout.$70.Metal1 0.600727890243
Rred_1102 vout.$130.Metal1 vout.$942.Metal3 489.146280484
Rred_1103 vout.$130.Metal1 vout.P18.nSD 8.61233997275
Rred_1104 vout.$1313.Metal4 vout.$1323.Metal4 0.00842990654206
Rred_1105 vout.$1313.Metal4 vout.$161.Metal1 24375.4320652
Rred_1106 vout.$1313.Metal4 vout.$162.Metal1 24375.4320652
Rred_1107 vout.$1313.Metal4 vout.$163.Metal1 24375.4320652
Rred_1108 vout.$1313.Metal4 vout.$164.Metal1 24375.4320652
Rred_1109 vout.$1313.Metal4 vout.$165.Metal1 24375.4320652
Rred_1110 vout.$1313.Metal4 vout.$594.Metal2 485.483869595
Rred_1111 vout.$1313.Metal4 vout.$596.Metal2 485.483869595
Rred_1112 vout.$1313.Metal4 vout.$598.Metal2 485.483869595
Rred_1113 vout.$1313.Metal4 vout.$600.Metal2 485.483869595
Rred_1114 vout.$1313.Metal4 vout.$602.Metal2 485.483869595
Rred_1115 vout.$1313.Metal4 vout.P0.GatPoly 620.059392334
Rred_1116 vout.$1323.Metal4 vout.$1333.Metal4 0.00842990654206
Rred_1117 vout.$1328.Metal4 vout.$1368.Metal4 0.75805390775
Rred_1118 vout.$1328.Metal4 vout.$156.Metal1 4901.18384755
Rred_1119 vout.$1328.Metal4 vout.$584.Metal2 52.0586936315
Rred_1120 vout.$1328.Metal4 vout.$604.Metal2 182.279627323
Rred_1121 vout.$1328.Metal4 vout.$644.Metal2 1905.45038155
Rred_1122 vout.$1329.Metal4 vout.$1369.Metal4 0.755583409428
Rred_1123 vout.$1329.Metal4 vout.$157.Metal1 4901.18384755
Rred_1124 vout.$1329.Metal4 vout.$586.Metal2 52.0586936315
Rred_1125 vout.$1329.Metal4 vout.$606.Metal2 182.279627323
Rred_1126 vout.$1329.Metal4 vout.$646.Metal2 1911.01992043
Rred_1127 vout.$1330.Metal4 vout.$1370.Metal4 0.755583409428
Rred_1128 vout.$1330.Metal4 vout.$158.Metal1 4901.18384755
Rred_1129 vout.$1330.Metal4 vout.$588.Metal2 52.0586936315
Rred_1130 vout.$1330.Metal4 vout.$608.Metal2 182.279627323
Rred_1131 vout.$1330.Metal4 vout.$648.Metal2 1911.01992043
Rred_1132 vout.$1331.Metal4 vout.$1371.Metal4 0.755583409428
Rred_1133 vout.$1331.Metal4 vout.$159.Metal1 4901.18384755
Rred_1134 vout.$1331.Metal4 vout.$590.Metal2 52.0586936315
Rred_1135 vout.$1331.Metal4 vout.$610.Metal2 182.279627323
Rred_1136 vout.$1331.Metal4 vout.$650.Metal2 1911.01992043
Rred_1137 vout.$1332.Metal4 vout.$1372.Metal4 0.755583409428
Rred_1138 vout.$1332.Metal4 vout.$160.Metal1 4901.18384755
Rred_1139 vout.$1332.Metal4 vout.$592.Metal2 52.0586936315
Rred_1140 vout.$1332.Metal4 vout.$612.Metal2 182.279627323
Rred_1141 vout.$1332.Metal4 vout.$652.Metal2 1911.01992043
Rred_1142 vout.$1333.Metal4 vout.$1343.Metal4 0.00842990654206
Rred_1143 vout.$1333.Metal4 vout.$614.Metal2 916.00443459
Rred_1144 vout.$1333.Metal4 vout.$616.Metal2 916.00443459
Rred_1145 vout.$1333.Metal4 vout.$618.Metal2 916.00443459
Rred_1146 vout.$1333.Metal4 vout.$620.Metal2 916.00443459
Rred_1147 vout.$1333.Metal4 vout.$622.Metal2 916.00443459
Rred_1148 vout.$1343.Metal4 vout.$1353.Metal4 0.00842990654206
Rred_1149 vout.$1353.Metal4 vout.$1363.Metal4 0.00842990654206
Rred_1150 vout.$1353.Metal4 vout.$654.Metal2 916.00443459
Rred_1151 vout.$1353.Metal4 vout.$656.Metal2 916.00443459
Rred_1152 vout.$1353.Metal4 vout.$660.Metal2 916.00443459
Rred_1153 vout.$1363.Metal4 vout.$1373.Metal4 0.00843000513901
Rred_1154 vout.$1363.Metal4 vout.$678.Metal2 916.00443459
Rred_1155 vout.$1363.Metal4 vout.$682.Metal2 916.00443459
Rred_1156 vout.$1368.Metal4 vout.$1408.Metal4 0.829308571898
Rred_1157 vout.$1368.Metal4 vout.$644.Metal2 1905.46163528
Rred_1158 vout.$1368.Metal4 vout.$684.Metal2 916.00443459
Rred_1159 vout.$1368.Metal4 vout.$724.Metal2 2100.25322434
Rred_1160 vout.$1369.Metal4 vout.$1370.Metal4 0.0343908045977
Rred_1161 vout.$1369.Metal4 vout.$1408.Metal4 0.0356932530183
Rred_1162 vout.$1369.Metal4 vout.$397.Metal1 4715.39062526
Rred_1163 vout.$1369.Metal4 vout.$646.Metal2 1899.25173421
Rred_1164 vout.$1369.Metal4 vout.$686.Metal2 916.00443459
Rred_1165 vout.$1369.Metal4 vout.$726.Metal2 916.00443459
Rred_1166 vout.$1369.Metal4 vout.$766.Metal2 177.199678431
Rred_1167 vout.$1369.Metal4 vout.$786.Metal2 50.1666125505
Rred_1168 vout.$1370.Metal4 vout.$1371.Metal4 0.0343908045977
Rred_1169 vout.$1370.Metal4 vout.$398.Metal1 4715.39062526
Rred_1170 vout.$1370.Metal4 vout.$648.Metal2 1899.25173421
Rred_1171 vout.$1370.Metal4 vout.$688.Metal2 916.00443459
Rred_1172 vout.$1370.Metal4 vout.$728.Metal2 916.00443459
Rred_1173 vout.$1370.Metal4 vout.$768.Metal2 177.199678431
Rred_1174 vout.$1370.Metal4 vout.$788.Metal2 50.1666125505
Rred_1175 vout.$1371.Metal4 vout.$1372.Metal4 0.0343908045977
Rred_1176 vout.$1371.Metal4 vout.$399.Metal1 4715.39062526
Rred_1177 vout.$1371.Metal4 vout.$650.Metal2 1899.25173421
Rred_1178 vout.$1371.Metal4 vout.$690.Metal2 916.00443459
Rred_1179 vout.$1371.Metal4 vout.$730.Metal2 916.00443459
Rred_1180 vout.$1371.Metal4 vout.$770.Metal2 177.199678431
Rred_1181 vout.$1371.Metal4 vout.$790.Metal2 50.1666125505
Rred_1182 vout.$1372.Metal4 vout.$1383.Metal4 0.0688216220834
Rred_1183 vout.$1372.Metal4 vout.$400.Metal1 4715.39062526
Rred_1184 vout.$1372.Metal4 vout.$652.Metal2 1899.25173421
Rred_1185 vout.$1372.Metal4 vout.$712.Metal2 467.002217295
Rred_1186 vout.$1372.Metal4 vout.$732.Metal2 467.002217295
Rred_1187 vout.$1372.Metal4 vout.$772.Metal2 177.199678431
Rred_1188 vout.$1372.Metal4 vout.$792.Metal2 50.1666125505
Rred_1189 vout.$1373.Metal4 vout.$1384.Metal4 0.00918991691467
Rred_1190 vout.$1373.Metal4 vout.$694.Metal2 916.00443459
Rred_1191 vout.$1373.Metal4 vout.$696.Metal2 916.00443459
Rred_1192 vout.$1373.Metal4 vout.$700.Metal2 916.00443459
Rred_1193 vout.$1383.Metal4 vout.$1394.Metal4 0.0403681913489
Rred_1194 vout.$1383.Metal4 vout.$401.Metal1 4715.39062526
Rred_1195 vout.$1383.Metal4 vout.$734.Metal2 916.00443459
Rred_1196 vout.$1383.Metal4 vout.$774.Metal2 177.199678431
Rred_1197 vout.$1383.Metal4 vout.$794.Metal2 50.1666125505
Rred_1198 vout.$1384.Metal4 vout.$1395.Metal4 0.0110956707561
Rred_1199 vout.$1384.Metal4 vout.$722.Metal2 916.00443459
Rred_1200 vout.$1394.Metal4 vout.$1415.Metal4 0.05624580116
Rred_1201 vout.$1394.Metal4 vout.$402.Metal1 4715.39062526
Rred_1202 vout.$1394.Metal4 vout.$736.Metal2 916.00443459
Rred_1203 vout.$1394.Metal4 vout.$776.Metal2 177.199678431
Rred_1204 vout.$1394.Metal4 vout.$796.Metal2 50.1666125505
Rred_1205 vout.$1395.Metal4 vout.$1405.Metal4 0.01400429174
Rred_1206 vout.$1395.Metal4 vout.$738.Metal2 916.00443459
Rred_1207 vout.$1395.Metal4 vout.$740.Metal2 916.00443459
Rred_1208 vout.$14.Metal1 vout.$442.Metal2 5.33891199389
Rred_1209 vout.$14.Metal1 vout.$462.Metal2 25.1220892469
Rred_1210 vout.$14.Metal1 vout.$64.Metal1 0.600729620506
Rred_1211 vout.$14.Metal1 vout.$890.Metal3 586.866710802
Rred_1212 vout.$14.Metal1 vout.P6.nSD 8.65123602902
Rred_1213 vout.$1405.Metal4 vout.$1415.Metal4 0.00280395760705
Rred_1214 vout.$1405.Metal4 vout.$762.Metal2 916.00443459
Rred_1215 vout.$1408.Metal4 vout.$396.Metal1 4715.39062526
Rred_1216 vout.$1408.Metal4 vout.$724.Metal2 1729.2283748
Rred_1217 vout.$1408.Metal4 vout.$764.Metal2 177.199678431
Rred_1218 vout.$1408.Metal4 vout.$784.Metal2 50.1666125505
Rred_1219 vout.$1415.Metal4 vout.$1416.Metal4 0.0161972814407
Rred_1220 vout.$1415.Metal4 vout.$403.Metal1 4715.39062526
Rred_1221 vout.$1415.Metal4 vout.$404.Metal1 24876.6694912
Rred_1222 vout.$1415.Metal4 vout.$778.Metal2 177.199678431
Rred_1223 vout.$1415.Metal4 vout.$798.Metal2 50.1666125505
Rred_1224 vout.$1415.Metal4 vout.$800.Metal2 495.466982286
Rred_1225 vout.$1416.Metal4 vout.$405.Metal1 8743.9185852
Rred_1226 vout.$1416.Metal4 vout.$780.Metal2 916.00443459
Rred_1227 vout.$1416.Metal4 vout.$802.Metal2 102.520847603
Rred_1228 vout.$15.Metal1 vout.$444.Metal2 5.33891199389
Rred_1229 vout.$15.Metal1 vout.$464.Metal2 25.1220892469
Rred_1230 vout.$15.Metal1 vout.$65.Metal1 0.600729620506
Rred_1231 vout.$15.Metal1 vout.$892.Metal3 586.866710802
Rred_1232 vout.$15.Metal1 vout.P8.nSD 8.65123602902
Rred_1233 vout.$156.Metal1 vout.$206.Metal1 0.59229373722
Rred_1234 vout.$156.Metal1 vout.$584.Metal2 5.40656480397
Rred_1235 vout.$156.Metal1 vout.$604.Metal2 27.1005435027
Rred_1236 vout.$156.Metal1 vout.P0.pSD 8.64999884435
Rred_1237 vout.$157.Metal1 vout.$207.Metal1 0.59229373722
Rred_1238 vout.$157.Metal1 vout.$586.Metal2 5.40656480397
Rred_1239 vout.$157.Metal1 vout.$606.Metal2 27.1005435027
Rred_1240 vout.$157.Metal1 vout.P2.pSD 8.64999884435
Rred_1241 vout.$158.Metal1 vout.$208.Metal1 0.59229373722
Rred_1242 vout.$158.Metal1 vout.$588.Metal2 5.40656480397
Rred_1243 vout.$158.Metal1 vout.$608.Metal2 27.1005435027
Rred_1244 vout.$158.Metal1 vout.P4.pSD 8.64999884435
Rred_1245 vout.$159.Metal1 vout.$209.Metal1 0.59229373722
Rred_1246 vout.$159.Metal1 vout.$590.Metal2 5.40656480397
Rred_1247 vout.$159.Metal1 vout.$610.Metal2 27.1005435027
Rred_1248 vout.$159.Metal1 vout.P6.pSD 8.64999884435
Rred_1249 vout.$16.Metal1 vout.$446.Metal2 5.33891199389
Rred_1250 vout.$16.Metal1 vout.$466.Metal2 25.1220892469
Rred_1251 vout.$16.Metal1 vout.$66.Metal1 0.600729620506
Rred_1252 vout.$16.Metal1 vout.$894.Metal3 586.866710802
Rred_1253 vout.$16.Metal1 vout.P10.nSD 8.65123602902
Rred_1254 vout.$160.Metal1 vout.$210.Metal1 0.59229373722
Rred_1255 vout.$160.Metal1 vout.$592.Metal2 5.40656480397
Rred_1256 vout.$160.Metal1 vout.$612.Metal2 27.1005435027
Rred_1257 vout.$160.Metal1 vout.P8.pSD 8.64999884435
Rred_1258 vout.$161.Metal1 vout.$211.Metal1 0.59229373722
Rred_1259 vout.$161.Metal1 vout.$594.Metal2 5.41051222785
Rred_1260 vout.$161.Metal1 vout.$614.Metal2 27.1257864987
Rred_1261 vout.$161.Metal1 vout.P10.pSD 8.64999884435
Rred_1262 vout.$162.Metal1 vout.$212.Metal1 0.59229373722
Rred_1263 vout.$162.Metal1 vout.$596.Metal2 5.41051222785
Rred_1264 vout.$162.Metal1 vout.$616.Metal2 27.1257864987
Rred_1265 vout.$162.Metal1 vout.P12.pSD 8.64999884435
Rred_1266 vout.$163.Metal1 vout.$213.Metal1 0.59229373722
Rred_1267 vout.$163.Metal1 vout.$598.Metal2 5.41051222785
Rred_1268 vout.$163.Metal1 vout.$618.Metal2 27.1257864987
Rred_1269 vout.$163.Metal1 vout.P14.pSD 8.64999884435
Rred_1270 vout.$164.Metal1 vout.$214.Metal1 0.59229373722
Rred_1271 vout.$164.Metal1 vout.$600.Metal2 5.41051222785
Rred_1272 vout.$164.Metal1 vout.$620.Metal2 27.1257864987
Rred_1273 vout.$164.Metal1 vout.P16.pSD 8.64999884435
Rred_1274 vout.$165.Metal1 vout.$215.Metal1 0.59229373722
Rred_1275 vout.$165.Metal1 vout.$602.Metal2 5.41051222785
Rred_1276 vout.$165.Metal1 vout.$622.Metal2 27.1257864987
Rred_1277 vout.$165.Metal1 vout.P18.pSD 8.64999884435
Rred_1278 vout.$17.Metal1 vout.$448.Metal2 5.33891199389
Rred_1279 vout.$17.Metal1 vout.$468.Metal2 25.1220892469
Rred_1280 vout.$17.Metal1 vout.$67.Metal1 0.600729620506
Rred_1281 vout.$17.Metal1 vout.$896.Metal3 586.866710802
Rred_1282 vout.$17.Metal1 vout.P12.nSD 8.65123602902
Rred_1283 vout.$18.Metal1 vout.$450.Metal2 5.34273779964
Rred_1284 vout.$18.Metal1 vout.$470.Metal2 25.1436636536
Rred_1285 vout.$18.Metal1 vout.$68.Metal1 0.600729620506
Rred_1286 vout.$18.Metal1 vout.$858.Metal3 489.146280484
Rred_1287 vout.$18.Metal1 vout.P14.nSD 8.65123602902
Rred_1288 vout.$19.Metal1 vout.$452.Metal2 5.3427376082
Rred_1289 vout.$19.Metal1 vout.$472.Metal2 25.1436636536
Rred_1290 vout.$19.Metal1 vout.$69.Metal1 0.600729620506
Rred_1291 vout.$19.Metal1 vout.$860.Metal3 489.063041914
Rred_1292 vout.$19.Metal1 vout.P16.nSD 8.65123602902
Rred_1293 vout.$20.Metal1 vout.$454.Metal2 5.34273771658
Rred_1294 vout.$20.Metal1 vout.$474.Metal2 25.1436636536
Rred_1295 vout.$20.Metal1 vout.$70.Metal1 0.600729620506
Rred_1296 vout.$20.Metal1 vout.$862.Metal3 489.110162712
Rred_1297 vout.$20.Metal1 vout.P18.nSD 8.65123602902
Rred_1298 vout.$206.Metal1 vout.$226.Metal1 0.19153913295
Rred_1299 vout.$206.Metal1 vout.$584.Metal2 33.9222776771
Rred_1300 vout.$206.Metal1 vout.$604.Metal2 8.33299389457
Rred_1301 vout.$206.Metal1 vout.$644.Metal2 20.3451917239
Rred_1302 vout.$206.Metal1 vout.P0.pSD 8.60461906604
Rred_1303 vout.$207.Metal1 vout.$227.Metal1 0.19153913295
Rred_1304 vout.$207.Metal1 vout.$586.Metal2 33.9222776771
Rred_1305 vout.$207.Metal1 vout.$606.Metal2 8.33299389457
Rred_1306 vout.$207.Metal1 vout.$646.Metal2 20.3451917239
Rred_1307 vout.$207.Metal1 vout.P2.pSD 8.60461906604
Rred_1308 vout.$208.Metal1 vout.$228.Metal1 0.19153913295
Rred_1309 vout.$208.Metal1 vout.$588.Metal2 33.9222776771
Rred_1310 vout.$208.Metal1 vout.$608.Metal2 8.33299389457
Rred_1311 vout.$208.Metal1 vout.$648.Metal2 20.3451917239
Rred_1312 vout.$208.Metal1 vout.P4.pSD 8.60461906604
Rred_1313 vout.$209.Metal1 vout.$229.Metal1 0.19153913295
Rred_1314 vout.$209.Metal1 vout.$590.Metal2 33.9222776771
Rred_1315 vout.$209.Metal1 vout.$610.Metal2 8.33299389457
Rred_1316 vout.$209.Metal1 vout.$650.Metal2 20.3451917239
Rred_1317 vout.$209.Metal1 vout.P6.pSD 8.60461906604
Rred_1318 vout.$210.Metal1 vout.$230.Metal1 0.19153913295
Rred_1319 vout.$210.Metal1 vout.$592.Metal2 33.9222776771
Rred_1320 vout.$210.Metal1 vout.$612.Metal2 8.33299389457
Rred_1321 vout.$210.Metal1 vout.$652.Metal2 20.3451917239
Rred_1322 vout.$210.Metal1 vout.P8.pSD 8.60461906604
Rred_1323 vout.$211.Metal1 vout.$251.Metal1 0.386436234913
Rred_1324 vout.$211.Metal1 vout.$594.Metal2 33.9222776771
Rred_1325 vout.$211.Metal1 vout.$614.Metal2 14.1136835097
Rred_1326 vout.$211.Metal1 vout.$634.Metal2 9.4804418252
Rred_1327 vout.$211.Metal1 vout.$654.Metal2 23.7131325969
Rred_1328 vout.$211.Metal1 vout.P10.pSD 6.89536081351
Rred_1329 vout.$212.Metal1 vout.$232.Metal1 0.19153913295
Rred_1330 vout.$212.Metal1 vout.$596.Metal2 33.9222776771
Rred_1331 vout.$212.Metal1 vout.$616.Metal2 8.33299389457
Rred_1332 vout.$212.Metal1 vout.$656.Metal2 20.3451917239
Rred_1333 vout.$212.Metal1 vout.P12.pSD 8.60461906604
Rred_1334 vout.$213.Metal1 vout.$233.Metal1 0.19153913295
Rred_1335 vout.$213.Metal1 vout.$598.Metal2 33.9222776771
Rred_1336 vout.$213.Metal1 vout.$618.Metal2 8.33299389457
Rred_1337 vout.$213.Metal1 vout.$658.Metal2 20.3451917239
Rred_1338 vout.$213.Metal1 vout.P14.pSD 8.60461906604
Rred_1339 vout.$214.Metal1 vout.$234.Metal1 0.19153913295
Rred_1340 vout.$214.Metal1 vout.$600.Metal2 33.9222776771
Rred_1341 vout.$214.Metal1 vout.$620.Metal2 8.33299389457
Rred_1342 vout.$214.Metal1 vout.$660.Metal2 20.3451917239
Rred_1343 vout.$214.Metal1 vout.P16.pSD 8.60461906604
Rred_1344 vout.$215.Metal1 vout.$235.Metal1 0.19153913295
Rred_1345 vout.$215.Metal1 vout.$602.Metal2 33.9222776771
Rred_1346 vout.$215.Metal1 vout.$622.Metal2 8.33299389457
Rred_1347 vout.$215.Metal1 vout.$662.Metal2 20.3451917239
Rred_1348 vout.$215.Metal1 vout.P18.pSD 8.60461906604
Rred_1349 vout.$226.Metal1 vout.$266.Metal1 0.38426238157
Rred_1350 vout.$226.Metal1 vout.$604.Metal2 191.826093397
Rred_1351 vout.$226.Metal1 vout.$644.Metal2 9.66626661297
Rred_1352 vout.$226.Metal1 vout.$664.Metal2 28.7057668446
Rred_1353 vout.$226.Metal1 vout.P0.pSD 11.3856443308
Rred_1354 vout.$227.Metal1 vout.$267.Metal1 0.38426238157
Rred_1355 vout.$227.Metal1 vout.$606.Metal2 191.826093397
Rred_1356 vout.$227.Metal1 vout.$646.Metal2 9.66626661297
Rred_1357 vout.$227.Metal1 vout.$666.Metal2 28.7057668446
Rred_1358 vout.$227.Metal1 vout.P2.pSD 11.3856443308
Rred_1359 vout.$228.Metal1 vout.$268.Metal1 0.38426238157
Rred_1360 vout.$228.Metal1 vout.$608.Metal2 191.826093397
Rred_1361 vout.$228.Metal1 vout.$648.Metal2 9.66626661297
Rred_1362 vout.$228.Metal1 vout.$668.Metal2 28.7057668446
Rred_1363 vout.$228.Metal1 vout.P4.pSD 11.3856443308
Rred_1364 vout.$229.Metal1 vout.$269.Metal1 0.38426238157
Rred_1365 vout.$229.Metal1 vout.$610.Metal2 191.826093397
Rred_1366 vout.$229.Metal1 vout.$650.Metal2 9.66626661297
Rred_1367 vout.$229.Metal1 vout.$670.Metal2 28.7057668446
Rred_1368 vout.$229.Metal1 vout.P6.pSD 11.3856443308
Rred_1369 vout.$230.Metal1 vout.$270.Metal1 0.38426238157
Rred_1370 vout.$230.Metal1 vout.$612.Metal2 191.826093397
Rred_1371 vout.$230.Metal1 vout.$652.Metal2 9.66626661297
Rred_1372 vout.$230.Metal1 vout.$672.Metal2 28.7057668446
Rred_1373 vout.$230.Metal1 vout.P8.pSD 11.3856443308
Rred_1374 vout.$232.Metal1 vout.$272.Metal1 0.38426238157
Rred_1375 vout.$232.Metal1 vout.$616.Metal2 191.826093397
Rred_1376 vout.$232.Metal1 vout.$656.Metal2 9.66626661297
Rred_1377 vout.$232.Metal1 vout.$676.Metal2 28.7057668446
Rred_1378 vout.$232.Metal1 vout.P12.pSD 11.3856443308
Rred_1379 vout.$233.Metal1 vout.$273.Metal1 0.38426238157
Rred_1380 vout.$233.Metal1 vout.$618.Metal2 191.826093397
Rred_1381 vout.$233.Metal1 vout.$658.Metal2 9.66626661297
Rred_1382 vout.$233.Metal1 vout.$678.Metal2 28.7057668446
Rred_1383 vout.$233.Metal1 vout.P14.pSD 11.3856443308
Rred_1384 vout.$234.Metal1 vout.$274.Metal1 0.38426238157
Rred_1385 vout.$234.Metal1 vout.$620.Metal2 191.826093397
Rred_1386 vout.$234.Metal1 vout.$660.Metal2 9.66626661297
Rred_1387 vout.$234.Metal1 vout.$680.Metal2 28.7057668446
Rred_1388 vout.$234.Metal1 vout.P16.pSD 11.3856443308
Rred_1389 vout.$235.Metal1 vout.$275.Metal1 0.38426238157
Rred_1390 vout.$235.Metal1 vout.$622.Metal2 191.826093397
Rred_1391 vout.$235.Metal1 vout.$662.Metal2 9.66626661297
Rred_1392 vout.$235.Metal1 vout.$682.Metal2 28.7057668446
Rred_1393 vout.$235.Metal1 vout.P18.pSD 11.3856443308
Rred_1394 vout.$251.Metal1 vout.$291.Metal1 0.38732542701
Rred_1395 vout.$251.Metal1 vout.$634.Metal2 189.705060776
Rred_1396 vout.$251.Metal1 vout.$654.Metal2 14.8626230548
Rred_1397 vout.$251.Metal1 vout.$674.Metal2 11.0544675569
Rred_1398 vout.$251.Metal1 vout.$694.Metal2 35.9727300761
Rred_1399 vout.$251.Metal1 vout.P10.pSD 8.53455490918
Rred_1400 vout.$266.Metal1 vout.$286.Metal1 0.192205668934
Rred_1401 vout.$266.Metal1 vout.$644.Metal2 82.5290796781
Rred_1402 vout.$266.Metal1 vout.$664.Metal2 13.3824727938
Rred_1403 vout.$266.Metal1 vout.$684.Metal2 17.851042471
Rred_1404 vout.$266.Metal1 vout.P0.pSD 11.3901835074
Rred_1405 vout.$267.Metal1 vout.$287.Metal1 0.192205668934
Rred_1406 vout.$267.Metal1 vout.$646.Metal2 82.5290796781
Rred_1407 vout.$267.Metal1 vout.$666.Metal2 13.3824727938
Rred_1408 vout.$267.Metal1 vout.$686.Metal2 17.851042471
Rred_1409 vout.$267.Metal1 vout.P2.pSD 11.3901835074
Rred_1410 vout.$268.Metal1 vout.$288.Metal1 0.192205668934
Rred_1411 vout.$268.Metal1 vout.$648.Metal2 82.5290796781
Rred_1412 vout.$268.Metal1 vout.$668.Metal2 13.3824727938
Rred_1413 vout.$268.Metal1 vout.$688.Metal2 17.851042471
Rred_1414 vout.$268.Metal1 vout.P4.pSD 11.3901835074
Rred_1415 vout.$269.Metal1 vout.$289.Metal1 0.192205668934
Rred_1416 vout.$269.Metal1 vout.$650.Metal2 82.5290796781
Rred_1417 vout.$269.Metal1 vout.$670.Metal2 13.3824727938
Rred_1418 vout.$269.Metal1 vout.$690.Metal2 17.851042471
Rred_1419 vout.$269.Metal1 vout.P6.pSD 11.3901835074
Rred_1420 vout.$270.Metal1 vout.$290.Metal1 0.192195694381
Rred_1421 vout.$270.Metal1 vout.$652.Metal2 82.5290796781
Rred_1422 vout.$270.Metal1 vout.$672.Metal2 9.78615341297
Rred_1423 vout.$270.Metal1 vout.$712.Metal2 36.4158234955
Rred_1424 vout.$270.Metal1 vout.P8.pSD 11.3901835074
Rred_1425 vout.$272.Metal1 vout.$292.Metal1 0.192205668934
Rred_1426 vout.$272.Metal1 vout.$656.Metal2 82.5290796781
Rred_1427 vout.$272.Metal1 vout.$676.Metal2 13.3824727938
Rred_1428 vout.$272.Metal1 vout.$696.Metal2 17.851042471
Rred_1429 vout.$272.Metal1 vout.P12.pSD 11.3901835074
Rred_1430 vout.$273.Metal1 vout.$293.Metal1 0.192195694381
Rred_1431 vout.$273.Metal1 vout.$658.Metal2 82.5290796781
Rred_1432 vout.$273.Metal1 vout.$678.Metal2 9.78615341297
Rred_1433 vout.$273.Metal1 vout.$718.Metal2 36.4158234955
Rred_1434 vout.$273.Metal1 vout.P14.pSD 11.3901835074
Rred_1435 vout.$274.Metal1 vout.$294.Metal1 0.192205668934
Rred_1436 vout.$274.Metal1 vout.$660.Metal2 82.5290796781
Rred_1437 vout.$274.Metal1 vout.$680.Metal2 13.3824727938
Rred_1438 vout.$274.Metal1 vout.$700.Metal2 17.851042471
Rred_1439 vout.$274.Metal1 vout.P16.pSD 11.3901835074
Rred_1440 vout.$275.Metal1 vout.$295.Metal1 0.192195694381
Rred_1441 vout.$275.Metal1 vout.$662.Metal2 82.5290796781
Rred_1442 vout.$275.Metal1 vout.$682.Metal2 9.78615341297
Rred_1443 vout.$275.Metal1 vout.$722.Metal2 36.4158234955
Rred_1444 vout.$275.Metal1 vout.P18.pSD 11.3901835074
Rred_1445 vout.$286.Metal1 vout.$326.Metal1 0.384307606624
Rred_1446 vout.$286.Metal1 vout.$684.Metal2 18.3469047619
Rred_1447 vout.$286.Metal1 vout.$704.Metal2 13.2451091915
Rred_1448 vout.$286.Metal1 vout.$724.Metal2 77.6835696811
Rred_1449 vout.$286.Metal1 vout.P0.pSD 11.3900355644
Rred_1450 vout.$287.Metal1 vout.$327.Metal1 0.384307606624
Rred_1451 vout.$287.Metal1 vout.$686.Metal2 18.3469047619
Rred_1452 vout.$287.Metal1 vout.$706.Metal2 13.2451091915
Rred_1453 vout.$287.Metal1 vout.$726.Metal2 77.6835696811
Rred_1454 vout.$287.Metal1 vout.P2.pSD 11.3900355644
Rred_1455 vout.$288.Metal1 vout.$328.Metal1 0.384307606624
Rred_1456 vout.$288.Metal1 vout.$688.Metal2 18.3469047619
Rred_1457 vout.$288.Metal1 vout.$708.Metal2 13.2451091915
Rred_1458 vout.$288.Metal1 vout.$728.Metal2 77.6835696811
Rred_1459 vout.$288.Metal1 vout.P4.pSD 11.3900355644
Rred_1460 vout.$289.Metal1 vout.$329.Metal1 0.384307606624
Rred_1461 vout.$289.Metal1 vout.$690.Metal2 18.3469047619
Rred_1462 vout.$289.Metal1 vout.$710.Metal2 13.2451091915
Rred_1463 vout.$289.Metal1 vout.$730.Metal2 77.6835696811
Rred_1464 vout.$289.Metal1 vout.P6.pSD 11.3900355644
Rred_1465 vout.$290.Metal1 vout.$330.Metal1 0.384307606624
Rred_1466 vout.$290.Metal1 vout.$672.Metal2 37.4273741482
Rred_1467 vout.$290.Metal1 vout.$712.Metal2 9.78301485682
Rred_1468 vout.$290.Metal1 vout.$732.Metal2 77.6835696811
Rred_1469 vout.$290.Metal1 vout.P8.pSD 11.3900355644
Rred_1470 vout.$291.Metal1 vout.$331.Metal1 0.384307606624
Rred_1471 vout.$291.Metal1 vout.$674.Metal2 51.1919620314
Rred_1472 vout.$291.Metal1 vout.$694.Metal2 12.208498315
Rred_1473 vout.$291.Metal1 vout.$714.Metal2 13.2451091915
Rred_1474 vout.$291.Metal1 vout.$734.Metal2 77.6835696811
Rred_1475 vout.$291.Metal1 vout.P10.pSD 8.57831421196
Rred_1476 vout.$292.Metal1 vout.$332.Metal1 0.384307606624
Rred_1477 vout.$292.Metal1 vout.$696.Metal2 18.3469047619
Rred_1478 vout.$292.Metal1 vout.$716.Metal2 13.2451091915
Rred_1479 vout.$292.Metal1 vout.$736.Metal2 77.6835696811
Rred_1480 vout.$292.Metal1 vout.P12.pSD 11.3900355644
Rred_1481 vout.$293.Metal1 vout.$333.Metal1 0.384307606624
Rred_1482 vout.$293.Metal1 vout.$678.Metal2 37.4273741482
Rred_1483 vout.$293.Metal1 vout.$718.Metal2 9.78301485682
Rred_1484 vout.$293.Metal1 vout.$738.Metal2 77.6835696811
Rred_1485 vout.$293.Metal1 vout.P14.pSD 11.3900355644
Rred_1486 vout.$294.Metal1 vout.$334.Metal1 0.384307606624
Rred_1487 vout.$294.Metal1 vout.$700.Metal2 18.3469047619
Rred_1488 vout.$294.Metal1 vout.$720.Metal2 13.2451091915
Rred_1489 vout.$294.Metal1 vout.$740.Metal2 77.6835696811
Rred_1490 vout.$294.Metal1 vout.P16.pSD 11.3900355644
Rred_1491 vout.$295.Metal1 vout.$335.Metal1 0.384307606624
Rred_1492 vout.$295.Metal1 vout.$682.Metal2 37.4273741482
Rred_1493 vout.$295.Metal1 vout.$722.Metal2 9.78301485682
Rred_1494 vout.$295.Metal1 vout.$742.Metal2 77.6835696811
Rred_1495 vout.$295.Metal1 vout.P18.pSD 11.3900355644
Rred_1496 vout.$326.Metal1 vout.$346.Metal1 0.191582903712
Rred_1497 vout.$326.Metal1 vout.$704.Metal2 29.347126324
Rred_1498 vout.$326.Metal1 vout.$724.Metal2 9.67111776757
Rred_1499 vout.$326.Metal1 vout.$764.Metal2 167.886188518
Rred_1500 vout.$326.Metal1 vout.P0.pSD 11.3857994955
Rred_1501 vout.$327.Metal1 vout.$347.Metal1 0.191582903712
Rred_1502 vout.$327.Metal1 vout.$706.Metal2 29.347126324
Rred_1503 vout.$327.Metal1 vout.$726.Metal2 9.67111776757
Rred_1504 vout.$327.Metal1 vout.$766.Metal2 167.886188518
Rred_1505 vout.$327.Metal1 vout.P2.pSD 11.3857994955
Rred_1506 vout.$328.Metal1 vout.$348.Metal1 0.191582903712
Rred_1507 vout.$328.Metal1 vout.$708.Metal2 29.347126324
Rred_1508 vout.$328.Metal1 vout.$728.Metal2 9.67111776757
Rred_1509 vout.$328.Metal1 vout.$768.Metal2 167.886188518
Rred_1510 vout.$328.Metal1 vout.P4.pSD 11.3857994955
Rred_1511 vout.$329.Metal1 vout.$349.Metal1 0.191582903712
Rred_1512 vout.$329.Metal1 vout.$710.Metal2 29.347126324
Rred_1513 vout.$329.Metal1 vout.$730.Metal2 9.67111776757
Rred_1514 vout.$329.Metal1 vout.$770.Metal2 167.886188518
Rred_1515 vout.$329.Metal1 vout.P6.pSD 11.3857994955
Rred_1516 vout.$330.Metal1 vout.$350.Metal1 0.191582903712
Rred_1517 vout.$330.Metal1 vout.$712.Metal2 29.347126324
Rred_1518 vout.$330.Metal1 vout.$732.Metal2 9.67111776757
Rred_1519 vout.$330.Metal1 vout.$772.Metal2 167.886188518
Rred_1520 vout.$330.Metal1 vout.P8.pSD 11.3857994955
Rred_1521 vout.$331.Metal1 vout.$351.Metal1 0.191582903712
Rred_1522 vout.$331.Metal1 vout.$714.Metal2 29.347126324
Rred_1523 vout.$331.Metal1 vout.$734.Metal2 9.67111776757
Rred_1524 vout.$331.Metal1 vout.$774.Metal2 167.886188518
Rred_1525 vout.$331.Metal1 vout.P10.pSD 11.3857994955
Rred_1526 vout.$332.Metal1 vout.$352.Metal1 0.191582903712
Rred_1527 vout.$332.Metal1 vout.$716.Metal2 29.347126324
Rred_1528 vout.$332.Metal1 vout.$736.Metal2 9.67111776757
Rred_1529 vout.$332.Metal1 vout.$776.Metal2 167.886188518
Rred_1530 vout.$332.Metal1 vout.P12.pSD 11.3857994955
Rred_1531 vout.$333.Metal1 vout.$353.Metal1 0.191582903712
Rred_1532 vout.$333.Metal1 vout.$718.Metal2 29.347126324
Rred_1533 vout.$333.Metal1 vout.$738.Metal2 9.67111776757
Rred_1534 vout.$333.Metal1 vout.$778.Metal2 167.886188518
Rred_1535 vout.$333.Metal1 vout.P14.pSD 11.3857994955
Rred_1536 vout.$334.Metal1 vout.$354.Metal1 0.191582903712
Rred_1537 vout.$334.Metal1 vout.$720.Metal2 29.347126324
Rred_1538 vout.$334.Metal1 vout.$740.Metal2 9.67111776757
Rred_1539 vout.$334.Metal1 vout.$780.Metal2 167.886188518
Rred_1540 vout.$334.Metal1 vout.P16.pSD 11.3857994955
Rred_1541 vout.$335.Metal1 vout.$355.Metal1 0.191586797682
Rred_1542 vout.$335.Metal1 vout.$722.Metal2 29.347126324
Rred_1543 vout.$335.Metal1 vout.$742.Metal2 10.2622783848
Rred_1544 vout.$335.Metal1 vout.$762.Metal2 82.2952380951
Rred_1545 vout.$335.Metal1 vout.P18.pSD 11.3857994955
Rred_1546 vout.$346.Metal1 vout.$396.Metal1 0.589428843203
Rred_1547 vout.$346.Metal1 vout.$724.Metal2 20.66291551
Rred_1548 vout.$346.Metal1 vout.$764.Metal2 8.36164879815
Rred_1549 vout.$346.Metal1 vout.$784.Metal2 33.7581973834
Rred_1550 vout.$346.Metal1 vout.P0.pSD 8.62442107941
Rred_1551 vout.$347.Metal1 vout.$397.Metal1 0.589428843203
Rred_1552 vout.$347.Metal1 vout.$726.Metal2 20.66291551
Rred_1553 vout.$347.Metal1 vout.$766.Metal2 8.36164879815
Rred_1554 vout.$347.Metal1 vout.$786.Metal2 33.7581973834
Rred_1555 vout.$347.Metal1 vout.P2.pSD 8.62442107941
Rred_1556 vout.$348.Metal1 vout.$398.Metal1 0.589428843203
Rred_1557 vout.$348.Metal1 vout.$728.Metal2 20.66291551
Rred_1558 vout.$348.Metal1 vout.$768.Metal2 8.36164879815
Rred_1559 vout.$348.Metal1 vout.$788.Metal2 33.7581973834
Rred_1560 vout.$348.Metal1 vout.P4.pSD 8.62442107941
Rred_1561 vout.$349.Metal1 vout.$399.Metal1 0.589428843203
Rred_1562 vout.$349.Metal1 vout.$730.Metal2 20.66291551
Rred_1563 vout.$349.Metal1 vout.$770.Metal2 8.36164879815
Rred_1564 vout.$349.Metal1 vout.$790.Metal2 33.7581973834
Rred_1565 vout.$349.Metal1 vout.P6.pSD 8.62442107941
Rred_1566 vout.$350.Metal1 vout.$400.Metal1 0.589428843203
Rred_1567 vout.$350.Metal1 vout.$732.Metal2 20.66291551
Rred_1568 vout.$350.Metal1 vout.$772.Metal2 8.36164879815
Rred_1569 vout.$350.Metal1 vout.$792.Metal2 33.7581973834
Rred_1570 vout.$350.Metal1 vout.P8.pSD 8.62442107941
Rred_1571 vout.$351.Metal1 vout.$401.Metal1 0.589428843203
Rred_1572 vout.$351.Metal1 vout.$734.Metal2 20.66291551
Rred_1573 vout.$351.Metal1 vout.$774.Metal2 8.36164879815
Rred_1574 vout.$351.Metal1 vout.$794.Metal2 33.7581973834
Rred_1575 vout.$351.Metal1 vout.P10.pSD 8.62442107941
Rred_1576 vout.$352.Metal1 vout.$402.Metal1 0.589428843203
Rred_1577 vout.$352.Metal1 vout.$736.Metal2 20.66291551
Rred_1578 vout.$352.Metal1 vout.$776.Metal2 8.36164879815
Rred_1579 vout.$352.Metal1 vout.$796.Metal2 33.7581973834
Rred_1580 vout.$352.Metal1 vout.P12.pSD 8.62442107941
Rred_1581 vout.$353.Metal1 vout.$403.Metal1 0.589428843203
Rred_1582 vout.$353.Metal1 vout.$738.Metal2 20.66291551
Rred_1583 vout.$353.Metal1 vout.$778.Metal2 8.36164879815
Rred_1584 vout.$353.Metal1 vout.$798.Metal2 33.7581973834
Rred_1585 vout.$353.Metal1 vout.P14.pSD 8.62442107941
Rred_1586 vout.$354.Metal1 vout.$404.Metal1 0.589428843203
Rred_1587 vout.$354.Metal1 vout.$740.Metal2 20.66291551
Rred_1588 vout.$354.Metal1 vout.$780.Metal2 8.36164879815
Rred_1589 vout.$354.Metal1 vout.$800.Metal2 33.7581973834
Rred_1590 vout.$354.Metal1 vout.P16.pSD 8.62442107941
Rred_1591 vout.$355.Metal1 vout.$405.Metal1 0.589428843203
Rred_1592 vout.$355.Metal1 vout.$762.Metal2 10.1286446886
Rred_1593 vout.$355.Metal1 vout.$782.Metal2 14.0453862751
Rred_1594 vout.$355.Metal1 vout.$802.Metal2 33.7581973834
Rred_1595 vout.$355.Metal1 vout.P18.pSD 8.62442107941
Rred_1596 vout.$396.Metal1 vout.$764.Metal2 27.3377293211
Rred_1597 vout.$396.Metal1 vout.$784.Metal2 5.4106819922
Rred_1598 vout.$396.Metal1 vout.P0.pSD 8.62937340344
Rred_1599 vout.$397.Metal1 vout.$766.Metal2 27.3377293211
Rred_1600 vout.$397.Metal1 vout.$786.Metal2 5.4106819922
Rred_1601 vout.$397.Metal1 vout.P2.pSD 8.62937340344
Rred_1602 vout.$398.Metal1 vout.$768.Metal2 27.3377293211
Rred_1603 vout.$398.Metal1 vout.$788.Metal2 5.4106819922
Rred_1604 vout.$398.Metal1 vout.P4.pSD 8.62937340344
Rred_1605 vout.$399.Metal1 vout.$770.Metal2 27.3377293211
Rred_1606 vout.$399.Metal1 vout.$790.Metal2 5.4106819922
Rred_1607 vout.$399.Metal1 vout.P6.pSD 8.62937340344
Rred_1608 vout.$400.Metal1 vout.$772.Metal2 27.3377293211
Rred_1609 vout.$400.Metal1 vout.$792.Metal2 5.4106819922
Rred_1610 vout.$400.Metal1 vout.P8.pSD 8.62937340344
Rred_1611 vout.$401.Metal1 vout.$774.Metal2 27.3377293211
Rred_1612 vout.$401.Metal1 vout.$794.Metal2 5.4106819922
Rred_1613 vout.$401.Metal1 vout.P10.pSD 8.62937340344
Rred_1614 vout.$402.Metal1 vout.$776.Metal2 27.3377293211
Rred_1615 vout.$402.Metal1 vout.$796.Metal2 5.4106819922
Rred_1616 vout.$402.Metal1 vout.P12.pSD 8.62937340344
Rred_1617 vout.$403.Metal1 vout.$778.Metal2 27.3377293211
Rred_1618 vout.$403.Metal1 vout.$798.Metal2 5.4106819922
Rred_1619 vout.$403.Metal1 vout.P14.pSD 8.62937340344
Rred_1620 vout.$404.Metal1 vout.$780.Metal2 27.3633079929
Rred_1621 vout.$404.Metal1 vout.$800.Metal2 5.41461557858
Rred_1622 vout.$404.Metal1 vout.P16.pSD 8.62937340344
Rred_1623 vout.$405.Metal1 vout.$782.Metal2 27.3633079929
Rred_1624 vout.$405.Metal1 vout.$802.Metal2 5.41246762867
Rred_1625 vout.$405.Metal1 vout.P18.pSD 8.62937340344
Rred_1626 vout.$436.Metal2 vout.$456.Metal2 0.180378909705
Rred_1627 vout.$436.Metal2 vout.$61.Metal1 36.8629539855
Rred_1628 vout.$436.Metal2 vout.$864.Metal3 5.03124294697
Rred_1629 vout.$436.Metal2 vout.P0.nSD 1080.97583806
Rred_1630 vout.$438.Metal2 vout.$458.Metal2 0.180262726022
Rred_1631 vout.$438.Metal2 vout.$62.Metal1 36.8629539855
Rred_1632 vout.$438.Metal2 vout.$886.Metal3 5.60971213539
Rred_1633 vout.$438.Metal2 vout.P2.nSD 1080.97583806
Rred_1634 vout.$440.Metal2 vout.$460.Metal2 0.180262726022
Rred_1635 vout.$440.Metal2 vout.$63.Metal1 36.8629539855
Rred_1636 vout.$440.Metal2 vout.$888.Metal3 5.60971213539
Rred_1637 vout.$440.Metal2 vout.P4.nSD 1080.97583806
Rred_1638 vout.$442.Metal2 vout.$462.Metal2 0.180262726022
Rred_1639 vout.$442.Metal2 vout.$64.Metal1 36.8629539855
Rred_1640 vout.$442.Metal2 vout.$890.Metal3 5.60971213539
Rred_1641 vout.$442.Metal2 vout.P6.nSD 1080.97583806
Rred_1642 vout.$444.Metal2 vout.$464.Metal2 0.180262726022
Rred_1643 vout.$444.Metal2 vout.$65.Metal1 36.8629539855
Rred_1644 vout.$444.Metal2 vout.$892.Metal3 5.60971213539
Rred_1645 vout.$444.Metal2 vout.P8.nSD 1080.97583806
Rred_1646 vout.$446.Metal2 vout.$466.Metal2 0.180262726022
Rred_1647 vout.$446.Metal2 vout.$66.Metal1 36.8629539855
Rred_1648 vout.$446.Metal2 vout.$894.Metal3 5.60971213539
Rred_1649 vout.$446.Metal2 vout.P10.nSD 1080.97583806
Rred_1650 vout.$448.Metal2 vout.$468.Metal2 0.180262726022
Rred_1651 vout.$448.Metal2 vout.$67.Metal1 36.8629539855
Rred_1652 vout.$448.Metal2 vout.$896.Metal3 5.60971213539
Rred_1653 vout.$448.Metal2 vout.P12.nSD 1080.97583806
Rred_1654 vout.$450.Metal2 vout.$470.Metal2 0.180378909705
Rred_1655 vout.$450.Metal2 vout.$68.Metal1 36.8629539855
Rred_1656 vout.$450.Metal2 vout.$858.Metal3 4.67562697816
Rred_1657 vout.$450.Metal2 vout.P14.nSD 1080.97583806
Rred_1658 vout.$452.Metal2 vout.$472.Metal2 0.180378909705
Rred_1659 vout.$452.Metal2 vout.$69.Metal1 36.8629539855
Rred_1660 vout.$452.Metal2 vout.$860.Metal3 4.67524464256
Rred_1661 vout.$452.Metal2 vout.P16.nSD 1080.97583806
Rred_1662 vout.$454.Metal2 vout.$474.Metal2 0.180378909705
Rred_1663 vout.$454.Metal2 vout.$70.Metal1 36.8629539855
Rred_1664 vout.$454.Metal2 vout.$862.Metal3 4.67546108849
Rred_1665 vout.$454.Metal2 vout.P18.nSD 1080.97583806
Rred_1666 vout.$456.Metal2 vout.$476.Metal2 0.1804
Rred_1667 vout.$456.Metal2 vout.$61.Metal1 14.7379363825
Rred_1668 vout.$456.Metal2 vout.$864.Metal3 9
Rred_1669 vout.$456.Metal2 vout.P0.nSD 820.807297694
Rred_1670 vout.$458.Metal2 vout.$498.Metal2 0.368032035556
Rred_1671 vout.$458.Metal2 vout.$62.Metal1 8.17554782771
Rred_1672 vout.$458.Metal2 vout.$886.Metal3 6.47992893904
Rred_1673 vout.$458.Metal2 vout.P2.nSD 820.807297694
Rred_1674 vout.$460.Metal2 vout.$500.Metal2 0.368032035556
Rred_1675 vout.$460.Metal2 vout.$63.Metal1 8.17554782771
Rred_1676 vout.$460.Metal2 vout.$888.Metal3 6.47992893904
Rred_1677 vout.$460.Metal2 vout.P4.nSD 820.807297694
Rred_1678 vout.$462.Metal2 vout.$502.Metal2 0.368032035556
Rred_1679 vout.$462.Metal2 vout.$64.Metal1 8.17554782771
Rred_1680 vout.$462.Metal2 vout.$890.Metal3 6.47992893904
Rred_1681 vout.$462.Metal2 vout.P6.nSD 820.807297694
Rred_1682 vout.$464.Metal2 vout.$504.Metal2 0.368032035556
Rred_1683 vout.$464.Metal2 vout.$65.Metal1 8.17554782771
Rred_1684 vout.$464.Metal2 vout.$892.Metal3 6.47992893904
Rred_1685 vout.$464.Metal2 vout.P8.nSD 820.807297694
Rred_1686 vout.$466.Metal2 vout.$506.Metal2 0.368032035556
Rred_1687 vout.$466.Metal2 vout.$66.Metal1 8.17554782771
Rred_1688 vout.$466.Metal2 vout.$894.Metal3 6.47992893904
Rred_1689 vout.$466.Metal2 vout.P10.nSD 820.807297694
Rred_1690 vout.$468.Metal2 vout.$508.Metal2 0.368032035556
Rred_1691 vout.$468.Metal2 vout.$67.Metal1 8.17554782771
Rred_1692 vout.$468.Metal2 vout.$896.Metal3 6.47992893904
Rred_1693 vout.$468.Metal2 vout.P12.nSD 820.807297694
Rred_1694 vout.$470.Metal2 vout.$510.Metal2 0.368032035556
Rred_1695 vout.$470.Metal2 vout.$68.Metal1 8.17554782771
Rred_1696 vout.$470.Metal2 vout.$858.Metal3 18.3608
Rred_1697 vout.$470.Metal2 vout.$898.Metal3 9.1804
Rred_1698 vout.$470.Metal2 vout.P14.nSD 820.807297694
Rred_1699 vout.$472.Metal2 vout.$512.Metal2 0.368032035556
Rred_1700 vout.$472.Metal2 vout.$69.Metal1 8.17554782771
Rred_1701 vout.$472.Metal2 vout.$860.Metal3 18.3608
Rred_1702 vout.$472.Metal2 vout.$900.Metal3 9.1804
Rred_1703 vout.$472.Metal2 vout.P16.nSD 820.807297694
Rred_1704 vout.$474.Metal2 vout.$514.Metal2 0.368032035556
Rred_1705 vout.$474.Metal2 vout.$70.Metal1 8.17554782771
Rred_1706 vout.$474.Metal2 vout.$862.Metal3 18.3608
Rred_1707 vout.$474.Metal2 vout.$902.Metal3 9.1804
Rred_1708 vout.$474.Metal2 vout.P18.nSD 820.807297694
Rred_1709 vout.$476.Metal2 vout.$496.Metal2 0.1804
Rred_1710 vout.$476.Metal2 vout.$61.Metal1 9
Rred_1711 vout.$476.Metal2 vout.$864.Metal3 18.3608
Rred_1712 vout.$476.Metal2 vout.$904.Metal3 18.3608
Rred_1713 vout.$496.Metal2 vout.$516.Metal2 0.180378912217
Rred_1714 vout.$496.Metal2 vout.$61.Metal1 14.7377604585
Rred_1715 vout.$496.Metal2 vout.$904.Metal3 9
Rred_1716 vout.$496.Metal2 vout.P0.nSD 817.999377695
Rred_1717 vout.$498.Metal2 vout.$518.Metal2 0.180261718607
Rred_1718 vout.$498.Metal2 vout.$62.Metal1 8.1754936915
Rred_1719 vout.$498.Metal2 vout.$886.Metal3 6.46324815475
Rred_1720 vout.$498.Metal2 vout.P2.nSD 817.999377695
Rred_1721 vout.$500.Metal2 vout.$520.Metal2 0.180261718607
Rred_1722 vout.$500.Metal2 vout.$63.Metal1 8.1754936915
Rred_1723 vout.$500.Metal2 vout.$888.Metal3 6.46324815475
Rred_1724 vout.$500.Metal2 vout.P4.nSD 817.999377695
Rred_1725 vout.$502.Metal2 vout.$522.Metal2 0.180261718607
Rred_1726 vout.$502.Metal2 vout.$64.Metal1 8.1754936915
Rred_1727 vout.$502.Metal2 vout.$890.Metal3 6.46324815475
Rred_1728 vout.$502.Metal2 vout.P6.nSD 817.999377695
Rred_1729 vout.$504.Metal2 vout.$524.Metal2 0.180261718607
Rred_1730 vout.$504.Metal2 vout.$65.Metal1 8.1754936915
Rred_1731 vout.$504.Metal2 vout.$892.Metal3 6.46324815475
Rred_1732 vout.$504.Metal2 vout.P8.nSD 817.999377695
Rred_1733 vout.$506.Metal2 vout.$526.Metal2 0.180378912217
Rred_1734 vout.$506.Metal2 vout.$66.Metal1 8.1754936915
Rred_1735 vout.$506.Metal2 vout.$894.Metal3 9.1804
Rred_1736 vout.$506.Metal2 vout.$934.Metal3 18.3608
Rred_1737 vout.$506.Metal2 vout.P10.nSD 817.999377695
Rred_1738 vout.$508.Metal2 vout.$528.Metal2 0.180378912217
Rred_1739 vout.$508.Metal2 vout.$67.Metal1 8.1754936915
Rred_1740 vout.$508.Metal2 vout.$896.Metal3 9.1804
Rred_1741 vout.$508.Metal2 vout.$936.Metal3 18.3608
Rred_1742 vout.$508.Metal2 vout.P12.nSD 817.999377695
Rred_1743 vout.$510.Metal2 vout.$530.Metal2 0.180378912217
Rred_1744 vout.$510.Metal2 vout.$68.Metal1 8.1754936915
Rred_1745 vout.$510.Metal2 vout.$898.Metal3 9.1804
Rred_1746 vout.$510.Metal2 vout.$938.Metal3 18.3608
Rred_1747 vout.$510.Metal2 vout.P14.nSD 817.999377695
Rred_1748 vout.$512.Metal2 vout.$532.Metal2 0.180378912217
Rred_1749 vout.$512.Metal2 vout.$69.Metal1 8.1754936915
Rred_1750 vout.$512.Metal2 vout.$900.Metal3 9.1804
Rred_1751 vout.$512.Metal2 vout.$940.Metal3 18.3608
Rred_1752 vout.$512.Metal2 vout.P16.nSD 817.999377695
Rred_1753 vout.$514.Metal2 vout.$534.Metal2 0.180378912217
Rred_1754 vout.$514.Metal2 vout.$70.Metal1 8.1754936915
Rred_1755 vout.$514.Metal2 vout.$902.Metal3 9.1804
Rred_1756 vout.$514.Metal2 vout.$942.Metal3 18.3608
Rred_1757 vout.$514.Metal2 vout.P18.nSD 817.999377695
Rred_1758 vout.$516.Metal2 vout.$61.Metal1 36.8628478103
Rred_1759 vout.$516.Metal2 vout.$904.Metal3 5.01807384201
Rred_1760 vout.$516.Metal2 vout.P0.nSD 1071.12549178
Rred_1761 vout.$518.Metal2 vout.$62.Metal1 36.8628478103
Rred_1762 vout.$518.Metal2 vout.$886.Metal3 5.56133892572
Rred_1763 vout.$518.Metal2 vout.P2.nSD 1071.12549178
Rred_1764 vout.$520.Metal2 vout.$63.Metal1 36.8628478103
Rred_1765 vout.$520.Metal2 vout.$888.Metal3 5.56133892572
Rred_1766 vout.$520.Metal2 vout.P4.nSD 1071.12549178
Rred_1767 vout.$522.Metal2 vout.$64.Metal1 36.8628478103
Rred_1768 vout.$522.Metal2 vout.$890.Metal3 5.56133892572
Rred_1769 vout.$522.Metal2 vout.P6.nSD 1071.12549178
Rred_1770 vout.$524.Metal2 vout.$65.Metal1 36.8628478103
Rred_1771 vout.$524.Metal2 vout.$892.Metal3 5.56133892572
Rred_1772 vout.$524.Metal2 vout.P8.nSD 1071.12549178
Rred_1773 vout.$526.Metal2 vout.$66.Metal1 36.8628478103
Rred_1774 vout.$526.Metal2 vout.$934.Metal3 4.67562697816
Rred_1775 vout.$526.Metal2 vout.P10.nSD 1071.12549178
Rred_1776 vout.$528.Metal2 vout.$67.Metal1 36.8628478103
Rred_1777 vout.$528.Metal2 vout.$936.Metal3 4.67562697816
Rred_1778 vout.$528.Metal2 vout.P12.nSD 1071.12549178
Rred_1779 vout.$530.Metal2 vout.$68.Metal1 36.8628478103
Rred_1780 vout.$530.Metal2 vout.$938.Metal3 4.67562697816
Rred_1781 vout.$530.Metal2 vout.P14.nSD 1071.12549178
Rred_1782 vout.$532.Metal2 vout.$69.Metal1 36.8628478103
Rred_1783 vout.$532.Metal2 vout.$940.Metal3 4.67562697816
Rred_1784 vout.$532.Metal2 vout.P16.nSD 1071.12549178
Rred_1785 vout.$534.Metal2 vout.$70.Metal1 36.8628478103
Rred_1786 vout.$534.Metal2 vout.$942.Metal3 4.67562697816
Rred_1787 vout.$534.Metal2 vout.P18.nSD 1071.12549178
Rred_1788 vout.$584.Metal2 vout.$604.Metal2 0.180262448049
Rred_1789 vout.$584.Metal2 vout.P0.pSD 1008.61703649
Rred_1790 vout.$586.Metal2 vout.$606.Metal2 0.180262448049
Rred_1791 vout.$586.Metal2 vout.P2.pSD 1008.61703649
Rred_1792 vout.$588.Metal2 vout.$608.Metal2 0.180262448049
Rred_1793 vout.$588.Metal2 vout.P4.pSD 1008.61703649
Rred_1794 vout.$590.Metal2 vout.$610.Metal2 0.180262448049
Rred_1795 vout.$590.Metal2 vout.P6.pSD 1008.61703649
Rred_1796 vout.$592.Metal2 vout.$612.Metal2 0.180262448049
Rred_1797 vout.$592.Metal2 vout.P8.pSD 1008.61703649
Rred_1798 vout.$594.Metal2 vout.$614.Metal2 0.180379054418
Rred_1799 vout.$594.Metal2 vout.P10.pSD 1008.61703649
Rred_1800 vout.$596.Metal2 vout.$616.Metal2 0.180379054418
Rred_1801 vout.$596.Metal2 vout.P12.pSD 1008.61703649
Rred_1802 vout.$598.Metal2 vout.$618.Metal2 0.180379054418
Rred_1803 vout.$598.Metal2 vout.P14.pSD 1008.61703649
Rred_1804 vout.$600.Metal2 vout.$620.Metal2 0.180379054418
Rred_1805 vout.$600.Metal2 vout.P16.pSD 1008.61703649
Rred_1806 vout.$602.Metal2 vout.$622.Metal2 0.180379054418
Rred_1807 vout.$602.Metal2 vout.P18.pSD 1008.61703649
Rred_1808 vout.$604.Metal2 vout.$644.Metal2 0.368025388161
Rred_1809 vout.$604.Metal2 vout.P0.pSD 832.064754456
Rred_1810 vout.$606.Metal2 vout.$646.Metal2 0.368025388161
Rred_1811 vout.$606.Metal2 vout.P2.pSD 832.064754456
Rred_1812 vout.$608.Metal2 vout.$648.Metal2 0.368025388161
Rred_1813 vout.$608.Metal2 vout.P4.pSD 832.064754456
Rred_1814 vout.$61.Metal1 vout.P0.nSD 5.77463667393
Rred_1815 vout.$610.Metal2 vout.$650.Metal2 0.368025388161
Rred_1816 vout.$610.Metal2 vout.P6.pSD 832.064754456
Rred_1817 vout.$612.Metal2 vout.$652.Metal2 0.368025388161
Rred_1818 vout.$612.Metal2 vout.P8.pSD 832.064754456
Rred_1819 vout.$614.Metal2 vout.$634.Metal2 0.1804
Rred_1820 vout.$614.Metal2 vout.P10.pSD 832.064754456
Rred_1821 vout.$616.Metal2 vout.$656.Metal2 0.368025388161
Rred_1822 vout.$616.Metal2 vout.P12.pSD 832.064754456
Rred_1823 vout.$618.Metal2 vout.$658.Metal2 0.368025388161
Rred_1824 vout.$618.Metal2 vout.P14.pSD 832.064754456
Rred_1825 vout.$62.Metal1 vout.$886.Metal3 916.00443459
Rred_1826 vout.$62.Metal1 vout.P2.nSD 5.77463667393
Rred_1827 vout.$620.Metal2 vout.$660.Metal2 0.368025388161
Rred_1828 vout.$620.Metal2 vout.P16.pSD 832.064754456
Rred_1829 vout.$622.Metal2 vout.$662.Metal2 0.368025388161
Rred_1830 vout.$622.Metal2 vout.P18.pSD 832.064754456
Rred_1831 vout.$63.Metal1 vout.$888.Metal3 916.00443459
Rred_1832 vout.$63.Metal1 vout.P4.nSD 5.77463667393
Rred_1833 vout.$634.Metal2 vout.$654.Metal2 0.180397204392
Rred_1834 vout.$634.Metal2 vout.P10.pSD 17040.4882507
Rred_1835 vout.$64.Metal1 vout.$890.Metal3 916.00443459
Rred_1836 vout.$64.Metal1 vout.P6.nSD 5.77463667393
Rred_1837 vout.$644.Metal2 vout.$664.Metal2 0.180394721481
Rred_1838 vout.$644.Metal2 vout.P0.pSD 7404.32963091
Rred_1839 vout.$646.Metal2 vout.$666.Metal2 0.180394721481
Rred_1840 vout.$646.Metal2 vout.P2.pSD 7404.32963091
Rred_1841 vout.$648.Metal2 vout.$668.Metal2 0.180394721481
Rred_1842 vout.$648.Metal2 vout.P4.pSD 7404.32963091
Rred_1843 vout.$65.Metal1 vout.$892.Metal3 916.00443459
Rred_1844 vout.$65.Metal1 vout.P8.nSD 5.77463667393
Rred_1845 vout.$650.Metal2 vout.$670.Metal2 0.180394721481
Rred_1846 vout.$650.Metal2 vout.P6.pSD 7404.32963091
Rred_1847 vout.$652.Metal2 vout.$672.Metal2 0.180394721481
Rred_1848 vout.$652.Metal2 vout.P8.pSD 7404.32963091
Rred_1849 vout.$654.Metal2 vout.$674.Metal2 0.1804
Rred_1850 vout.$654.Metal2 vout.P10.pSD 2104.61416801
Rred_1851 vout.$656.Metal2 vout.$676.Metal2 0.180394721481
Rred_1852 vout.$656.Metal2 vout.P12.pSD 7404.32963091
Rred_1853 vout.$658.Metal2 vout.$678.Metal2 0.180394721481
Rred_1854 vout.$658.Metal2 vout.P14.pSD 7404.32963091
Rred_1855 vout.$66.Metal1 vout.$894.Metal3 916.00443459
Rred_1856 vout.$66.Metal1 vout.P10.nSD 5.77463667393
Rred_1857 vout.$660.Metal2 vout.$680.Metal2 0.180394721481
Rred_1858 vout.$660.Metal2 vout.P16.pSD 7404.32963091
Rred_1859 vout.$662.Metal2 vout.$682.Metal2 0.180394721481
Rred_1860 vout.$662.Metal2 vout.P18.pSD 7404.32963091
Rred_1861 vout.$664.Metal2 vout.$684.Metal2 0.1804
Rred_1862 vout.$664.Metal2 vout.P0.pSD 2578.53048644
Rred_1863 vout.$666.Metal2 vout.$686.Metal2 0.1804
Rred_1864 vout.$666.Metal2 vout.P2.pSD 2578.53048644
Rred_1865 vout.$668.Metal2 vout.$688.Metal2 0.1804
Rred_1866 vout.$668.Metal2 vout.P4.pSD 2578.53048644
Rred_1867 vout.$67.Metal1 vout.$896.Metal3 916.00443459
Rred_1868 vout.$67.Metal1 vout.P12.nSD 5.77463667393
Rred_1869 vout.$670.Metal2 vout.$690.Metal2 0.1804
Rred_1870 vout.$670.Metal2 vout.P6.pSD 2578.53048644
Rred_1871 vout.$672.Metal2 vout.$712.Metal2 0.368012936457
Rred_1872 vout.$672.Metal2 vout.P8.pSD 2578.53048644
Rred_1873 vout.$674.Metal2 vout.$694.Metal2 0.180393155253
Rred_1874 vout.$674.Metal2 vout.P10.pSD 4527.7715239
Rred_1875 vout.$676.Metal2 vout.$696.Metal2 0.1804
Rred_1876 vout.$676.Metal2 vout.P12.pSD 2578.53048644
Rred_1877 vout.$678.Metal2 vout.$718.Metal2 0.368012936457
Rred_1878 vout.$678.Metal2 vout.P14.pSD 2578.53048644
Rred_1879 vout.$68.Metal1 vout.$898.Metal3 916.00443459
Rred_1880 vout.$68.Metal1 vout.P14.nSD 5.77463667393
Rred_1881 vout.$680.Metal2 vout.$700.Metal2 0.1804
Rred_1882 vout.$680.Metal2 vout.P16.pSD 2578.53048644
Rred_1883 vout.$682.Metal2 vout.$722.Metal2 0.368012936457
Rred_1884 vout.$682.Metal2 vout.P18.pSD 2578.53048644
Rred_1885 vout.$684.Metal2 vout.$704.Metal2 0.1804
Rred_1886 vout.$686.Metal2 vout.$706.Metal2 0.1804
Rred_1887 vout.$688.Metal2 vout.$708.Metal2 0.1804
Rred_1888 vout.$69.Metal1 vout.$900.Metal3 916.00443459
Rred_1889 vout.$69.Metal1 vout.P16.nSD 5.77463667393
Rred_1890 vout.$690.Metal2 vout.$710.Metal2 0.1804
Rred_1891 vout.$694.Metal2 vout.$714.Metal2 0.1804
Rred_1892 vout.$694.Metal2 vout.P10.pSD 3227.3951466
Rred_1893 vout.$696.Metal2 vout.$716.Metal2 0.1804
Rred_1894 vout.$70.Metal1 vout.$902.Metal3 916.00443459
Rred_1895 vout.$70.Metal1 vout.P18.nSD 5.77463667393
Rred_1896 vout.$700.Metal2 vout.$720.Metal2 0.1804
Rred_1897 vout.$704.Metal2 vout.$724.Metal2 0.180394514148
Rred_1898 vout.$704.Metal2 vout.P0.pSD 2635.72741826
Rred_1899 vout.$706.Metal2 vout.$726.Metal2 0.180394514148
Rred_1900 vout.$706.Metal2 vout.P2.pSD 2635.72741826
Rred_1901 vout.$708.Metal2 vout.$728.Metal2 0.180394514148
Rred_1902 vout.$708.Metal2 vout.P4.pSD 2635.72741826
Rred_1903 vout.$710.Metal2 vout.$730.Metal2 0.180394514148
Rred_1904 vout.$710.Metal2 vout.P6.pSD 2635.72741826
Rred_1905 vout.$712.Metal2 vout.$732.Metal2 0.180371595645
Rred_1906 vout.$712.Metal2 vout.P8.pSD 2635.72741826
Rred_1907 vout.$714.Metal2 vout.$734.Metal2 0.180394514148
Rred_1908 vout.$714.Metal2 vout.P10.pSD 2635.72741826
Rred_1909 vout.$716.Metal2 vout.$736.Metal2 0.180394514148
Rred_1910 vout.$716.Metal2 vout.P12.pSD 2635.72741826
Rred_1911 vout.$718.Metal2 vout.$738.Metal2 0.180394514148
Rred_1912 vout.$718.Metal2 vout.P14.pSD 2635.72741826
Rred_1913 vout.$720.Metal2 vout.$740.Metal2 0.180394514148
Rred_1914 vout.$720.Metal2 vout.P16.pSD 2635.72741826
Rred_1915 vout.$722.Metal2 vout.$742.Metal2 0.180394514148
Rred_1916 vout.$722.Metal2 vout.P18.pSD 2635.72741826
Rred_1917 vout.$724.Metal2 vout.$764.Metal2 0.368024555366
Rred_1918 vout.$724.Metal2 vout.P0.pSD 6969.06840536
Rred_1919 vout.$726.Metal2 vout.$766.Metal2 0.368024555366
Rred_1920 vout.$726.Metal2 vout.P2.pSD 6969.06840536
Rred_1921 vout.$728.Metal2 vout.$768.Metal2 0.368024555366
Rred_1922 vout.$728.Metal2 vout.P4.pSD 6969.06840536
Rred_1923 vout.$730.Metal2 vout.$770.Metal2 0.368024555366
Rred_1924 vout.$730.Metal2 vout.P6.pSD 6969.06840536
Rred_1925 vout.$732.Metal2 vout.$772.Metal2 0.368024555366
Rred_1926 vout.$732.Metal2 vout.P8.pSD 6969.06840536
Rred_1927 vout.$734.Metal2 vout.$774.Metal2 0.368024555366
Rred_1928 vout.$734.Metal2 vout.P10.pSD 6969.06840536
Rred_1929 vout.$736.Metal2 vout.$776.Metal2 0.368024555366
Rred_1930 vout.$736.Metal2 vout.P12.pSD 6969.06840536
Rred_1931 vout.$738.Metal2 vout.$778.Metal2 0.368024555366
Rred_1932 vout.$738.Metal2 vout.P14.pSD 6969.06840536
Rred_1933 vout.$740.Metal2 vout.$780.Metal2 0.368024555366
Rred_1934 vout.$740.Metal2 vout.P16.pSD 6969.06840536
Rred_1935 vout.$742.Metal2 vout.$762.Metal2 0.1804
Rred_1936 vout.$742.Metal2 vout.P18.pSD 6969.06840536
Rred_1937 vout.$762.Metal2 vout.$782.Metal2 0.1804
Rred_1938 vout.$764.Metal2 vout.$784.Metal2 0.180263053343
Rred_1939 vout.$764.Metal2 vout.P0.pSD 835.901910051
Rred_1940 vout.$766.Metal2 vout.$786.Metal2 0.180263053343
Rred_1941 vout.$766.Metal2 vout.P2.pSD 835.901910051
Rred_1942 vout.$768.Metal2 vout.$788.Metal2 0.180263053343
Rred_1943 vout.$768.Metal2 vout.P4.pSD 835.901910051
Rred_1944 vout.$770.Metal2 vout.$790.Metal2 0.180263053343
Rred_1945 vout.$770.Metal2 vout.P6.pSD 835.901910051
Rred_1946 vout.$772.Metal2 vout.$792.Metal2 0.180263053343
Rred_1947 vout.$772.Metal2 vout.P8.pSD 835.901910051
Rred_1948 vout.$774.Metal2 vout.$794.Metal2 0.180263053343
Rred_1949 vout.$774.Metal2 vout.P10.pSD 835.901910051
Rred_1950 vout.$776.Metal2 vout.$796.Metal2 0.180263053343
Rred_1951 vout.$776.Metal2 vout.P12.pSD 835.901910051
Rred_1952 vout.$778.Metal2 vout.$798.Metal2 0.180263053343
Rred_1953 vout.$778.Metal2 vout.P14.pSD 835.901910051
Rred_1954 vout.$780.Metal2 vout.$800.Metal2 0.180379236211
Rred_1955 vout.$780.Metal2 vout.P16.pSD 835.901910051
Rred_1956 vout.$782.Metal2 vout.$802.Metal2 0.180379236211
Rred_1957 vout.$782.Metal2 vout.P18.pSD 835.901910051
Rred_1958 vout.$784.Metal2 vout.P0.pSD 1003.73271272
Rred_1959 vout.$786.Metal2 vout.P2.pSD 1003.73271272
Rred_1960 vout.$788.Metal2 vout.P4.pSD 1003.73271272
Rred_1961 vout.$790.Metal2 vout.P6.pSD 1003.73271272
Rred_1962 vout.$792.Metal2 vout.P8.pSD 1003.73271272
Rred_1963 vout.$794.Metal2 vout.P10.pSD 1003.73271272
Rred_1964 vout.$796.Metal2 vout.P12.pSD 1003.73271272
Rred_1965 vout.$798.Metal2 vout.P14.pSD 1003.73271272
Rred_1966 vout.$800.Metal2 vout.P16.pSD 1003.73271272
Rred_1967 vout.$802.Metal2 vout.P18.pSD 1003.73271272
Rred_1968 vout.$858.Metal3 vout.$898.Metal3 0.368032035556
Rred_1969 vout.$860.Metal3 vout.$900.Metal3 0.368032035556
Rred_1970 vout.$862.Metal3 vout.$902.Metal3 0.368032035556
Rred_1971 vout.$864.Metal3 vout.$904.Metal3 0.368032035556
Rred_1972 vout.$894.Metal3 vout.$934.Metal3 0.368032035556
Rred_1973 vout.$896.Metal3 vout.$936.Metal3 0.368032035556
Rred_1974 vout.$898.Metal3 vout.$938.Metal3 0.368032035556
Rred_1975 vout.$900.Metal3 vout.$940.Metal3 0.368032035556
Rred_1976 vout.$902.Metal3 vout.$942.Metal3 0.368032035556
Rred_1977 vref vref.P0.GatPoly 12.3471093024
Rred_1978 vref vref.P0.nSD 20.4154763749
Rred_1979 vref vref.P0.pSD 11.6477658208
Rred_1980 vref.P0.GatPoly vref.P0.nSD 523.549171057
Rred_1981 vref.P0.GatPoly vref.P0.pSD 298.703690679
Rred_1982 vref.P0.nSD vref.P0.pSD 52.105523185
Rred_1983 vss vss.$1211.Metal5 1.09085715005
Rred_1984 vss vss.$1229.Metal5 1.09085715005
Rred_1985 vss vss.$1281.Metal5 0.284983201789
Rred_1986 vss vss.$1299.Metal5 0.284983201789
Rred_1987 vss.$10.Metal1 vss.$127.Metal1 0.134556072844
Rred_1988 vss.$10.Metal1 vss.$13.Metal1 0.134538560711
Rred_1989 vss.$10.Metal1 vss.$461.Metal2 9.21369386944
Rred_1990 vss.$10.Metal1 vss.$463.Metal2 2.60867094883
Rred_1991 vss.$10.Metal1 vss.$467.Metal2 2.60638001377
Rred_1992 vss.$10.Metal1 vss.$469.Metal2 9.21269223899
Rred_1993 vss.$10.Metal1 vss.$799.Metal3 515.070113458
Rred_1994 vss.$10.Metal1 vss.P0.pSD 4.74580830545
Rred_1995 vss.$10.Metal1 vss.P1.nSD 2438.33841934
Rred_1996 vss.$1001.Metal4 vss.$1003.Metal4 0.0353725490196
Rred_1997 vss.$1001.Metal4 vss.$1211.Metal5 9
Rred_1998 vss.$1001.Metal4 vss.$1246.Metal5 9
Rred_1999 vss.$1001.Metal4 vss.$1281.Metal5 9
Rred_2000 vss.$1001.Metal4 vss.$457.Metal2 260.4345898
Rred_2001 vss.$1001.Metal4 vss.$793.Metal3 3.07074509804
Rred_2002 vss.$1003.Metal4 vss.$1005.Metal4 0.0353725490196
Rred_2003 vss.$1003.Metal4 vss.$1211.Metal5 9
Rred_2004 vss.$1003.Metal4 vss.$1246.Metal5 9
Rred_2005 vss.$1003.Metal4 vss.$1281.Metal5 9
Rred_2006 vss.$1003.Metal4 vss.$793.Metal3 3
Rred_2007 vss.$1005.Metal4 vss.$1007.Metal4 0.0353725490196
Rred_2008 vss.$1005.Metal4 vss.$1211.Metal5 9
Rred_2009 vss.$1005.Metal4 vss.$1246.Metal5 9
Rred_2010 vss.$1005.Metal4 vss.$1281.Metal5 9
Rred_2011 vss.$1005.Metal4 vss.$795.Metal3 3
Rred_2012 vss.$1007.Metal4 vss.$1009.Metal4 0.0353725490196
Rred_2013 vss.$1007.Metal4 vss.$1211.Metal5 9
Rred_2014 vss.$1007.Metal4 vss.$1246.Metal5 9
Rred_2015 vss.$1007.Metal4 vss.$1281.Metal5 9
Rred_2016 vss.$1007.Metal4 vss.$463.Metal2 514.869179601
Rred_2017 vss.$1007.Metal4 vss.$795.Metal3 6.07074509804
Rred_2018 vss.$1007.Metal4 vss.$799.Metal3 6.07074509804
Rred_2019 vss.$1009.Metal4 vss.$1011.Metal4 0.0353725490196
Rred_2020 vss.$1009.Metal4 vss.$1211.Metal5 9
Rred_2021 vss.$1009.Metal4 vss.$1246.Metal5 9
Rred_2022 vss.$1009.Metal4 vss.$1281.Metal5 9
Rred_2023 vss.$1009.Metal4 vss.$799.Metal3 3
Rred_2024 vss.$1011.Metal4 vss.$1013.Metal4 0.0353725490196
Rred_2025 vss.$1011.Metal4 vss.$1211.Metal5 9
Rred_2026 vss.$1011.Metal4 vss.$1246.Metal5 9
Rred_2027 vss.$1011.Metal4 vss.$1281.Metal5 9
Rred_2028 vss.$1011.Metal4 vss.$801.Metal3 3
Rred_2029 vss.$1013.Metal4 vss.$1015.Metal4 0.0353725490196
Rred_2030 vss.$1013.Metal4 vss.$1211.Metal5 9
Rred_2031 vss.$1013.Metal4 vss.$1246.Metal5 9
Rred_2032 vss.$1013.Metal4 vss.$1281.Metal5 9
Rred_2033 vss.$1013.Metal4 vss.$469.Metal2 514.869179601
Rred_2034 vss.$1013.Metal4 vss.$801.Metal3 6.07074509804
Rred_2035 vss.$1013.Metal4 vss.$805.Metal3 6.07074509804
Rred_2036 vss.$1015.Metal4 vss.$1017.Metal4 0.0353725490196
Rred_2037 vss.$1015.Metal4 vss.$1211.Metal5 9
Rred_2038 vss.$1015.Metal4 vss.$1246.Metal5 9
Rred_2039 vss.$1015.Metal4 vss.$1281.Metal5 9
Rred_2040 vss.$1015.Metal4 vss.$805.Metal3 3
Rred_2041 vss.$1017.Metal4 vss.$1019.Metal4 0.0353725490196
Rred_2042 vss.$1017.Metal4 vss.$1211.Metal5 9
Rred_2043 vss.$1017.Metal4 vss.$1246.Metal5 9
Rred_2044 vss.$1017.Metal4 vss.$1281.Metal5 9
Rred_2045 vss.$1017.Metal4 vss.$473.Metal2 514.869179601
Rred_2046 vss.$1017.Metal4 vss.$805.Metal3 6.07074509804
Rred_2047 vss.$1017.Metal4 vss.$809.Metal3 6.07074509804
Rred_2048 vss.$1019.Metal4 vss.$1021.Metal4 0.0353725490196
Rred_2049 vss.$1019.Metal4 vss.$1211.Metal5 9
Rred_2050 vss.$1019.Metal4 vss.$1246.Metal5 9
Rred_2051 vss.$1019.Metal4 vss.$1281.Metal5 9
Rred_2052 vss.$1019.Metal4 vss.$809.Metal3 3
Rred_2053 vss.$1021.Metal4 vss.$1023.Metal4 0.0353725490196
Rred_2054 vss.$1021.Metal4 vss.$1211.Metal5 9
Rred_2055 vss.$1021.Metal4 vss.$1246.Metal5 9
Rred_2056 vss.$1021.Metal4 vss.$1281.Metal5 9
Rred_2057 vss.$1021.Metal4 vss.$811.Metal3 3
Rred_2058 vss.$1023.Metal4 vss.$1025.Metal4 0.0353725490196
Rred_2059 vss.$1023.Metal4 vss.$1211.Metal5 9
Rred_2060 vss.$1023.Metal4 vss.$1246.Metal5 9
Rred_2061 vss.$1023.Metal4 vss.$1281.Metal5 9
Rred_2062 vss.$1023.Metal4 vss.$479.Metal2 514.869179601
Rred_2063 vss.$1023.Metal4 vss.$811.Metal3 6.07074509804
Rred_2064 vss.$1023.Metal4 vss.$815.Metal3 6.07074509804
Rred_2065 vss.$1025.Metal4 vss.$1027.Metal4 0.0353725490196
Rred_2066 vss.$1025.Metal4 vss.$1211.Metal5 9
Rred_2067 vss.$1025.Metal4 vss.$1246.Metal5 9
Rred_2068 vss.$1025.Metal4 vss.$1281.Metal5 9
Rred_2069 vss.$1025.Metal4 vss.$815.Metal3 3
Rred_2070 vss.$1027.Metal4 vss.$1029.Metal4 0.0353725490196
Rred_2071 vss.$1027.Metal4 vss.$1211.Metal5 9
Rred_2072 vss.$1027.Metal4 vss.$1246.Metal5 9
Rred_2073 vss.$1027.Metal4 vss.$1281.Metal5 9
Rred_2074 vss.$1027.Metal4 vss.$483.Metal2 514.869179601
Rred_2075 vss.$1027.Metal4 vss.$815.Metal3 6.07074509804
Rred_2076 vss.$1027.Metal4 vss.$819.Metal3 6.07074509804
Rred_2077 vss.$1029.Metal4 vss.$1031.Metal4 0.0353725490196
Rred_2078 vss.$1029.Metal4 vss.$1211.Metal5 9
Rred_2079 vss.$1029.Metal4 vss.$1246.Metal5 9
Rred_2080 vss.$1029.Metal4 vss.$1281.Metal5 9
Rred_2081 vss.$1029.Metal4 vss.$819.Metal3 3
Rred_2082 vss.$1031.Metal4 vss.$1033.Metal4 0.0353725490196
Rred_2083 vss.$1031.Metal4 vss.$1211.Metal5 9
Rred_2084 vss.$1031.Metal4 vss.$1246.Metal5 9
Rred_2085 vss.$1031.Metal4 vss.$1281.Metal5 9
Rred_2086 vss.$1031.Metal4 vss.$821.Metal3 3
Rred_2087 vss.$1033.Metal4 vss.$1037.Metal4 0.0715771156688
Rred_2088 vss.$1033.Metal4 vss.$1211.Metal5 9
Rred_2089 vss.$1033.Metal4 vss.$1246.Metal5 3.63636011347
Rred_2090 vss.$1033.Metal4 vss.$1281.Metal5 9
Rred_2091 vss.$1033.Metal4 vss.$489.Metal2 514.869179601
Rred_2092 vss.$1033.Metal4 vss.$821.Metal3 6.07074509804
Rred_2093 vss.$1033.Metal4 vss.$825.Metal3 3.03532744586
Rred_2094 vss.$1037.Metal4 vss.$1039.Metal4 0.0353725490196
Rred_2095 vss.$1037.Metal4 vss.$1229.Metal5 9
Rred_2096 vss.$1037.Metal4 vss.$1246.Metal5 3.63636011347
Rred_2097 vss.$1037.Metal4 vss.$1299.Metal5 9
Rred_2098 vss.$1037.Metal4 vss.$493.Metal2 514.869179601
Rred_2099 vss.$1037.Metal4 vss.$825.Metal3 3.03532744586
Rred_2100 vss.$1037.Metal4 vss.$829.Metal3 6.07074509804
Rred_2101 vss.$1039.Metal4 vss.$1041.Metal4 0.0353725490196
Rred_2102 vss.$1039.Metal4 vss.$1229.Metal5 9
Rred_2103 vss.$1039.Metal4 vss.$1246.Metal5 9
Rred_2104 vss.$1039.Metal4 vss.$1299.Metal5 9
Rred_2105 vss.$1039.Metal4 vss.$829.Metal3 3
Rred_2106 vss.$1041.Metal4 vss.$1043.Metal4 0.0353725490196
Rred_2107 vss.$1041.Metal4 vss.$1229.Metal5 9
Rred_2108 vss.$1041.Metal4 vss.$1246.Metal5 9
Rred_2109 vss.$1041.Metal4 vss.$1299.Metal5 9
Rred_2110 vss.$1041.Metal4 vss.$831.Metal3 3
Rred_2111 vss.$1043.Metal4 vss.$1045.Metal4 0.0353725490196
Rred_2112 vss.$1043.Metal4 vss.$1229.Metal5 9
Rred_2113 vss.$1043.Metal4 vss.$1246.Metal5 9
Rred_2114 vss.$1043.Metal4 vss.$1299.Metal5 9
Rred_2115 vss.$1043.Metal4 vss.$499.Metal2 514.869179601
Rred_2116 vss.$1043.Metal4 vss.$831.Metal3 6.07074509804
Rred_2117 vss.$1043.Metal4 vss.$835.Metal3 6.07074509804
Rred_2118 vss.$1045.Metal4 vss.$1047.Metal4 0.0353725490196
Rred_2119 vss.$1045.Metal4 vss.$1229.Metal5 9
Rred_2120 vss.$1045.Metal4 vss.$1246.Metal5 9
Rred_2121 vss.$1045.Metal4 vss.$1299.Metal5 9
Rred_2122 vss.$1045.Metal4 vss.$835.Metal3 3
Rred_2123 vss.$1047.Metal4 vss.$1049.Metal4 0.0353725490196
Rred_2124 vss.$1047.Metal4 vss.$1229.Metal5 9
Rred_2125 vss.$1047.Metal4 vss.$1246.Metal5 9
Rred_2126 vss.$1047.Metal4 vss.$1299.Metal5 9
Rred_2127 vss.$1047.Metal4 vss.$503.Metal2 514.869179601
Rred_2128 vss.$1047.Metal4 vss.$835.Metal3 6.07074509804
Rred_2129 vss.$1047.Metal4 vss.$839.Metal3 6.07074509804
Rred_2130 vss.$1049.Metal4 vss.$1051.Metal4 0.0353725490196
Rred_2131 vss.$1049.Metal4 vss.$1229.Metal5 9
Rred_2132 vss.$1049.Metal4 vss.$1246.Metal5 9
Rred_2133 vss.$1049.Metal4 vss.$1299.Metal5 9
Rred_2134 vss.$1049.Metal4 vss.$839.Metal3 3
Rred_2135 vss.$1051.Metal4 vss.$1053.Metal4 0.0353725490196
Rred_2136 vss.$1051.Metal4 vss.$1229.Metal5 9
Rred_2137 vss.$1051.Metal4 vss.$1246.Metal5 9
Rred_2138 vss.$1051.Metal4 vss.$1299.Metal5 9
Rred_2139 vss.$1051.Metal4 vss.$841.Metal3 3
Rred_2140 vss.$1053.Metal4 vss.$1055.Metal4 0.0353725490196
Rred_2141 vss.$1053.Metal4 vss.$1229.Metal5 9
Rred_2142 vss.$1053.Metal4 vss.$1246.Metal5 9
Rred_2143 vss.$1053.Metal4 vss.$1299.Metal5 9
Rred_2144 vss.$1053.Metal4 vss.$509.Metal2 514.869179601
Rred_2145 vss.$1053.Metal4 vss.$841.Metal3 6.07074509804
Rred_2146 vss.$1053.Metal4 vss.$845.Metal3 6.07074509804
Rred_2147 vss.$1055.Metal4 vss.$1057.Metal4 0.0353725490196
Rred_2148 vss.$1055.Metal4 vss.$1229.Metal5 9
Rred_2149 vss.$1055.Metal4 vss.$1246.Metal5 9
Rred_2150 vss.$1055.Metal4 vss.$1299.Metal5 9
Rred_2151 vss.$1055.Metal4 vss.$845.Metal3 3
Rred_2152 vss.$1057.Metal4 vss.$1059.Metal4 0.0353725490196
Rred_2153 vss.$1057.Metal4 vss.$1229.Metal5 9
Rred_2154 vss.$1057.Metal4 vss.$1246.Metal5 9
Rred_2155 vss.$1057.Metal4 vss.$1299.Metal5 9
Rred_2156 vss.$1057.Metal4 vss.$513.Metal2 514.869179601
Rred_2157 vss.$1057.Metal4 vss.$845.Metal3 6.07074509804
Rred_2158 vss.$1057.Metal4 vss.$849.Metal3 6.07074509804
Rred_2159 vss.$1059.Metal4 vss.$1061.Metal4 0.0353725490196
Rred_2160 vss.$1059.Metal4 vss.$1229.Metal5 9
Rred_2161 vss.$1059.Metal4 vss.$1246.Metal5 9
Rred_2162 vss.$1059.Metal4 vss.$1299.Metal5 9
Rred_2163 vss.$1059.Metal4 vss.$849.Metal3 3
Rred_2164 vss.$1061.Metal4 vss.$1063.Metal4 0.0353725490196
Rred_2165 vss.$1061.Metal4 vss.$1229.Metal5 9
Rred_2166 vss.$1061.Metal4 vss.$1246.Metal5 9
Rred_2167 vss.$1061.Metal4 vss.$1299.Metal5 9
Rred_2168 vss.$1061.Metal4 vss.$851.Metal3 3
Rred_2169 vss.$1063.Metal4 vss.$1065.Metal4 0.0353725490196
Rred_2170 vss.$1063.Metal4 vss.$1229.Metal5 9
Rred_2171 vss.$1063.Metal4 vss.$1246.Metal5 9
Rred_2172 vss.$1063.Metal4 vss.$1299.Metal5 9
Rred_2173 vss.$1063.Metal4 vss.$519.Metal2 514.869179601
Rred_2174 vss.$1063.Metal4 vss.$851.Metal3 6.07074509804
Rred_2175 vss.$1063.Metal4 vss.$855.Metal3 6.07074509804
Rred_2176 vss.$1065.Metal4 vss.$1067.Metal4 0.0353725490196
Rred_2177 vss.$1065.Metal4 vss.$1229.Metal5 9
Rred_2178 vss.$1065.Metal4 vss.$1246.Metal5 9
Rred_2179 vss.$1065.Metal4 vss.$1299.Metal5 9
Rred_2180 vss.$1065.Metal4 vss.$855.Metal3 3
Rred_2181 vss.$1067.Metal4 vss.$1069.Metal4 0.0353725490196
Rred_2182 vss.$1067.Metal4 vss.$1229.Metal5 9
Rred_2183 vss.$1067.Metal4 vss.$1246.Metal5 9
Rred_2184 vss.$1067.Metal4 vss.$1299.Metal5 9
Rred_2185 vss.$1067.Metal4 vss.$857.Metal3 3
Rred_2186 vss.$1069.Metal4 vss.$1229.Metal5 9
Rred_2187 vss.$1069.Metal4 vss.$1246.Metal5 9
Rred_2188 vss.$1069.Metal4 vss.$1299.Metal5 9
Rred_2189 vss.$1069.Metal4 vss.$525.Metal2 260.4345898
Rred_2190 vss.$1069.Metal4 vss.$857.Metal3 3.07074509804
Rred_2191 vss.$1211.Metal5 vss.$1229.Metal5 0.203098938424
Rred_2192 vss.$1211.Metal5 vss.$1246.Metal5 0.00322142857143
Rred_2193 vss.$1211.Metal5 vss.$1281.Metal5 0.27633192602
Rred_2194 vss.$1211.Metal5 vss.$1299.Metal5 0.27633192602
Rred_2195 vss.$1229.Metal5 vss.$1246.Metal5 0.00322142857143
Rred_2196 vss.$1229.Metal5 vss.$1281.Metal5 0.27633192602
Rred_2197 vss.$1229.Metal5 vss.$1299.Metal5 0.27633192602
Rred_2198 vss.$1246.Metal5 vss.$1281.Metal5 0.00322142857143
Rred_2199 vss.$1246.Metal5 vss.$1299.Metal5 0.00322142857143
Rred_2200 vss.$1246.Metal5 vss.$825.Metal3 517.493239709
Rred_2201 vss.$127.Metal1 vss.$406.Metal1 374.726775254
Rred_2202 vss.$127.Metal1 vss.$457.Metal2 2.06926800761
Rred_2203 vss.$127.Metal1 vss.$461.Metal2 2.6061656473
Rred_2204 vss.$127.Metal1 vss.$463.Metal2 9.21566959287
Rred_2205 vss.$127.Metal1 vss.$793.Metal3 514.869179601
Rred_2206 vss.$127.Metal1 vss.P0.GatPoly 575.585257501
Rred_2207 vss.$127.Metal1 vss.P0.pSD 1.2050918941
Rred_2208 vss.$1281.Metal5 vss.$1299.Metal5 0.0721908978
Rred_2209 vss.$13.Metal1 vss.$136.Metal1 0.13455399662
Rred_2210 vss.$13.Metal1 vss.$467.Metal2 9.21249473047
Rred_2211 vss.$13.Metal1 vss.$469.Metal2 2.60592749965
Rred_2212 vss.$13.Metal1 vss.$473.Metal2 2.60626324174
Rred_2213 vss.$13.Metal1 vss.$475.Metal2 9.21338239481
Rred_2214 vss.$13.Metal1 vss.$805.Metal3 514.869179601
Rred_2215 vss.$13.Metal1 vss.P0.pSD 4.73467894859
Rred_2216 vss.$136.Metal1 vss.$138.Metal1 0.0883961537984
Rred_2217 vss.$136.Metal1 vss.$473.Metal2 9.21535783425
Rred_2218 vss.$136.Metal1 vss.$475.Metal2 2.60635479028
Rred_2219 vss.$136.Metal1 vss.$479.Metal2 3.0332974638
Rred_2220 vss.$136.Metal1 vss.$811.Metal3 514.965519391
Rred_2221 vss.$136.Metal1 vss.P0.pSD 5.7678802464
Rred_2222 vss.$136.Metal1 vss.P7.nSD 3520.07859317
Rred_2223 vss.$138.Metal1 vss.$140.Metal1 0.0883949469849
Rred_2224 vss.$138.Metal1 vss.$479.Metal2 3.03081295291
Rred_2225 vss.$138.Metal1 vss.$483.Metal2 3.03109437568
Rred_2226 vss.$138.Metal1 vss.$815.Metal3 514.869179601
Rred_2227 vss.$138.Metal1 vss.P0.pSD 6.96855884686
Rred_2228 vss.$140.Metal1 vss.$143.Metal1 0.134537302287
Rred_2229 vss.$140.Metal1 vss.$483.Metal2 3.03392302457
Rred_2230 vss.$140.Metal1 vss.$487.Metal2 2.60628807433
Rred_2231 vss.$140.Metal1 vss.$489.Metal2 9.21308576115
Rred_2232 vss.$140.Metal1 vss.$819.Metal3 515.013066347
Rred_2233 vss.$140.Metal1 vss.P0.pSD 5.74259719315
Rred_2234 vss.$140.Metal1 vss.P10.nSD 2880.89572544
Rred_2235 vss.$143.Metal1 vss.$146.Metal1 0.134537302287
Rred_2236 vss.$143.Metal1 vss.$487.Metal2 9.21209820967
Rred_2237 vss.$143.Metal1 vss.$489.Metal2 2.60589524409
Rred_2238 vss.$143.Metal1 vss.$493.Metal2 2.60589524409
Rred_2239 vss.$143.Metal1 vss.$495.Metal2 9.21209820967
Rred_2240 vss.$143.Metal1 vss.$825.Metal3 514.869179601
Rred_2241 vss.$143.Metal1 vss.P0.pSD 5.99437195309
Rred_2242 vss.$146.Metal1 vss.$148.Metal1 0.0883949469849
Rred_2243 vss.$146.Metal1 vss.$493.Metal2 9.21308576115
Rred_2244 vss.$146.Metal1 vss.$495.Metal2 2.60628807433
Rred_2245 vss.$146.Metal1 vss.$499.Metal2 3.03392302457
Rred_2246 vss.$146.Metal1 vss.$831.Metal3 515.013066347
Rred_2247 vss.$146.Metal1 vss.P0.pSD 5.74259719315
Rred_2248 vss.$146.Metal1 vss.P15.nSD 2880.89572544
Rred_2249 vss.$148.Metal1 vss.$150.Metal1 0.0883961537984
Rred_2250 vss.$148.Metal1 vss.$499.Metal2 3.03109437568
Rred_2251 vss.$148.Metal1 vss.$503.Metal2 3.03081295291
Rred_2252 vss.$148.Metal1 vss.$835.Metal3 514.869179601
Rred_2253 vss.$148.Metal1 vss.P0.pSD 6.96855884686
Rred_2254 vss.$150.Metal1 vss.$153.Metal1 0.13455399662
Rred_2255 vss.$150.Metal1 vss.$503.Metal2 3.0332974638
Rred_2256 vss.$150.Metal1 vss.$507.Metal2 2.60635479028
Rred_2257 vss.$150.Metal1 vss.$509.Metal2 9.21535783425
Rred_2258 vss.$150.Metal1 vss.$839.Metal3 514.965519391
Rred_2259 vss.$150.Metal1 vss.P0.pSD 5.7678802464
Rred_2260 vss.$150.Metal1 vss.P17.nSD 3520.07859317
Rred_2261 vss.$153.Metal1 vss.$156.Metal1 0.134538560711
Rred_2262 vss.$153.Metal1 vss.$507.Metal2 9.21338239481
Rred_2263 vss.$153.Metal1 vss.$509.Metal2 2.60626324174
Rred_2264 vss.$153.Metal1 vss.$513.Metal2 2.60592749965
Rred_2265 vss.$153.Metal1 vss.$515.Metal2 9.21249473047
Rred_2266 vss.$153.Metal1 vss.$845.Metal3 514.869179601
Rred_2267 vss.$153.Metal1 vss.P0.pSD 4.73467894859
Rred_2268 vss.$156.Metal1 vss.$159.Metal1 0.134556072844
Rred_2269 vss.$156.Metal1 vss.$513.Metal2 9.21269223899
Rred_2270 vss.$156.Metal1 vss.$515.Metal2 2.60638001377
Rred_2271 vss.$156.Metal1 vss.$519.Metal2 2.60867094883
Rred_2272 vss.$156.Metal1 vss.$521.Metal2 9.21369386944
Rred_2273 vss.$156.Metal1 vss.$851.Metal3 515.070113458
Rred_2274 vss.$156.Metal1 vss.P0.pSD 4.74580830545
Rred_2275 vss.$156.Metal1 vss.P23.nSD 2438.33841934
Rred_2276 vss.$159.Metal1 vss.$406.Metal1 4.29246196613
Rred_2277 vss.$159.Metal1 vss.$519.Metal2 9.21566959287
Rred_2278 vss.$159.Metal1 vss.$521.Metal2 2.6061656473
Rred_2279 vss.$159.Metal1 vss.$525.Metal2 2.07168750645
Rred_2280 vss.$159.Metal1 vss.$857.Metal3 514.869179601
Rred_2281 vss.$159.Metal1 vss.P0.pSD 1.56224438002
Rred_2282 vss.$159.Metal1 vss.P1.GatPoly 2810.6786005
Rred_2283 vss.$406.Metal1 vss.$457.Metal2 25657.6732202
Rred_2284 vss.$406.Metal1 vss.$525.Metal2 293.906370482
Rred_2285 vss.$406.Metal1 vss.P0.GatPoly 10481.5830669
Rred_2286 vss.$406.Metal1 vss.P0.pSD 0.864494745687
Rred_2287 vss.$406.Metal1 vss.P1.GatPoly 120.065604144
Rred_2288 vss.$457.Metal2 vss.$461.Metal2 0.0715792428553
Rred_2289 vss.$457.Metal2 vss.$793.Metal3 2.03924200009
Rred_2290 vss.$457.Metal2 vss.P0.GatPoly 39410.5236737
Rred_2291 vss.$457.Metal2 vss.P0.pSD 99.2208713675
Rred_2292 vss.$461.Metal2 vss.$463.Metal2 0.0353894398326
Rred_2293 vss.$461.Metal2 vss.$793.Metal3 6.07074509804
Rred_2294 vss.$461.Metal2 vss.$795.Metal3 3
Rred_2295 vss.$461.Metal2 vss.P0.nSD 4.85289602321
Rred_2296 vss.$461.Metal2 vss.P0.pSD 965.693169401
Rred_2297 vss.$463.Metal2 vss.$467.Metal2 0.0717291852966
Rred_2298 vss.$463.Metal2 vss.$795.Metal3 6.07074509804
Rred_2299 vss.$463.Metal2 vss.$799.Metal3 3.0385484346
Rred_2300 vss.$463.Metal2 vss.P0.nSD 61.4700162939
Rred_2301 vss.$463.Metal2 vss.P0.pSD 922.514354286
Rred_2302 vss.$463.Metal2 vss.P1.nSD 5.3653390732
Rred_2303 vss.$467.Metal2 vss.$469.Metal2 0.0354142727223
Rred_2304 vss.$467.Metal2 vss.$799.Metal3 6.07311427894
Rred_2305 vss.$467.Metal2 vss.$801.Metal3 3
Rred_2306 vss.$467.Metal2 vss.P0.pSD 1012.44644602
Rred_2307 vss.$467.Metal2 vss.P1.nSD 28.7500817548
Rred_2308 vss.$467.Metal2 vss.P3.nSD 23.0674325808
Rred_2309 vss.$469.Metal2 vss.$473.Metal2 0.0715792428553
Rred_2310 vss.$469.Metal2 vss.$801.Metal3 6.07074509804
Rred_2311 vss.$469.Metal2 vss.$805.Metal3 3.03537254902
Rred_2312 vss.$469.Metal2 vss.P0.pSD 1012.44892572
Rred_2313 vss.$469.Metal2 vss.P3.nSD 5.59210486807
Rred_2314 vss.$473.Metal2 vss.$475.Metal2 0.0354281800377
Rred_2315 vss.$473.Metal2 vss.$805.Metal3 3.03537254902
Rred_2316 vss.$473.Metal2 vss.$809.Metal3 6.07074509804
Rred_2317 vss.$473.Metal2 vss.P0.pSD 934.365403224
Rred_2318 vss.$473.Metal2 vss.P5.nSD 6.36592866327
Rred_2319 vss.$475.Metal2 vss.$479.Metal2 0.0716891504411
Rred_2320 vss.$475.Metal2 vss.$809.Metal3 3
Rred_2321 vss.$475.Metal2 vss.$811.Metal3 6.07188102602
Rred_2322 vss.$475.Metal2 vss.P0.pSD 972.100383861
Rred_2323 vss.$475.Metal2 vss.P5.nSD 15.3843276028
Rred_2324 vss.$475.Metal2 vss.P7.nSD 41.5047175299
Rred_2325 vss.$479.Metal2 vss.$483.Metal2 0.0715792428553
Rred_2326 vss.$479.Metal2 vss.$811.Metal3 3.03770111892
Rred_2327 vss.$479.Metal2 vss.$815.Metal3 3.03537254902
Rred_2328 vss.$479.Metal2 vss.P0.pSD 2007.27970237
Rred_2329 vss.$479.Metal2 vss.P7.nSD 5.06466559298
Rred_2330 vss.$483.Metal2 vss.$487.Metal2 0.0717098457889
Rred_2331 vss.$483.Metal2 vss.$815.Metal3 3.03537254902
Rred_2332 vss.$483.Metal2 vss.$819.Metal3 3.03813918368
Rred_2333 vss.$483.Metal2 vss.P0.pSD 1817.82155118
Rred_2334 vss.$483.Metal2 vss.P10.nSD 5.21075965667
Rred_2335 vss.$487.Metal2 vss.$489.Metal2 0.035421888356
Rred_2336 vss.$487.Metal2 vss.$819.Metal3 6.07244164503
Rred_2337 vss.$487.Metal2 vss.$821.Metal3 3
Rred_2338 vss.$487.Metal2 vss.P0.pSD 1012.43864897
Rred_2339 vss.$487.Metal2 vss.P10.nSD 33.9682084228
Rred_2340 vss.$487.Metal2 vss.P11.nSD 18.4579146921
Rred_2341 vss.$489.Metal2 vss.$493.Metal2 0.0715792428553
Rred_2342 vss.$489.Metal2 vss.$821.Metal3 6.07074509804
Rred_2343 vss.$489.Metal2 vss.$825.Metal3 3.03537254902
Rred_2344 vss.$489.Metal2 vss.P0.pSD 1012.45104753
Rred_2345 vss.$489.Metal2 vss.P11.nSD 5.95416602971
Rred_2346 vss.$493.Metal2 vss.$495.Metal2 0.035421888356
Rred_2347 vss.$493.Metal2 vss.$825.Metal3 3.03537254902
Rred_2348 vss.$493.Metal2 vss.$829.Metal3 6.07074509804
Rred_2349 vss.$493.Metal2 vss.P0.pSD 1012.45104753
Rred_2350 vss.$493.Metal2 vss.P13.nSD 5.95416602971
Rred_2351 vss.$495.Metal2 vss.$499.Metal2 0.0717098457889
Rred_2352 vss.$495.Metal2 vss.$829.Metal3 3
Rred_2353 vss.$495.Metal2 vss.$831.Metal3 6.07244164503
Rred_2354 vss.$495.Metal2 vss.P0.pSD 1012.43864897
Rred_2355 vss.$495.Metal2 vss.P13.nSD 18.4579146921
Rred_2356 vss.$495.Metal2 vss.P15.nSD 33.9682084228
Rred_2357 vss.$499.Metal2 vss.$503.Metal2 0.0715792428553
Rred_2358 vss.$499.Metal2 vss.$831.Metal3 3.03813918368
Rred_2359 vss.$499.Metal2 vss.$835.Metal3 3.03537254902
Rred_2360 vss.$499.Metal2 vss.P0.pSD 1817.82155118
Rred_2361 vss.$499.Metal2 vss.P15.nSD 5.21075965667
Rred_2362 vss.$503.Metal2 vss.$507.Metal2 0.0716891504411
Rred_2363 vss.$503.Metal2 vss.$835.Metal3 3.03537254902
Rred_2364 vss.$503.Metal2 vss.$839.Metal3 3.03770111892
Rred_2365 vss.$503.Metal2 vss.P0.pSD 2007.27970237
Rred_2366 vss.$503.Metal2 vss.P17.nSD 5.06466559298
Rred_2367 vss.$507.Metal2 vss.$509.Metal2 0.0354281800377
Rred_2368 vss.$507.Metal2 vss.$839.Metal3 6.07188102602
Rred_2369 vss.$507.Metal2 vss.$841.Metal3 3
Rred_2370 vss.$507.Metal2 vss.P0.pSD 972.100383861
Rred_2371 vss.$507.Metal2 vss.P17.nSD 41.5047175299
Rred_2372 vss.$507.Metal2 vss.P19.nSD 15.3843276028
Rred_2373 vss.$509.Metal2 vss.$513.Metal2 0.0715792428553
Rred_2374 vss.$509.Metal2 vss.$841.Metal3 6.07074509804
Rred_2375 vss.$509.Metal2 vss.$845.Metal3 3.03537254902
Rred_2376 vss.$509.Metal2 vss.P0.pSD 934.365403224
Rred_2377 vss.$509.Metal2 vss.P19.nSD 6.36592866327
Rred_2378 vss.$513.Metal2 vss.$515.Metal2 0.0354142727223
Rred_2379 vss.$513.Metal2 vss.$845.Metal3 3.03537254902
Rred_2380 vss.$513.Metal2 vss.$849.Metal3 6.07074509804
Rred_2381 vss.$513.Metal2 vss.P0.pSD 1012.44892572
Rred_2382 vss.$513.Metal2 vss.P21.nSD 5.59210486807
Rred_2383 vss.$515.Metal2 vss.$519.Metal2 0.0717291852966
Rred_2384 vss.$515.Metal2 vss.$849.Metal3 3
Rred_2385 vss.$515.Metal2 vss.$851.Metal3 6.07311427894
Rred_2386 vss.$515.Metal2 vss.P0.pSD 1012.44644602
Rred_2387 vss.$515.Metal2 vss.P21.nSD 23.0674325808
Rred_2388 vss.$515.Metal2 vss.P23.nSD 28.7500817548
Rred_2389 vss.$519.Metal2 vss.$521.Metal2 0.0353894398326
Rred_2390 vss.$519.Metal2 vss.$851.Metal3 3.0385484346
Rred_2391 vss.$519.Metal2 vss.$855.Metal3 6.07074509804
Rred_2392 vss.$519.Metal2 vss.P0.pSD 922.514354286
Rred_2393 vss.$519.Metal2 vss.P23.nSD 5.3653390732
Rred_2394 vss.$519.Metal2 vss.P25.nSD 61.4700162939
Rred_2395 vss.$521.Metal2 vss.$525.Metal2 0.0715792428553
Rred_2396 vss.$521.Metal2 vss.$855.Metal3 3
Rred_2397 vss.$521.Metal2 vss.$857.Metal3 6.07074509804
Rred_2398 vss.$521.Metal2 vss.P0.pSD 965.693169401
Rred_2399 vss.$521.Metal2 vss.P25.nSD 4.85289602321
Rred_2400 vss.$525.Metal2 vss.$857.Metal3 2.03924200009
Rred_2401 vss.$525.Metal2 vss.P0.pSD 136.838729851
Rred_2402 vss.$525.Metal2 vss.P1.GatPoly 192448.145745
Rred_2403 vss.$793.Metal3 vss.$795.Metal3 0.0353725490196
Rred_2404 vss.$795.Metal3 vss.$799.Metal3 0.0715792428553
Rred_2405 vss.$799.Metal3 vss.$801.Metal3 0.0353725490196
Rred_2406 vss.$799.Metal3 vss.P1.nSD 2438.33841934
Rred_2407 vss.$801.Metal3 vss.$805.Metal3 0.0715792428553
Rred_2408 vss.$805.Metal3 vss.$809.Metal3 0.0715792428553
Rred_2409 vss.$809.Metal3 vss.$811.Metal3 0.0353725490196
Rred_2410 vss.$811.Metal3 vss.$815.Metal3 0.0715792428553
Rred_2411 vss.$811.Metal3 vss.P7.nSD 3520.07859317
Rred_2412 vss.$815.Metal3 vss.$819.Metal3 0.0715792428553
Rred_2413 vss.$819.Metal3 vss.$821.Metal3 0.0353725490196
Rred_2414 vss.$819.Metal3 vss.P10.nSD 2880.89572544
Rred_2415 vss.$821.Metal3 vss.$825.Metal3 0.0715792428553
Rred_2416 vss.$825.Metal3 vss.$829.Metal3 0.0715792428553
Rred_2417 vss.$829.Metal3 vss.$831.Metal3 0.0353725490196
Rred_2418 vss.$831.Metal3 vss.$835.Metal3 0.0715792428553
Rred_2419 vss.$831.Metal3 vss.P15.nSD 2880.89572544
Rred_2420 vss.$835.Metal3 vss.$839.Metal3 0.0715792428553
Rred_2421 vss.$839.Metal3 vss.$841.Metal3 0.0353725490196
Rred_2422 vss.$839.Metal3 vss.P17.nSD 3520.07859317
Rred_2423 vss.$841.Metal3 vss.$845.Metal3 0.0715792428553
Rred_2424 vss.$845.Metal3 vss.$849.Metal3 0.0715792428553
Rred_2425 vss.$849.Metal3 vss.$851.Metal3 0.0353725490196
Rred_2426 vss.$851.Metal3 vss.$855.Metal3 0.0715792428553
Rred_2427 vss.$851.Metal3 vss.P23.nSD 2438.33841934
Rred_2428 vss.$855.Metal3 vss.$857.Metal3 0.0353725490196
Rred_2429 vss.P0.GatPoly vss.P0.pSD 134.64715669
Rred_2430 vss.P0.pSD vss.P1.GatPoly 1551.37246751
.ENDS sparx_powdet_sbd_pex
