*********************************************************
*** NGSPICE file created by KLayout-PEX 0.6.12
*** -----------------------------------------------------
***     Extraction Engine: KPEX/2.5D
***     Technology: ihp_sg13g2
***     Date: 2026-10-26 17:21:42
*********************************************************

.SUBCKT sparx_powdet_sbd_pex vout vref vdd rfin vss
X$1 vdd.P0.GatPoly \$I26 vss rhigh w=5e-07 l=2e-06 ps=0 b=0 m=1
X$2 \$I26.P1.GatPoly \$I30 vss rsil w=5e-07 l=2.5e-06 m=1
X$3 \$I26.P2.GatPoly \$I28 vss rsil w=5e-07 l=2.5e-06 m=1
X$4 \$I28.P0.Metal5 \$I17 vss schottky_nbl1 m=1
X$5 \$I30.P0.Metal1 \$I33 vss schottky_nbl1 m=1
X$6 vout.P0.GatPoly \$I17.P0.GatPoly vss rppd w=5e-07 l=1.5e-06 ps=0 b=0 m=1
X$7 \$I33.P0.GatPoly vref.P0.GatPoly vss rppd w=5e-07 l=1.5e-06 ps=0 b=0 m=1
X$8 vdd.P1.pSD vdd.P1.GatPoly vdd.P0.pSD \$I50 sg13_lv_pmos w=5e-06 l=1.3e-07
+ as=1.7e-12 ad=9.5e-13 ps=1.068e-05 pd=5.38e-06
X$9 vout.P0.pSD \$I17.P1.GatPoly vdd.P1.pSD \$I50 sg13_lv_pmos w=5e-06
+ l=1.3e-07 as=9.5e-13 ad=9.5e-13 ps=5.38e-06 pd=5.38e-06
X$10 vdd.P3.pSD \$I17.P2.GatPoly vout.P0.pSD \$I50 sg13_lv_pmos w=5e-06
+ l=1.3e-07 as=9.5e-13 ad=9.5e-13 ps=5.38e-06 pd=5.38e-06
X$11 vout.P2.pSD \$I17.P3.GatPoly vdd.P3.pSD \$I50 sg13_lv_pmos w=5e-06
+ l=1.3e-07 as=9.5e-13 ad=9.5e-13 ps=5.38e-06 pd=5.38e-06
X$12 vdd.P5.pSD \$I17.P4.GatPoly vout.P2.pSD \$I50 sg13_lv_pmos w=5e-06
+ l=1.3e-07 as=9.5e-13 ad=9.5e-13 ps=5.38e-06 pd=5.38e-06
X$13 vout.P4.pSD \$I17.P5.GatPoly vdd.P5.pSD \$I50 sg13_lv_pmos w=5e-06
+ l=1.3e-07 as=9.5e-13 ad=9.5e-13 ps=5.38e-06 pd=5.38e-06
X$14 vdd.P7.pSD \$I17.P6.GatPoly vout.P4.pSD \$I50 sg13_lv_pmos w=5e-06
+ l=1.3e-07 as=9.5e-13 ad=9.5e-13 ps=5.38e-06 pd=5.38e-06
X$15 vout.P6.pSD \$I17.P7.GatPoly vdd.P7.pSD \$I50 sg13_lv_pmos w=5e-06
+ l=1.3e-07 as=9.5e-13 ad=9.5e-13 ps=5.38e-06 pd=5.38e-06
X$16 vdd.P10.pSD \$I17.P8.GatPoly vout.P6.pSD \$I50 sg13_lv_pmos w=5e-06
+ l=1.3e-07 as=9.5e-13 ad=9.5e-13 ps=5.38e-06 pd=5.38e-06
X$17 vout.P8.pSD \$I17.P9.GatPoly vdd.P10.pSD \$I50 sg13_lv_pmos w=5e-06
+ l=1.3e-07 as=9.5e-13 ad=9.5e-13 ps=5.38e-06 pd=5.38e-06
X$18 vdd.P11.pSD \$I17.P10.GatPoly vout.P8.pSD \$I50 sg13_lv_pmos w=5e-06
+ l=1.3e-07 as=9.5e-13 ad=9.5e-13 ps=5.38e-06 pd=5.38e-06
X$19 vref.P0.pSD \$I33.P1.GatPoly vdd.P11.pSD \$I50 sg13_lv_pmos w=5e-06
+ l=1.3e-07 as=9.5e-13 ad=9.5e-13 ps=5.38e-06 pd=5.38e-06
X$20 vdd.P13.pSD \$I33.P2.GatPoly vref.P0.pSD \$I50 sg13_lv_pmos w=5e-06
+ l=1.3e-07 as=9.5e-13 ad=9.5e-13 ps=5.38e-06 pd=5.38e-06
X$21 vout.P10.pSD \$I17.P11.GatPoly vdd.P13.pSD \$I50 sg13_lv_pmos w=5e-06
+ l=1.3e-07 as=9.5e-13 ad=9.5e-13 ps=5.38e-06 pd=5.38e-06
X$22 vdd.P15.pSD \$I17.P12.GatPoly vout.P10.pSD \$I50 sg13_lv_pmos w=5e-06
+ l=1.3e-07 as=9.5e-13 ad=9.5e-13 ps=5.38e-06 pd=5.38e-06
X$23 vout.P12.pSD \$I17.P13.GatPoly vdd.P15.pSD \$I50 sg13_lv_pmos w=5e-06
+ l=1.3e-07 as=9.5e-13 ad=9.5e-13 ps=5.38e-06 pd=5.38e-06
X$24 vdd.P17.pSD \$I17.P14.GatPoly vout.P12.pSD \$I50 sg13_lv_pmos w=5e-06
+ l=1.3e-07 as=9.5e-13 ad=9.5e-13 ps=5.38e-06 pd=5.38e-06
X$25 vout.P14.pSD \$I17.P15.GatPoly vdd.P17.pSD \$I50 sg13_lv_pmos w=5e-06
+ l=1.3e-07 as=9.5e-13 ad=9.5e-13 ps=5.38e-06 pd=5.38e-06
X$26 vdd.P19.pSD \$I17.P16.GatPoly vout.P14.pSD \$I50 sg13_lv_pmos w=5e-06
+ l=1.3e-07 as=9.5e-13 ad=9.5e-13 ps=5.38e-06 pd=5.38e-06
X$27 vout.P16.pSD \$I17.P17.GatPoly vdd.P19.pSD \$I50 sg13_lv_pmos w=5e-06
+ l=1.3e-07 as=9.5e-13 ad=9.5e-13 ps=5.38e-06 pd=5.38e-06
X$28 vdd.P21.pSD \$I17.P18.GatPoly vout.P16.pSD \$I50 sg13_lv_pmos w=5e-06
+ l=1.3e-07 as=9.5e-13 ad=9.5e-13 ps=5.38e-06 pd=5.38e-06
X$29 vout.P18.pSD \$I17.P19.GatPoly vdd.P21.pSD \$I50 sg13_lv_pmos w=5e-06
+ l=1.3e-07 as=9.5e-13 ad=9.5e-13 ps=5.38e-06 pd=5.38e-06
X$30 vdd.P23.pSD \$I17.P20.GatPoly vout.P18.pSD \$I50 sg13_lv_pmos w=5e-06
+ l=1.3e-07 as=9.5e-13 ad=9.5e-13 ps=5.38e-06 pd=5.38e-06
X$31 vdd.P25.pSD vdd.P2.GatPoly vdd.P23.pSD \$I50 sg13_lv_pmos w=5e-06
+ l=1.3e-07 as=9.5e-13 ad=1.7e-12 ps=5.38e-06 pd=1.068e-05
X$32 vdd.P0.nSD \$I50 ntap1
X$33 vss.P1.nSD vss.P0.GatPoly vss.P0.nSD vss sg13_lv_nmos w=2.5e-06 l=1.3e-07
+ as=8.5e-13 ad=4.75e-13 ps=5.68e-06 pd=2.88e-06
X$34 vout.P0.nSD \$I17.P21.GatPoly vss.P1.nSD vss sg13_lv_nmos w=2.5e-06
+ l=1.3e-07 as=4.75e-13 ad=4.75e-13 ps=2.88e-06 pd=2.88e-06
X$35 vss.P3.nSD \$I17.P22.GatPoly vout.P0.nSD vss sg13_lv_nmos w=2.5e-06
+ l=1.3e-07 as=4.75e-13 ad=4.75e-13 ps=2.88e-06 pd=2.88e-06
X$36 vout.P2.nSD \$I17.P23.GatPoly vss.P3.nSD vss sg13_lv_nmos w=2.5e-06
+ l=1.3e-07 as=4.75e-13 ad=4.75e-13 ps=2.88e-06 pd=2.88e-06
X$37 vss.P5.nSD \$I17.P24.GatPoly vout.P2.nSD vss sg13_lv_nmos w=2.5e-06
+ l=1.3e-07 as=4.75e-13 ad=4.75e-13 ps=2.88e-06 pd=2.88e-06
X$38 vout.P4.nSD \$I17.P25.GatPoly vss.P5.nSD vss sg13_lv_nmos w=2.5e-06
+ l=1.3e-07 as=4.75e-13 ad=4.75e-13 ps=2.88e-06 pd=2.88e-06
X$39 vss.P7.nSD \$I17.P26.GatPoly vout.P4.nSD vss sg13_lv_nmos w=2.5e-06
+ l=1.3e-07 as=4.75e-13 ad=4.75e-13 ps=2.88e-06 pd=2.88e-06
X$40 vout.P6.nSD \$I17.P27.GatPoly vss.P7.nSD vss sg13_lv_nmos w=2.5e-06
+ l=1.3e-07 as=4.75e-13 ad=4.75e-13 ps=2.88e-06 pd=2.88e-06
X$41 vss.P10.nSD \$I17.P28.GatPoly vout.P6.nSD vss sg13_lv_nmos w=2.5e-06
+ l=1.3e-07 as=4.75e-13 ad=4.75e-13 ps=2.88e-06 pd=2.88e-06
X$42 vout.P8.nSD \$I17.P29.GatPoly vss.P10.nSD vss sg13_lv_nmos w=2.5e-06
+ l=1.3e-07 as=4.75e-13 ad=4.75e-13 ps=2.88e-06 pd=2.88e-06
X$43 vss.P11.nSD \$I17.P30.GatPoly vout.P8.nSD vss sg13_lv_nmos w=2.5e-06
+ l=1.3e-07 as=4.75e-13 ad=4.75e-13 ps=2.88e-06 pd=2.88e-06
X$44 vref.P0.nSD \$I33.P3.GatPoly vss.P11.nSD vss sg13_lv_nmos w=2.5e-06
+ l=1.3e-07 as=4.75e-13 ad=4.75e-13 ps=2.88e-06 pd=2.88e-06
X$45 vss.P13.nSD \$I33.P4.GatPoly vref.P0.nSD vss sg13_lv_nmos w=2.5e-06
+ l=1.3e-07 as=4.75e-13 ad=4.75e-13 ps=2.88e-06 pd=2.88e-06
X$46 vout.P10.nSD \$I17.P31.GatPoly vss.P13.nSD vss sg13_lv_nmos w=2.5e-06
+ l=1.3e-07 as=4.75e-13 ad=4.75e-13 ps=2.88e-06 pd=2.88e-06
X$47 vss.P15.nSD \$I17.P32.GatPoly vout.P10.nSD vss sg13_lv_nmos w=2.5e-06
+ l=1.3e-07 as=4.75e-13 ad=4.75e-13 ps=2.88e-06 pd=2.88e-06
X$48 vout.P12.nSD \$I17.P33.GatPoly vss.P15.nSD vss sg13_lv_nmos w=2.5e-06
+ l=1.3e-07 as=4.75e-13 ad=4.75e-13 ps=2.88e-06 pd=2.88e-06
X$49 vss.P17.nSD \$I17.P34.GatPoly vout.P12.nSD vss sg13_lv_nmos w=2.5e-06
+ l=1.3e-07 as=4.75e-13 ad=4.75e-13 ps=2.88e-06 pd=2.88e-06
X$50 vout.P14.nSD \$I17.P35.GatPoly vss.P17.nSD vss sg13_lv_nmos w=2.5e-06
+ l=1.3e-07 as=4.75e-13 ad=4.75e-13 ps=2.88e-06 pd=2.88e-06
X$51 vss.P19.nSD \$I17.P36.GatPoly vout.P14.nSD vss sg13_lv_nmos w=2.5e-06
+ l=1.3e-07 as=4.75e-13 ad=4.75e-13 ps=2.88e-06 pd=2.88e-06
X$52 vout.P16.nSD \$I17.P37.GatPoly vss.P19.nSD vss sg13_lv_nmos w=2.5e-06
+ l=1.3e-07 as=4.75e-13 ad=4.75e-13 ps=2.88e-06 pd=2.88e-06
X$53 vss.P21.nSD \$I17.P38.GatPoly vout.P16.nSD vss sg13_lv_nmos w=2.5e-06
+ l=1.3e-07 as=4.75e-13 ad=4.75e-13 ps=2.88e-06 pd=2.88e-06
X$54 vout.P18.nSD \$I17.P39.GatPoly vss.P21.nSD vss sg13_lv_nmos w=2.5e-06
+ l=1.3e-07 as=4.75e-13 ad=4.75e-13 ps=2.88e-06 pd=2.88e-06
X$55 vss.P23.nSD \$I17.P40.GatPoly vout.P18.nSD vss sg13_lv_nmos w=2.5e-06
+ l=1.3e-07 as=4.75e-13 ad=4.75e-13 ps=2.88e-06 pd=2.88e-06
X$56 vss.P25.nSD vss.P1.GatPoly vss.P23.nSD vss sg13_lv_nmos w=2.5e-06
+ l=1.3e-07 as=4.75e-13 ad=8.5e-13 ps=2.88e-06 pd=5.68e-06
X$57 vss.P0.pSD vss ptap1
* netlist reduce (TICER tau=0.1ps max degree 5, floating max degree 64): 7135 R, 11759 C, 4347 nodes -> 2433 R, 9281 C, 687 nodes
Cred_1 \$I17 \$I17.$692.Metal3 0.000993435f
Cred_2 \$I17 \$I17.$748.Metal3 0.00152969f
Cred_3 \$I17 \$I26 1.17084e-05f
Cred_4 \$I17 \$I26.$2169.TopMetal1 0.0209244f
Cred_5 \$I17 \$I26.P1.GatPoly 5.85346e-06f
Cred_6 \$I17 \$I26.P2.GatPoly 5.02133e-06f
Cred_7 \$I17 \$I28 0.0607072f
Cred_8 \$I17 \$I28.P0.Metal5 0.646146f
Cred_9 \$I17 \$I30 0.000309658f
Cred_10 \$I17 \$I30.P0.Metal1 0.00160091f
Cred_11 \$I17 \$I33 0.0129998f
Cred_12 \$I17 \$I33.$82.Metal2 0.00703462f
Cred_13 \$I17 \$I33.P0.GatPoly 5.1496e-05f
Cred_14 \$I17 \$I33.P3.GatPoly 4.68956e-06f
Cred_15 \$I17 \$I33.P4.GatPoly 4.68956e-06f
Cred_16 \$I17 \$I50 0.000284341f
Cred_17 \$I17 rfin 0.0313725f
Cred_18 \$I17 vss 1.7989f
Cred_19 \$I17 vdd.$2365.Metal1 6.99584e-06f
Cred_20 \$I17 vdd.$2399.Metal1 5.62459e-08f
Cred_21 \$I17 vdd.P0.nSD 7.01976e-05f
Cred_22 \$I17 vdd.P1.GatPoly 1.66871e-06f
Cred_23 \$I17 vdd.P2.GatPoly 2.50173e-09f
Cred_24 \$I17 vout 3.68797e-05f
Cred_25 \$I17 vout.$123.Metal1 1.82346e-08f
Cred_26 \$I17 vout.$1236.Metal4 0.000320768f
Cred_27 \$I17 vout.$1299.Metal4 1.1855e-06f
Cred_28 \$I17 vout.$1313.Metal4 6.17794e-10f
Cred_29 \$I17 vout.$500.Metal2 4.04338e-07f
Cred_30 \$I17 vout.$520.Metal2 1.66131e-06f
Cred_31 \$I17 vout.$888.Metal3 2.01721e-05f
Cred_32 \$I17 vout.P0.GatPoly 5.78518e-09f
Cred_33 \$I17 vref 0.000593713f
Cred_34 \$I17 vref.P0.GatPoly 0.000106574f
Cred_35 \$I17 vref.P0.nSD 5.07517e-05f
Cred_36 \$I17 vref.P0.pSD 8.84749e-05f
Cred_37 \$I17 vss.$1212.Metal5 0.00501862f
Cred_38 \$I17 vss.$127.Metal1 1.67883e-05f
Cred_39 \$I17 vss.$1282.Metal5 0.202951f
Cred_40 \$I17 vss.$1300.Metal5 3.60775e-05f
Cred_41 \$I17 vss.$406.Metal1 1.44812e-05f
Cred_42 \$I17 vss.$457.Metal2 2.45191e-07f
Cred_43 \$I17 vss.P0.GatPoly 1.75057e-06f
Cred_44 \$I17 vss.P0.pSD 0.00027015f
Cred_45 \$I17.$689.Metal3 \$I26 2.74959e-06f
Cred_46 \$I17.$689.Metal3 \$I26.$2169.TopMetal1 0.00425294f
Cred_47 \$I17.$689.Metal3 \$I26.P1.GatPoly 1.37462e-06f
Cred_48 \$I17.$689.Metal3 \$I26.P2.GatPoly 1.17921e-06f
Cred_49 \$I17.$689.Metal3 \$I33.$82.Metal2 0.0981636f
Cred_50 \$I17.$689.Metal3 \$I50 0.012162f
Cred_51 \$I17.$689.Metal3 vss 1.63386f
Cred_52 \$I17.$689.Metal3 vdd.$2365.Metal1 0.000450558f
Cred_53 \$I17.$689.Metal3 vdd.$2399.Metal1 3.62244e-06f
Cred_54 \$I17.$689.Metal3 vdd.P0.nSD 0.00452098f
Cred_55 \$I17.$689.Metal3 vdd.P1.GatPoly 0.000101712f
Cred_56 \$I17.$689.Metal3 vdd.P2.GatPoly 1.61121e-07f
Cred_57 \$I17.$689.Metal3 vout.$11.Metal1 6.09069e-08f
Cred_58 \$I17.$689.Metal3 vout.$121.Metal1 0.0110923f
Cred_59 \$I17.$689.Metal3 vout.$122.Metal1 0.00940715f
Cred_60 \$I17.$689.Metal3 vout.$123.Metal1 0.00168914f
Cred_61 \$I17.$689.Metal3 vout.$1235.Metal4 0.0224973f
Cred_62 \$I17.$689.Metal3 vout.$1236.Metal4 0.00344724f
Cred_63 \$I17.$689.Metal3 vout.$1264.Metal4 0.0103436f
Cred_64 \$I17.$689.Metal3 vout.$436.Metal2 5.20935e-06f
Cred_65 \$I17.$689.Metal3 vout.$498.Metal2 0.000352277f
Cred_66 \$I17.$689.Metal3 vout.$500.Metal2 6.37675e-05f
Cred_67 \$I17.$689.Metal3 vout.$516.Metal2 0.00528487f
Cred_68 \$I17.$689.Metal3 vout.$518.Metal2 0.00490309f
Cred_69 \$I17.$689.Metal3 vout.$520.Metal2 0.00107771f
Cred_70 \$I17.$689.Metal3 vout.$864.Metal3 0.000117904f
Cred_71 \$I17.$689.Metal3 vout.$886.Metal3 0.0175748f
Cred_72 \$I17.$689.Metal3 vout.$888.Metal3 0.0031813f
Cred_73 \$I17.$689.Metal3 vout.$904.Metal3 0.0284925f
Cred_74 \$I17.$689.Metal3 vout.P0.nSD 0.00661341f
Cred_75 \$I17.$689.Metal3 vout.P2.nSD 0.00551123f
Cred_76 \$I17.$689.Metal3 vout.P4.nSD 0.00130253f
Cred_77 \$I17.$689.Metal3 vss.$10.Metal1 3.96753e-06f
Cred_78 \$I17.$689.Metal3 vss.$1013.Metal4 7.24192e-06f
Cred_79 \$I17.$689.Metal3 vss.$1017.Metal4 5.50382e-06f
Cred_80 \$I17.$689.Metal3 vss.$1212.Metal5 0.111555f
Cred_81 \$I17.$689.Metal3 vss.$127.Metal1 0.0500352f
Cred_82 \$I17.$689.Metal3 vss.$1282.Metal5 1.22412f
Cred_83 \$I17.$689.Metal3 vss.$406.Metal1 0.00476455f
Cred_84 \$I17.$689.Metal3 vss.$457.Metal2 0.000730757f
Cred_85 \$I17.$689.Metal3 vss.$461.Metal2 0.0127148f
Cred_86 \$I17.$689.Metal3 vss.$463.Metal2 0.00280689f
Cred_87 \$I17.$689.Metal3 vss.$467.Metal2 0.00327864f
Cred_88 \$I17.$689.Metal3 vss.$469.Metal2 0.0121436f
Cred_89 \$I17.$689.Metal3 vss.$473.Metal2 0.00533263f
Cred_90 \$I17.$689.Metal3 vss.$475.Metal2 0.00220433f
Cred_91 \$I17.$689.Metal3 vss.$799.Metal3 0.00111476f
Cred_92 \$I17.$689.Metal3 vss.$801.Metal3 0.00185614f
Cred_93 \$I17.$689.Metal3 vss.$805.Metal3 0.00108099f
Cred_94 \$I17.$689.Metal3 vss.$809.Metal3 0.000938989f
Cred_95 \$I17.$689.Metal3 vss.P0.GatPoly 0.0154656f
Cred_96 \$I17.$689.Metal3 vss.P0.nSD 0.00361817f
Cred_97 \$I17.$689.Metal3 vss.P0.pSD 0.2528f
Cred_98 \$I17.$689.Metal3 vss.P1.nSD 0.00412347f
Cred_99 \$I17.$689.Metal3 vss.P3.nSD 0.0118293f
Cred_100 \$I17.$689.Metal3 vss.P5.nSD 0.00565691f
Cred_101 \$I17.$692.Metal3 \$I17.$748.Metal3 1.18361e-05f
Cred_102 \$I17.$692.Metal3 \$I26 3.51732e-06f
Cred_103 \$I17.$692.Metal3 \$I26.$2169.TopMetal1 0.00562289f
Cred_104 \$I17.$692.Metal3 \$I26.P1.GatPoly 1.75845e-06f
Cred_105 \$I17.$692.Metal3 \$I26.P2.GatPoly 1.50847e-06f
Cred_106 \$I17.$692.Metal3 \$I28 0.000661785f
Cred_107 \$I17.$692.Metal3 \$I28.P0.Metal5 0.0200173f
Cred_108 \$I17.$692.Metal3 \$I30 1.69304e-06f
Cred_109 \$I17.$692.Metal3 \$I30.P0.Metal1 8.7489e-06f
Cred_110 \$I17.$692.Metal3 \$I33 0.000763026f
Cred_111 \$I17.$692.Metal3 \$I33.$82.Metal2 0.108631f
Cred_112 \$I17.$692.Metal3 \$I33.P0.GatPoly 0.00133207f
Cred_113 \$I17.$692.Metal3 \$I33.P3.GatPoly 0.000130651f
Cred_114 \$I17.$692.Metal3 \$I33.P4.GatPoly 0.000129344f
Cred_115 \$I17.$692.Metal3 \$I50 0.00403538f
Cred_116 \$I17.$692.Metal3 rfin 0.00227489f
Cred_117 \$I17.$692.Metal3 vss 0.583999f
Cred_118 \$I17.$692.Metal3 vdd.$2365.Metal1 9.92852e-05f
Cred_119 \$I17.$692.Metal3 vdd.$2399.Metal1 7.98243e-07f
Cred_120 \$I17.$692.Metal3 vdd.P0.nSD 0.000996247f
Cred_121 \$I17.$692.Metal3 vdd.P1.GatPoly 2.36825e-05f
Cred_122 \$I17.$692.Metal3 vdd.P2.GatPoly 3.55047e-08f
Cred_123 \$I17.$692.Metal3 vout 0.000523398f
Cred_124 \$I17.$692.Metal3 vout.$122.Metal1 0.00188764f
Cred_125 \$I17.$692.Metal3 vout.$123.Metal1 0.00855746f
Cred_126 \$I17.$692.Metal3 vout.$1235.Metal4 0.00313244f
Cred_127 \$I17.$692.Metal3 vout.$1236.Metal4 0.0164853f
Cred_128 \$I17.$692.Metal3 vout.$1237.Metal4 0.0131432f
Cred_129 \$I17.$692.Metal3 vout.$1238.Metal4 0.00249941f
Cred_130 \$I17.$692.Metal3 vout.$124.Metal1 0.00705214f
Cred_131 \$I17.$692.Metal3 vout.$125.Metal1 0.00140633f
Cred_132 \$I17.$692.Metal3 vout.$1299.Metal4 0.00365413f
Cred_133 \$I17.$692.Metal3 vout.$1313.Metal4 8.76776e-09f
Cred_134 \$I17.$692.Metal3 vout.$498.Metal2 6.40132e-05f
Cred_135 \$I17.$692.Metal3 vout.$500.Metal2 0.000349714f
Cred_136 \$I17.$692.Metal3 vout.$502.Metal2 0.000262237f
Cred_137 \$I17.$692.Metal3 vout.$504.Metal2 5.39187e-05f
Cred_138 \$I17.$692.Metal3 vout.$518.Metal2 0.000950458f
Cred_139 \$I17.$692.Metal3 vout.$520.Metal2 0.00725536f
Cred_140 \$I17.$692.Metal3 vout.$522.Metal2 0.0036663f
Cred_141 \$I17.$692.Metal3 vout.$524.Metal2 0.000739251f
Cred_142 \$I17.$692.Metal3 vout.$886.Metal3 0.00319356f
Cred_143 \$I17.$692.Metal3 vout.$888.Metal3 0.0174469f
Cred_144 \$I17.$692.Metal3 vout.$890.Metal3 0.0130828f
Cred_145 \$I17.$692.Metal3 vout.$892.Metal3 0.00268996f
Cred_146 \$I17.$692.Metal3 vout.P0.GatPoly 8.21035e-08f
Cred_147 \$I17.$692.Metal3 vout.P2.nSD 0.000800679f
Cred_148 \$I17.$692.Metal3 vout.P4.nSD 0.0050088f
Cred_149 \$I17.$692.Metal3 vout.P6.nSD 0.0041316f
Cred_150 \$I17.$692.Metal3 vout.P8.nSD 0.000976468f
Cred_151 \$I17.$692.Metal3 vref 0.0428867f
Cred_152 \$I17.$692.Metal3 vref.P0.GatPoly 0.00285627f
Cred_153 \$I17.$692.Metal3 vref.P0.nSD 0.0115867f
Cred_154 \$I17.$692.Metal3 vref.P0.pSD 0.0147577f
Cred_155 \$I17.$692.Metal3 vss.$1017.Metal4 2.75139e-06f
Cred_156 \$I17.$692.Metal3 vss.$1023.Metal4 5.61954e-06f
Cred_157 \$I17.$692.Metal3 vss.$1027.Metal4 3.99909e-06f
Cred_158 \$I17.$692.Metal3 vss.$1212.Metal5 0.000363911f
Cred_159 \$I17.$692.Metal3 vss.$127.Metal1 0.002798f
Cred_160 \$I17.$692.Metal3 vss.$1282.Metal5 0.302422f
Cred_161 \$I17.$692.Metal3 vss.$1300.Metal5 0.00263101f
Cred_162 \$I17.$692.Metal3 vss.$136.Metal1 1.87187e-05f
Cred_163 \$I17.$692.Metal3 vss.$406.Metal1 0.00484086f
Cred_164 \$I17.$692.Metal3 vss.$457.Metal2 4.08644e-05f
Cred_165 \$I17.$692.Metal3 vss.$473.Metal2 0.0053367f
Cred_166 \$I17.$692.Metal3 vss.$475.Metal2 0.00379471f
Cred_167 \$I17.$692.Metal3 vss.$479.Metal2 0.0130156f
Cred_168 \$I17.$692.Metal3 vss.$483.Metal2 0.00413564f
Cred_169 \$I17.$692.Metal3 vss.$485.Metal2 0.00151493f
Cred_170 \$I17.$692.Metal3 vss.$805.Metal3 0.00023335f
Cred_171 \$I17.$692.Metal3 vss.$809.Metal3 0.00117793f
Cred_172 \$I17.$692.Metal3 vss.$811.Metal3 0.00178181f
Cred_173 \$I17.$692.Metal3 vss.$815.Metal3 0.00081577f
Cred_174 \$I17.$692.Metal3 vss.$819.Metal3 0.000682272f
Cred_175 \$I17.$692.Metal3 vss.P0.GatPoly 0.000116357f
Cred_176 \$I17.$692.Metal3 vss.P0.pSD 0.0666128f
Cred_177 \$I17.$692.Metal3 vss.P10.nSD 0.00425608f
Cred_178 \$I17.$692.Metal3 vss.P5.nSD 0.00562691f
Cred_179 \$I17.$692.Metal3 vss.P7.nSD 0.0103486f
Cred_180 \$I17.$696.Metal3 \$I33.$82.Metal2 0.340555f
Cred_181 \$I17.$696.Metal3 \$I33.P0.GatPoly 0.0273523f
Cred_182 \$I17.$696.Metal3 \$I33.P3.GatPoly 0.0117776f
Cred_183 \$I17.$696.Metal3 \$I33.P4.GatPoly 0.00772968f
Cred_184 \$I17.$696.Metal3 vss 0.386904f
Cred_185 \$I17.$696.Metal3 vout.$1237.Metal4 0.00817305f
Cred_186 \$I17.$696.Metal3 vout.$1238.Metal4 0.021986f
Cred_187 \$I17.$696.Metal3 vout.$1239.Metal4 0.00341649f
Cred_188 \$I17.$696.Metal3 vout.$124.Metal1 0.00423717f
Cred_189 \$I17.$696.Metal3 vout.$125.Metal1 0.00969909f
Cred_190 \$I17.$696.Metal3 vout.$126.Metal1 0.00460818f
Cred_191 \$I17.$696.Metal3 vout.$1269.Metal4 0.0148707f
Cred_192 \$I17.$696.Metal3 vout.$127.Metal1 0.000941267f
Cred_193 \$I17.$696.Metal3 vout.$1299.Metal4 0.0498619f
Cred_194 \$I17.$696.Metal3 vout.$502.Metal2 0.000151382f
Cred_195 \$I17.$696.Metal3 vout.$504.Metal2 0.000353974f
Cred_196 \$I17.$696.Metal3 vout.$522.Metal2 0.00217194f
Cred_197 \$I17.$696.Metal3 vout.$524.Metal2 0.00507031f
Cred_198 \$I17.$696.Metal3 vout.$526.Metal2 0.00173984f
Cred_199 \$I17.$696.Metal3 vout.$528.Metal2 0.000351199f
Cred_200 \$I17.$696.Metal3 vout.$890.Metal3 0.0075523f
Cred_201 \$I17.$696.Metal3 vout.$892.Metal3 0.0176594f
Cred_202 \$I17.$696.Metal3 vout.$934.Metal3 0.00917591f
Cred_203 \$I17.$696.Metal3 vout.$936.Metal3 0.00195939f
Cred_204 \$I17.$696.Metal3 vout.P10.nSD 0.00237694f
Cred_205 \$I17.$696.Metal3 vout.P12.nSD 0.000399986f
Cred_206 \$I17.$696.Metal3 vout.P6.nSD 0.00217718f
Cred_207 \$I17.$696.Metal3 vout.P8.nSD 0.00533413f
Cred_208 \$I17.$696.Metal3 vref 0.0565535f
Cred_209 \$I17.$696.Metal3 vref.P0.GatPoly 0.00220132f
Cred_210 \$I17.$696.Metal3 vref.P0.nSD 0.0208548f
Cred_211 \$I17.$696.Metal3 vref.P0.pSD 0.0193853f
Cred_212 \$I17.$696.Metal3 vss.$1023.Metal4 1.87223e-06f
Cred_213 \$I17.$696.Metal3 vss.$1027.Metal4 3.99909e-06f
Cred_214 \$I17.$696.Metal3 vss.$1033.Metal4 1.04182e-05f
Cred_215 \$I17.$696.Metal3 vss.$1037.Metal4 5.20453e-06f
Cred_216 \$I17.$696.Metal3 vss.$1043.Metal4 1.33219e-06f
Cred_217 \$I17.$696.Metal3 vss.$127.Metal1 0.00125986f
Cred_218 \$I17.$696.Metal3 vss.$1282.Metal5 0.102782f
Cred_219 \$I17.$696.Metal3 vss.$1300.Metal5 0.0193893f
Cred_220 \$I17.$696.Metal3 vss.$136.Metal1 2.42513e-06f
Cred_221 \$I17.$696.Metal3 vss.$141.Metal1 1.97014e-05f
Cred_222 \$I17.$696.Metal3 vss.$146.Metal1 6.80481e-06f
Cred_223 \$I17.$696.Metal3 vss.$406.Metal1 0.00601579f
Cred_224 \$I17.$696.Metal3 vss.$457.Metal2 1.84001e-05f
Cred_225 \$I17.$696.Metal3 vss.$475.Metal2 0.000205679f
Cred_226 \$I17.$696.Metal3 vss.$479.Metal2 0.0016874f
Cred_227 \$I17.$696.Metal3 vss.$483.Metal2 0.00689886f
Cred_228 \$I17.$696.Metal3 vss.$485.Metal2 0.00419902f
Cred_229 \$I17.$696.Metal3 vss.$489.Metal2 0.0121631f
Cred_230 \$I17.$696.Metal3 vss.$493.Metal2 0.00524267f
Cred_231 \$I17.$696.Metal3 vss.$495.Metal2 0.00226663f
Cred_232 \$I17.$696.Metal3 vss.$499.Metal2 0.00376354f
Cred_233 \$I17.$696.Metal3 vss.$811.Metal3 0.000161212f
Cred_234 \$I17.$696.Metal3 vss.$815.Metal3 0.000497956f
Cred_235 \$I17.$696.Metal3 vss.$819.Metal3 0.001369f
Cred_236 \$I17.$696.Metal3 vss.$821.Metal3 0.00223339f
Cred_237 \$I17.$696.Metal3 vss.$825.Metal3 0.00132499f
Cred_238 \$I17.$696.Metal3 vss.$829.Metal3 0.00110587f
Cred_239 \$I17.$696.Metal3 vss.$831.Metal3 0.000577145f
Cred_240 \$I17.$696.Metal3 vss.$835.Metal3 0.000112985f
Cred_241 \$I17.$696.Metal3 vss.P0.GatPoly 4.50414e-05f
Cred_242 \$I17.$696.Metal3 vss.P0.pSD 0.0519206f
Cred_243 \$I17.$696.Metal3 vss.P10.nSD 0.00705475f
Cred_244 \$I17.$696.Metal3 vss.P11.nSD 0.00904227f
Cred_245 \$I17.$696.Metal3 vss.P13.nSD 0.00451555f
Cred_246 \$I17.$696.Metal3 vss.P15.nSD 0.00341648f
Cred_247 \$I17.$696.Metal3 vss.P7.nSD 0.00152358f
Cred_248 \$I17.$700.Metal3 \$I33.$82.Metal2 0.119094f
Cred_249 \$I17.$700.Metal3 \$I33.P0.GatPoly 0.0102292f
Cred_250 \$I17.$700.Metal3 \$I33.P3.GatPoly 0.00126831f
Cred_251 \$I17.$700.Metal3 \$I33.P4.GatPoly 0.00530684f
Cred_252 \$I17.$700.Metal3 vss 0.467022f
Cred_253 \$I17.$700.Metal3 vout.$1239.Metal4 0.00341477f
Cred_254 \$I17.$700.Metal3 vout.$126.Metal1 0.0064777f
Cred_255 \$I17.$700.Metal3 vout.$1269.Metal4 0.091174f
Cred_256 \$I17.$700.Metal3 vout.$127.Metal1 0.0103283f
Cred_257 \$I17.$700.Metal3 vout.$128.Metal1 0.00704676f
Cred_258 \$I17.$700.Metal3 vout.$129.Metal1 0.00141252f
Cred_259 \$I17.$700.Metal3 vout.$1299.Metal4 0.266323f
Cred_260 \$I17.$700.Metal3 vout.$526.Metal2 0.00242897f
Cred_261 \$I17.$700.Metal3 vout.$528.Metal2 0.00382837f
Cred_262 \$I17.$700.Metal3 vout.$530.Metal2 0.00261663f
Cred_263 \$I17.$700.Metal3 vout.$532.Metal2 0.000527031f
Cred_264 \$I17.$700.Metal3 vout.$934.Metal3 0.012633f
Cred_265 \$I17.$700.Metal3 vout.$936.Metal3 0.0201947f
Cred_266 \$I17.$700.Metal3 vout.$938.Metal3 0.0140168f
Cred_267 \$I17.$700.Metal3 vout.$940.Metal3 0.00294038f
Cred_268 \$I17.$700.Metal3 vout.P10.nSD 0.00317642f
Cred_269 \$I17.$700.Metal3 vout.P12.nSD 0.00440469f
Cred_270 \$I17.$700.Metal3 vout.P14.nSD 0.00300236f
Cred_271 \$I17.$700.Metal3 vout.P16.nSD 0.000600244f
Cred_272 \$I17.$700.Metal3 vref 0.0409136f
Cred_273 \$I17.$700.Metal3 vref.P0.GatPoly 0.00157639f
Cred_274 \$I17.$700.Metal3 vref.P0.nSD 0.00875091f
Cred_275 \$I17.$700.Metal3 vref.P0.pSD 0.008938f
Cred_276 \$I17.$700.Metal3 vss.$1037.Metal4 5.2019e-06f
Cred_277 \$I17.$700.Metal3 vss.$1043.Metal4 6.66599e-06f
Cred_278 \$I17.$700.Metal3 vss.$1047.Metal4 7.49602e-06f
Cred_279 \$I17.$700.Metal3 vss.$1053.Metal4 2.06263e-06f
Cred_280 \$I17.$700.Metal3 vss.$127.Metal1 0.000717799f
Cred_281 \$I17.$700.Metal3 vss.$1300.Metal5 0.0186739f
Cred_282 \$I17.$700.Metal3 vss.$146.Metal1 2.04079e-05f
Cred_283 \$I17.$700.Metal3 vss.$150.Metal1 1.96741e-05f
Cred_284 \$I17.$700.Metal3 vss.$406.Metal1 0.0128133f
Cred_285 \$I17.$700.Metal3 vss.$457.Metal2 1.04834e-05f
Cred_286 \$I17.$700.Metal3 vss.$493.Metal2 0.00524002f
Cred_287 \$I17.$700.Metal3 vss.$495.Metal2 0.00341948f
Cred_288 \$I17.$700.Metal3 vss.$499.Metal2 0.0112897f
Cred_289 \$I17.$700.Metal3 vss.$503.Metal2 0.0136816f
Cred_290 \$I17.$700.Metal3 vss.$507.Metal2 0.00357266f
Cred_291 \$I17.$700.Metal3 vss.$509.Metal2 0.00460356f
Cred_292 \$I17.$700.Metal3 vss.$825.Metal3 0.000441181f
Cred_293 \$I17.$700.Metal3 vss.$829.Metal3 0.00110531f
Cred_294 \$I17.$700.Metal3 vss.$831.Metal3 0.00150056f
Cred_295 \$I17.$700.Metal3 vss.$835.Metal3 0.0012011f
Cred_296 \$I17.$700.Metal3 vss.$839.Metal3 0.00161986f
Cred_297 \$I17.$700.Metal3 vss.$841.Metal3 0.000883059f
Cred_298 \$I17.$700.Metal3 vss.$845.Metal3 0.000174935f
Cred_299 \$I17.$700.Metal3 vss.P0.GatPoly 2.5662e-05f
Cred_300 \$I17.$700.Metal3 vss.P0.pSD 0.054327f
Cred_301 \$I17.$700.Metal3 vss.P13.nSD 0.00451327f
Cred_302 \$I17.$700.Metal3 vss.P15.nSD 0.0097922f
Cred_303 \$I17.$700.Metal3 vss.P17.nSD 0.0123127f
Cred_304 \$I17.$700.Metal3 vss.P19.nSD 0.00511316f
Cred_305 \$I17.$704.Metal3 vss 0.493058f
Cred_306 \$I17.$704.Metal3 vout.$1269.Metal4 0.0734805f
Cred_307 \$I17.$704.Metal3 vout.$128.Metal1 0.00421958f
Cred_308 \$I17.$704.Metal3 vout.$129.Metal1 0.00985806f
Cred_309 \$I17.$704.Metal3 vout.$1299.Metal4 0.236731f
Cred_310 \$I17.$704.Metal3 vout.$130.Metal1 0.0110681f
Cred_311 \$I17.$704.Metal3 vout.$530.Metal2 0.00156177f
Cred_312 \$I17.$704.Metal3 vout.$532.Metal2 0.00365294f
Cred_313 \$I17.$704.Metal3 vout.$534.Metal2 0.00417043f
Cred_314 \$I17.$704.Metal3 vout.$938.Metal3 0.00813164f
Cred_315 \$I17.$704.Metal3 vout.$940.Metal3 0.019216f
Cred_316 \$I17.$704.Metal3 vout.$942.Metal3 0.0217933f
Cred_317 \$I17.$704.Metal3 vout.P14.nSD 0.00180096f
Cred_318 \$I17.$704.Metal3 vout.P16.nSD 0.00420489f
Cred_319 \$I17.$704.Metal3 vout.P18.nSD 0.00555454f
Cred_320 \$I17.$704.Metal3 vref 0.0192609f
Cred_321 \$I17.$704.Metal3 vref.P0.GatPoly 0.000537624f
Cred_322 \$I17.$704.Metal3 vref.P0.nSD 0.00032515f
Cred_323 \$I17.$704.Metal3 vref.P0.pSD 0.000569903f
Cred_324 \$I17.$704.Metal3 vss 0.00268392f
Cred_325 \$I17.$704.Metal3 vss.$1053.Metal4 6.19102e-06f
Cred_326 \$I17.$704.Metal3 vss.$1057.Metal4 7.24192e-06f
Cred_327 \$I17.$704.Metal3 vss.$1212.Metal5 0.00276795f
Cred_328 \$I17.$704.Metal3 vss.$1230.Metal5 0.00276795f
Cred_329 \$I17.$704.Metal3 vss.$127.Metal1 0.000361661f
Cred_330 \$I17.$704.Metal3 vss.$1282.Metal5 0.0105951f
Cred_331 \$I17.$704.Metal3 vss.$1300.Metal5 0.033349f
Cred_332 \$I17.$704.Metal3 vss.$150.Metal1 2.80318e-06f
Cred_333 \$I17.$704.Metal3 vss.$156.Metal1 3.96753e-06f
Cred_334 \$I17.$704.Metal3 vss.$159.Metal1 0.00765181f
Cred_335 \$I17.$704.Metal3 vss.$406.Metal1 0.200136f
Cred_336 \$I17.$704.Metal3 vss.$457.Metal2 5.28201e-06f
Cred_337 \$I17.$704.Metal3 vss.$503.Metal2 0.00194828f
Cred_338 \$I17.$704.Metal3 vss.$507.Metal2 0.00340916f
Cred_339 \$I17.$704.Metal3 vss.$509.Metal2 0.00767046f
Cred_340 \$I17.$704.Metal3 vss.$513.Metal2 0.0142149f
Cred_341 \$I17.$704.Metal3 vss.$515.Metal2 0.00378078f
Cred_342 \$I17.$704.Metal3 vss.$519.Metal2 0.00246045f
Cred_343 \$I17.$704.Metal3 vss.$521.Metal2 0.00832658f
Cred_344 \$I17.$704.Metal3 vss.$525.Metal2 0.000111754f
Cred_345 \$I17.$704.Metal3 vss.$839.Metal3 0.000324122f
Cred_346 \$I17.$704.Metal3 vss.$841.Metal3 0.00123319f
Cred_347 \$I17.$704.Metal3 vss.$845.Metal3 0.00113927f
Cred_348 \$I17.$704.Metal3 vss.$849.Metal3 0.00185614f
Cred_349 \$I17.$704.Metal3 vss.$851.Metal3 0.00111476f
Cred_350 \$I17.$704.Metal3 vss.P0.GatPoly 1.29297e-05f
Cred_351 \$I17.$704.Metal3 vss.P0.pSD 0.0571568f
Cred_352 \$I17.$704.Metal3 vss.P1.GatPoly 0.0117603f
Cred_353 \$I17.$704.Metal3 vss.P17.nSD 0.00144526f
Cred_354 \$I17.$704.Metal3 vss.P19.nSD 0.00805204f
Cred_355 \$I17.$704.Metal3 vss.P21.nSD 0.013764f
Cred_356 \$I17.$704.Metal3 vss.P23.nSD 0.00288136f
Cred_357 \$I17.$704.Metal3 vss.P25.nSD 0.00238835f
Cred_358 \$I17.$748.Metal3 \$I26 5.41598e-06f
Cred_359 \$I17.$748.Metal3 \$I26.$2169.TopMetal1 0.00865813f
Cred_360 \$I17.$748.Metal3 \$I26.P1.GatPoly 2.70766e-06f
Cred_361 \$I17.$748.Metal3 \$I26.P2.GatPoly 2.32274e-06f
Cred_362 \$I17.$748.Metal3 \$I28 0.00101902f
Cred_363 \$I17.$748.Metal3 \$I28.P0.Metal5 0.0308226f
Cred_364 \$I17.$748.Metal3 \$I30 2.60694e-06f
Cred_365 \$I17.$748.Metal3 \$I30.P0.Metal1 1.34716e-05f
Cred_366 \$I17.$748.Metal3 \$I33 0.00117491f
Cred_367 \$I17.$748.Metal3 \$I33.$82.Metal2 0.37106f
Cred_368 \$I17.$748.Metal3 \$I33.P0.GatPoly 0.00122679f
Cred_369 \$I17.$748.Metal3 \$I33.P1.GatPoly 0.000422659f
Cred_370 \$I17.$748.Metal3 \$I33.P2.GatPoly 0.000412084f
Cred_371 \$I17.$748.Metal3 \$I33.P3.GatPoly 0.00011172f
Cred_372 \$I17.$748.Metal3 \$I33.P4.GatPoly 0.00011172f
Cred_373 \$I17.$748.Metal3 \$I50 0.0159095f
Cred_374 \$I17.$748.Metal3 rfin 0.00350288f
Cred_375 \$I17.$748.Metal3 vss 0.532402f
Cred_376 \$I17.$748.Metal3 vdd.$2365.Metal1 0.000321721f
Cred_377 \$I17.$748.Metal3 vdd.$2399.Metal1 5.97015e-05f
Cred_378 \$I17.$748.Metal3 vdd.$2763.Metal2 0.000105489f
Cred_379 \$I17.$748.Metal3 vdd.$2765.Metal2 0.000375072f
Cred_380 \$I17.$748.Metal3 vdd.P0.nSD 0.0130314f
Cred_381 \$I17.$748.Metal3 vdd.P1.GatPoly 4.39761e-05f
Cred_382 \$I17.$748.Metal3 vdd.P2.GatPoly 2.65543e-06f
Cred_383 \$I17.$748.Metal3 vdd.P7.pSD 0.000673933f
Cred_384 \$I17.$748.Metal3 vout 0.0323233f
Cred_385 \$I17.$748.Metal3 vout.$1036.Metal3 0.000499199f
Cred_386 \$I17.$748.Metal3 vout.$123.Metal1 3.98479e-07f
Cred_387 \$I17.$748.Metal3 vout.$1236.Metal4 0.00700972f
Cred_388 \$I17.$748.Metal3 vout.$1299.Metal4 0.000515558f
Cred_389 \$I17.$748.Metal3 vout.$1313.Metal4 0.00073803f
Cred_390 \$I17.$748.Metal3 vout.$1330.Metal4 0.00568357f
Cred_391 \$I17.$748.Metal3 vout.$1370.Metal4 0.000132996f
Cred_392 \$I17.$748.Metal3 vout.$158.Metal1 0.000483039f
Cred_393 \$I17.$748.Metal3 vout.$208.Metal1 0.000100551f
Cred_394 \$I17.$748.Metal3 vout.$500.Metal2 8.83597e-06f
Cred_395 \$I17.$748.Metal3 vout.$520.Metal2 3.63046e-05f
Cred_396 \$I17.$748.Metal3 vout.$588.Metal2 0.000201327f
Cred_397 \$I17.$748.Metal3 vout.$608.Metal2 1.22017e-05f
Cred_398 \$I17.$748.Metal3 vout.$888.Metal3 0.000440819f
Cred_399 \$I17.$748.Metal3 vout.P0.GatPoly 0.00662331f
Cred_400 \$I17.$748.Metal3 vout.P4.pSD 0.00013499f
Cred_401 \$I17.$748.Metal3 vref 0.110064f
Cred_402 \$I17.$748.Metal3 vref.P0.GatPoly 0.00958942f
Cred_403 \$I17.$748.Metal3 vref.P0.nSD 0.0155668f
Cred_404 \$I17.$748.Metal3 vref.P0.pSD 0.0308485f
Cred_405 \$I17.$748.Metal3 vss.$1212.Metal5 0.00056035f
Cred_406 \$I17.$748.Metal3 vss.$127.Metal1 0.000402725f
Cred_407 \$I17.$748.Metal3 vss.$1282.Metal5 0.449913f
Cred_408 \$I17.$748.Metal3 vss.$1300.Metal5 0.00749311f
Cred_409 \$I17.$748.Metal3 vss.$406.Metal1 0.000374046f
Cred_410 \$I17.$748.Metal3 vss.$457.Metal2 5.88175e-06f
Cred_411 \$I17.$748.Metal3 vss.P0.GatPoly 3.95369e-05f
Cred_412 \$I17.$748.Metal3 vss.P0.pSD 0.00683709f
Cred_413 \$I17.$758.Metal3 \$I33.$82.Metal2 0.0141517f
Cred_414 \$I17.$758.Metal3 \$I33.P1.GatPoly 7.8488e-06f
Cred_415 \$I17.$758.Metal3 \$I33.P2.GatPoly 7.4762e-06f
Cred_416 \$I17.$758.Metal3 \$I50 0.59823f
Cred_417 \$I17.$758.Metal3 vss 0.105285f
Cred_418 \$I17.$758.Metal3 vdd.$2365.Metal1 0.023005f
Cred_419 \$I17.$758.Metal3 vdd.$2370.Metal1 2.16185e-05f
Cred_420 \$I17.$758.Metal3 vdd.$2399.Metal1 0.000454965f
Cred_421 \$I17.$758.Metal3 vdd.$2747.Metal2 0.00382555f
Cred_422 \$I17.$758.Metal3 vdd.$2749.Metal2 0.00292862f
Cred_423 \$I17.$758.Metal3 vdd.$2751.Metal2 0.00305299f
Cred_424 \$I17.$758.Metal3 vdd.$2755.Metal2 0.0171382f
Cred_425 \$I17.$758.Metal3 vdd.$2759.Metal2 0.012559f
Cred_426 \$I17.$758.Metal3 vdd.$2761.Metal2 0.00519682f
Cred_427 \$I17.$758.Metal3 vdd.$2763.Metal2 0.00118049f
Cred_428 \$I17.$758.Metal3 vdd.$2765.Metal2 0.00419731f
Cred_429 \$I17.$758.Metal3 vdd.$2987.Metal3 2.16185e-05f
Cred_430 \$I17.$758.Metal3 vdd.P0.nSD 0.305744f
Cred_431 \$I17.$758.Metal3 vdd.P0.pSD 0.00334033f
Cred_432 \$I17.$758.Metal3 vdd.P1.GatPoly 0.00899087f
Cred_433 \$I17.$758.Metal3 vdd.P1.pSD 0.00736434f
Cred_434 \$I17.$758.Metal3 vdd.P2.GatPoly 2.02362e-05f
Cred_435 \$I17.$758.Metal3 vdd.P3.pSD 0.0280677f
Cred_436 \$I17.$758.Metal3 vdd.P5.pSD 0.0271353f
Cred_437 \$I17.$758.Metal3 vdd.P7.pSD 0.00754177f
Cred_438 \$I17.$758.Metal3 vout.$1032.Metal3 0.0113264f
Cred_439 \$I17.$758.Metal3 vout.$1034.Metal3 0.0112293f
Cred_440 \$I17.$758.Metal3 vout.$1036.Metal3 0.00862384f
Cred_441 \$I17.$758.Metal3 vout.$1112.Metal3 8.95256e-06f
Cred_442 \$I17.$758.Metal3 vout.$1152.Metal3 2.11942e-05f
Cred_443 \$I17.$758.Metal3 vout.$1328.Metal4 0.0053053f
Cred_444 \$I17.$758.Metal3 vout.$1329.Metal4 0.00529725f
Cred_445 \$I17.$758.Metal3 vout.$1330.Metal4 0.00211738f
Cred_446 \$I17.$758.Metal3 vout.$1368.Metal4 0.000195567f
Cred_447 \$I17.$758.Metal3 vout.$1369.Metal4 0.00319284f
Cred_448 \$I17.$758.Metal3 vout.$1370.Metal4 0.00311905f
Cred_449 \$I17.$758.Metal3 vout.$1408.Metal4 0.00247707f
Cred_450 \$I17.$758.Metal3 vout.$156.Metal1 0.0198689f
Cred_451 \$I17.$758.Metal3 vout.$157.Metal1 0.0205897f
Cred_452 \$I17.$758.Metal3 vout.$158.Metal1 0.0152367f
Cred_453 \$I17.$758.Metal3 vout.$206.Metal1 0.00722388f
Cred_454 \$I17.$758.Metal3 vout.$207.Metal1 0.00758233f
Cred_455 \$I17.$758.Metal3 vout.$208.Metal1 0.00470205f
Cred_456 \$I17.$758.Metal3 vout.$584.Metal2 0.00438608f
Cred_457 \$I17.$758.Metal3 vout.$586.Metal2 0.00439135f
Cred_458 \$I17.$758.Metal3 vout.$588.Metal2 0.00455355f
Cred_459 \$I17.$758.Metal3 vout.$604.Metal2 0.000384766f
Cred_460 \$I17.$758.Metal3 vout.$606.Metal2 0.000390646f
Cred_461 \$I17.$758.Metal3 vout.$608.Metal2 0.00027553f
Cred_462 \$I17.$758.Metal3 vout.$724.Metal2 9.37904e-08f
Cred_463 \$I17.$758.Metal3 vout.P0.pSD 0.00830346f
Cred_464 \$I17.$758.Metal3 vout.P2.pSD 0.00832224f
Cred_465 \$I17.$758.Metal3 vout.P4.pSD 0.00663113f
Cred_466 \$I17.$758.Metal3 vref 0.014076f
Cred_467 \$I17.$758.Metal3 vref.P0.GatPoly 0.000548885f
Cred_468 \$I17.$758.Metal3 vref.P0.nSD 0.00314658f
Cred_469 \$I17.$758.Metal3 vref.P0.pSD 0.00918776f
Cred_470 \$I17.$758.Metal3 vss.$1282.Metal5 0.27293f
Cred_471 \$I17.$760.Metal3 \$I33.$82.Metal2 0.0191021f
Cred_472 \$I17.$760.Metal3 \$I33.P1.GatPoly 4.93271e-05f
Cred_473 \$I17.$760.Metal3 \$I33.P2.GatPoly 4.69854e-05f
Cred_474 \$I17.$760.Metal3 \$I50 0.283104f
Cred_475 \$I17.$760.Metal3 vss 0.0316637f
Cred_476 \$I17.$760.Metal3 vdd.$2365.Metal1 0.000713002f
Cred_477 \$I17.$760.Metal3 vdd.$2399.Metal1 0.00032102f
Cred_478 \$I17.$760.Metal3 vdd.$2763.Metal2 0.00286395f
Cred_479 \$I17.$760.Metal3 vdd.$2765.Metal2 0.0101829f
Cred_480 \$I17.$760.Metal3 vdd.$2769.Metal2 0.00710169f
Cred_481 \$I17.$760.Metal3 vdd.$2771.Metal2 0.00260395f
Cred_482 \$I17.$760.Metal3 vdd.P0.nSD 0.0547463f
Cred_483 \$I17.$760.Metal3 vdd.P1.GatPoly 3.17133e-05f
Cred_484 \$I17.$760.Metal3 vdd.P10.pSD 0.0143205f
Cred_485 \$I17.$760.Metal3 vdd.P2.GatPoly 1.42785e-05f
Cred_486 \$I17.$760.Metal3 vdd.P7.pSD 0.0194767f
Cred_487 \$I17.$760.Metal3 vout 0.00227161f
Cred_488 \$I17.$760.Metal3 vout.$1036.Metal3 0.00247886f
Cred_489 \$I17.$760.Metal3 vout.$1038.Metal3 0.00989523f
Cred_490 \$I17.$760.Metal3 vout.$1040.Metal3 0.00209514f
Cred_491 \$I17.$760.Metal3 vout.$1299.Metal4 2.7354e-08f
Cred_492 \$I17.$760.Metal3 vout.$1313.Metal4 0.00229147f
Cred_493 \$I17.$760.Metal3 vout.$1330.Metal4 0.000295232f
Cred_494 \$I17.$760.Metal3 vout.$1331.Metal4 0.00448217f
Cred_495 \$I17.$760.Metal3 vout.$1332.Metal4 0.000953836f
Cred_496 \$I17.$760.Metal3 vout.$1370.Metal4 0.00148832f
Cred_497 \$I17.$760.Metal3 vout.$1371.Metal4 0.0027623f
Cred_498 \$I17.$760.Metal3 vout.$1372.Metal4 0.000543416f
Cred_499 \$I17.$760.Metal3 vout.$158.Metal1 0.00540226f
Cred_500 \$I17.$760.Metal3 vout.$159.Metal1 0.0197654f
Cred_501 \$I17.$760.Metal3 vout.$160.Metal1 0.00398057f
Cred_502 \$I17.$760.Metal3 vout.$208.Metal1 0.00112524f
Cred_503 \$I17.$760.Metal3 vout.$209.Metal1 0.0039185f
Cred_504 \$I17.$760.Metal3 vout.$210.Metal1 0.000783526f
Cred_505 \$I17.$760.Metal3 vout.$588.Metal2 0.00196096f
Cred_506 \$I17.$760.Metal3 vout.$590.Metal2 0.0036332f
Cred_507 \$I17.$760.Metal3 vout.$592.Metal2 0.000738254f
Cred_508 \$I17.$760.Metal3 vout.$608.Metal2 7.4257e-05f
Cred_509 \$I17.$760.Metal3 vout.$610.Metal2 0.000283905f
Cred_510 \$I17.$760.Metal3 vout.$612.Metal2 5.91044e-05f
Cred_511 \$I17.$760.Metal3 vout.P0.GatPoly 3.5634e-07f
Cred_512 \$I17.$760.Metal3 vout.P4.pSD 0.00151063f
Cred_513 \$I17.$760.Metal3 vout.P6.pSD 0.00718328f
Cred_514 \$I17.$760.Metal3 vout.P8.pSD 0.00169259f
Cred_515 \$I17.$760.Metal3 vref 0.0154387f
Cred_516 \$I17.$760.Metal3 vref.P0.GatPoly 0.000602022f
Cred_517 \$I17.$760.Metal3 vref.P0.nSD 0.00345119f
Cred_518 \$I17.$760.Metal3 vref.P0.pSD 0.0100772f
Cred_519 \$I17.$760.Metal3 vss.$1282.Metal5 0.114499f
Cred_520 \$I17.$760.Metal3 vss.$1300.Metal5 0.00252059f
Cred_521 \$I17.$763.Metal3 \$I33.$82.Metal2 0.328639f
Cred_522 \$I17.$763.Metal3 \$I33.P1.GatPoly 0.00997431f
Cred_523 \$I17.$763.Metal3 \$I33.P2.GatPoly 0.00418009f
Cred_524 \$I17.$763.Metal3 \$I50 0.241763f
Cred_525 \$I17.$763.Metal3 vss 0.0204539f
Cred_526 \$I17.$763.Metal3 vdd.$2365.Metal1 0.000418061f
Cred_527 \$I17.$763.Metal3 vdd.$2399.Metal1 0.000273903f
Cred_528 \$I17.$763.Metal3 vdd.$2769.Metal2 0.00682942f
Cred_529 \$I17.$763.Metal3 vdd.$2771.Metal2 0.00250412f
Cred_530 \$I17.$763.Metal3 vdd.$2773.Metal2 0.00315253f
Cred_531 \$I17.$763.Metal3 vdd.$2775.Metal2 0.00977917f
Cred_532 \$I17.$763.Metal3 vdd.$2779.Metal2 0.00256965f
Cred_533 \$I17.$763.Metal3 vdd.$2781.Metal2 0.000828407f
Cred_534 \$I17.$763.Metal3 vdd.$3007.Metal3 0.000537616f
Cred_535 \$I17.$763.Metal3 vdd.$3011.Metal3 0.000671998f
Cred_536 \$I17.$763.Metal3 vdd.$3015.Metal3 0.000134382f
Cred_537 \$I17.$763.Metal3 vdd.$3243.Metal4 6.33895e-06f
Cred_538 \$I17.$763.Metal3 vdd.$3247.Metal4 1.58447e-06f
Cred_539 \$I17.$763.Metal3 vdd.P0.nSD 0.0403041f
Cred_540 \$I17.$763.Metal3 vdd.P1.GatPoly 1.85947e-05f
Cred_541 \$I17.$763.Metal3 vdd.P10.pSD 0.0134732f
Cred_542 \$I17.$763.Metal3 vdd.P11.pSD 0.0179959f
Cred_543 \$I17.$763.Metal3 vdd.P13.pSD 0.0045804f
Cred_544 \$I17.$763.Metal3 vdd.P2.GatPoly 1.21828e-05f
Cred_545 \$I17.$763.Metal3 vout 0.00089738f
Cred_546 \$I17.$763.Metal3 vout.$1002.Metal3 0.0015613f
Cred_547 \$I17.$763.Metal3 vout.$1038.Metal3 0.0017047f
Cred_548 \$I17.$763.Metal3 vout.$1040.Metal3 0.00930637f
Cred_549 \$I17.$763.Metal3 vout.$1299.Metal4 1.0806e-08f
Cred_550 \$I17.$763.Metal3 vout.$1313.Metal4 0.00903924f
Cred_551 \$I17.$763.Metal3 vout.$1331.Metal4 0.000863612f
Cred_552 \$I17.$763.Metal3 vout.$1332.Metal4 0.00449949f
Cred_553 \$I17.$763.Metal3 vout.$1371.Metal4 0.000521856f
Cred_554 \$I17.$763.Metal3 vout.$1372.Metal4 0.00388006f
Cred_555 \$I17.$763.Metal3 vout.$1383.Metal4 0.000525663f
Cred_556 \$I17.$763.Metal3 vout.$159.Metal1 0.00399734f
Cred_557 \$I17.$763.Metal3 vout.$160.Metal1 0.0186932f
Cred_558 \$I17.$763.Metal3 vout.$161.Metal1 0.0023631f
Cred_559 \$I17.$763.Metal3 vout.$201.Metal1 0.000901575f
Cred_560 \$I17.$763.Metal3 vout.$209.Metal1 0.000783526f
Cred_561 \$I17.$763.Metal3 vout.$210.Metal1 0.0039185f
Cred_562 \$I17.$763.Metal3 vout.$590.Metal2 0.000698701f
Cred_563 \$I17.$763.Metal3 vout.$592.Metal2 0.0035734f
Cred_564 \$I17.$763.Metal3 vout.$594.Metal2 0.000419197f
Cred_565 \$I17.$763.Metal3 vout.$610.Metal2 5.12781e-05f
Cred_566 \$I17.$763.Metal3 vout.$612.Metal2 0.000272102f
Cred_567 \$I17.$763.Metal3 vout.$614.Metal2 7.87089e-07f
Cred_568 \$I17.$763.Metal3 vout.P0.GatPoly 1.40769e-07f
Cred_569 \$I17.$763.Metal3 vout.P10.pSD 0.00101955f
Cred_570 \$I17.$763.Metal3 vout.P6.pSD 0.00105189f
Cred_571 \$I17.$763.Metal3 vout.P8.pSD 0.00654215f
Cred_572 \$I17.$763.Metal3 vref 0.0365687f
Cred_573 \$I17.$763.Metal3 vref.P0.GatPoly 0.00142509f
Cred_574 \$I17.$763.Metal3 vref.P0.nSD 0.00798586f
Cred_575 \$I17.$763.Metal3 vref.P0.pSD 0.027762f
Cred_576 \$I17.$763.Metal3 vss.$1282.Metal5 0.0824629f
Cred_577 \$I17.$763.Metal3 vss.$1300.Metal5 0.0151361f
Cred_578 \$I17.$765.Metal3 \$I33.$82.Metal2 0.185831f
Cred_579 \$I17.$765.Metal3 \$I33.P1.GatPoly 0.00127358f
Cred_580 \$I17.$765.Metal3 \$I33.P2.GatPoly 0.00707026f
Cred_581 \$I17.$765.Metal3 \$I50 0.34372f
Cred_582 \$I17.$765.Metal3 vss 0.0476605f
Cred_583 \$I17.$765.Metal3 vdd.$2365.Metal1 0.000293852f
Cred_584 \$I17.$765.Metal3 vdd.$2399.Metal1 0.000632536f
Cred_585 \$I17.$765.Metal3 vdd.$2779.Metal2 0.00770894f
Cred_586 \$I17.$765.Metal3 vdd.$2781.Metal2 0.00248522f
Cred_587 \$I17.$765.Metal3 vdd.$2783.Metal2 0.00450889f
Cred_588 \$I17.$765.Metal3 vdd.$2785.Metal2 0.012297f
Cred_589 \$I17.$765.Metal3 vdd.$2789.Metal2 0.00568553f
Cred_590 \$I17.$765.Metal3 vdd.$2791.Metal2 0.00159906f
Cred_591 \$I17.$765.Metal3 vdd.$3011.Metal3 0.000403145f
Cred_592 \$I17.$765.Metal3 vdd.$3015.Metal3 0.000403145f
Cred_593 \$I17.$765.Metal3 vdd.$3247.Metal4 4.75342e-06f
Cred_594 \$I17.$765.Metal3 vdd.P0.nSD 0.0514859f
Cred_595 \$I17.$765.Metal3 vdd.P1.GatPoly 1.30701e-05f
Cred_596 \$I17.$765.Metal3 vdd.P13.pSD 0.0137412f
Cred_597 \$I17.$765.Metal3 vdd.P15.pSD 0.0246261f
Cred_598 \$I17.$765.Metal3 vdd.P17.pSD 0.010763f
Cred_599 \$I17.$765.Metal3 vdd.P2.GatPoly 2.81343e-05f
Cred_600 \$I17.$765.Metal3 vout 0.0695579f
Cred_601 \$I17.$765.Metal3 vout.$1002.Metal3 0.00996537f
Cred_602 \$I17.$765.Metal3 vout.$1004.Metal3 0.00750634f
Cred_603 \$I17.$765.Metal3 vout.$1006.Metal3 0.00162178f
Cred_604 \$I17.$765.Metal3 vout.$1299.Metal4 4.12616e-05f
Cred_605 \$I17.$765.Metal3 vout.$1313.Metal4 0.13718f
Cred_606 \$I17.$765.Metal3 vout.$1373.Metal4 0.0674227f
Cred_607 \$I17.$765.Metal3 vout.$1383.Metal4 0.00157699f
Cred_608 \$I17.$765.Metal3 vout.$161.Metal1 0.0175067f
Cred_609 \$I17.$765.Metal3 vout.$162.Metal1 0.0144916f
Cred_610 \$I17.$765.Metal3 vout.$163.Metal1 0.00290289f
Cred_611 \$I17.$765.Metal3 vout.$201.Metal1 0.00631162f
Cred_612 \$I17.$765.Metal3 vout.$212.Metal1 0.00293812f
Cred_613 \$I17.$765.Metal3 vout.$213.Metal1 0.000587493f
Cred_614 \$I17.$765.Metal3 vout.$594.Metal2 0.00291554f
Cred_615 \$I17.$765.Metal3 vout.$596.Metal2 0.00211467f
Cred_616 \$I17.$765.Metal3 vout.$598.Metal2 0.000425222f
Cred_617 \$I17.$765.Metal3 vout.$614.Metal2 5.51015e-06f
Cred_618 \$I17.$765.Metal3 vout.$616.Metal2 6.4154e-05f
Cred_619 \$I17.$765.Metal3 vout.$618.Metal2 1.2828e-05f
Cred_620 \$I17.$765.Metal3 vout.P0.GatPoly 0.000664332f
Cred_621 \$I17.$765.Metal3 vout.P10.pSD 0.00617622f
Cred_622 \$I17.$765.Metal3 vout.P12.pSD 0.00394443f
Cred_623 \$I17.$765.Metal3 vout.P14.pSD 0.000788711f
Cred_624 \$I17.$765.Metal3 vref 0.0399422f
Cred_625 \$I17.$765.Metal3 vref.P0.GatPoly 0.00155156f
Cred_626 \$I17.$765.Metal3 vref.P0.nSD 0.00766064f
Cred_627 \$I17.$765.Metal3 vref.P0.pSD 0.0247955f
Cred_628 \$I17.$765.Metal3 vss.$1300.Metal5 0.0454083f
Cred_629 \$I17.$769.Metal3 \$I50 0.681781f
Cred_630 \$I17.$769.Metal3 vss 0.107883f
Cred_631 \$I17.$769.Metal3 vdd.$2365.Metal1 0.00048922f
Cred_632 \$I17.$769.Metal3 vdd.$2394.Metal1 2.16181e-05f
Cred_633 \$I17.$769.Metal3 vdd.$2399.Metal1 0.0226538f
Cred_634 \$I17.$769.Metal3 vdd.$2783.Metal2 0.000599518f
Cred_635 \$I17.$769.Metal3 vdd.$2785.Metal2 0.00163505f
Cred_636 \$I17.$769.Metal3 vdd.$2789.Metal2 0.00917622f
Cred_637 \$I17.$769.Metal3 vdd.$2791.Metal2 0.00258081f
Cred_638 \$I17.$769.Metal3 vdd.$2793.Metal2 0.00557065f
Cred_639 \$I17.$769.Metal3 vdd.$2795.Metal2 0.0134624f
Cred_640 \$I17.$769.Metal3 vdd.$2799.Metal2 0.0171379f
Cred_641 \$I17.$769.Metal3 vdd.$2803.Metal2 0.00305296f
Cred_642 \$I17.$769.Metal3 vdd.$2805.Metal2 0.00292862f
Cred_643 \$I17.$769.Metal3 vdd.$2807.Metal2 0.00382555f
Cred_644 \$I17.$769.Metal3 vdd.$3035.Metal3 2.16181e-05f
Cred_645 \$I17.$769.Metal3 vdd.P0.nSD 0.304291f
Cred_646 \$I17.$769.Metal3 vdd.P1.GatPoly 2.17598e-05f
Cred_647 \$I17.$769.Metal3 vdd.P15.pSD 0.00316951f
Cred_648 \$I17.$769.Metal3 vdd.P17.pSD 0.0170594f
Cred_649 \$I17.$769.Metal3 vdd.P19.pSD 0.0277714f
Cred_650 \$I17.$769.Metal3 vdd.P2.GatPoly 0.00893597f
Cred_651 \$I17.$769.Metal3 vdd.P21.pSD 0.0280697f
Cred_652 \$I17.$769.Metal3 vdd.P23.pSD 0.00714553f
Cred_653 \$I17.$769.Metal3 vdd.P25.pSD 0.00334033f
Cred_654 \$I17.$769.Metal3 vout 0.123997f
Cred_655 \$I17.$769.Metal3 vout.$1004.Metal3 0.00426134f
Cred_656 \$I17.$769.Metal3 vout.$1006.Metal3 0.0101483f
Cred_657 \$I17.$769.Metal3 vout.$1008.Metal3 0.0117583f
Cred_658 \$I17.$769.Metal3 vout.$1010.Metal3 0.011399f
Cred_659 \$I17.$769.Metal3 vout.$1299.Metal4 2.90881e-05f
Cred_660 \$I17.$769.Metal3 vout.$1313.Metal4 0.255493f
Cred_661 \$I17.$769.Metal3 vout.$1373.Metal4 0.127213f
Cred_662 \$I17.$769.Metal3 vout.$162.Metal1 0.00868323f
Cred_663 \$I17.$769.Metal3 vout.$163.Metal1 0.0202771f
Cred_664 \$I17.$769.Metal3 vout.$164.Metal1 0.0231556f
Cred_665 \$I17.$769.Metal3 vout.$165.Metal1 0.0220142f
Cred_666 \$I17.$769.Metal3 vout.$212.Metal1 0.00176261f
Cred_667 \$I17.$769.Metal3 vout.$213.Metal1 0.00411427f
Cred_668 \$I17.$769.Metal3 vout.$214.Metal1 0.00469682f
Cred_669 \$I17.$769.Metal3 vout.$215.Metal1 0.00469266f
Cred_670 \$I17.$769.Metal3 vout.$596.Metal2 0.00126385f
Cred_671 \$I17.$769.Metal3 vout.$598.Metal2 0.00295404f
Cred_672 \$I17.$769.Metal3 vout.$600.Metal2 0.00337572f
Cred_673 \$I17.$769.Metal3 vout.$602.Metal2 0.003366f
Cred_674 \$I17.$769.Metal3 vout.$616.Metal2 3.84867e-05f
Cred_675 \$I17.$769.Metal3 vout.$618.Metal2 8.98355e-05f
Cred_676 \$I17.$769.Metal3 vout.$620.Metal2 0.000102555f
Cred_677 \$I17.$769.Metal3 vout.$622.Metal2 0.000102465f
Cred_678 \$I17.$769.Metal3 vout.P0.GatPoly 0.000505749f
Cred_679 \$I17.$769.Metal3 vout.P12.pSD 0.00236631f
Cred_680 \$I17.$769.Metal3 vout.P14.pSD 0.00552343f
Cred_681 \$I17.$769.Metal3 vout.P16.pSD 0.0063055f
Cred_682 \$I17.$769.Metal3 vout.P18.pSD 0.00725933f
Cred_683 \$I17.$769.Metal3 vref 0.0123209f
Cred_684 \$I17.$769.Metal3 vref.P0.GatPoly 0.000404391f
Cred_685 \$I17.$769.Metal3 vref.P0.nSD 0.000244572f
Cred_686 \$I17.$769.Metal3 vref.P0.pSD 0.000428671f
Cred_687 \$I17.$769.Metal3 vss 0.00552889f
Cred_688 \$I17.$769.Metal3 vss.$1212.Metal5 0.00570199f
Cred_689 \$I17.$769.Metal3 vss.$1230.Metal5 0.00570199f
Cred_690 \$I17.$769.Metal3 vss.$1282.Metal5 0.021826f
Cred_691 \$I17.$769.Metal3 vss.$1300.Metal5 0.021826f
Cred_692 \$I17.P0.GatPoly \$I33.$82.Metal2 0.0108007f
Cred_693 \$I17.P0.GatPoly \$I33.P0.GatPoly 2.92303e-06f
Cred_694 \$I17.P0.GatPoly \$I33.P1.GatPoly 5.56657e-05f
Cred_695 \$I17.P0.GatPoly \$I33.P2.GatPoly 5.53452e-05f
Cred_696 \$I17.P0.GatPoly \$I33.P3.GatPoly 2.6619e-07f
Cred_697 \$I17.P0.GatPoly \$I33.P4.GatPoly 2.6619e-07f
Cred_698 \$I17.P0.GatPoly \$I50 0.000552101f
Cred_699 \$I17.P0.GatPoly vss 0.130996f
Cred_700 \$I17.P0.GatPoly vdd.$2365.Metal1 1.59129e-05f
Cred_701 \$I17.P0.GatPoly vdd.$2399.Metal1 1.58603e-05f
Cred_702 \$I17.P0.GatPoly vdd.P0.nSD 0.00191088f
Cred_703 \$I17.P0.GatPoly vdd.P1.GatPoly 7.07782e-07f
Cred_704 \$I17.P0.GatPoly vdd.P2.GatPoly 7.05443e-07f
Cred_705 \$I17.P0.GatPoly vout 0.00438433f
Cred_706 \$I17.P0.GatPoly vout.$1299.Metal4 7.13986e-05f
Cred_707 \$I17.P0.GatPoly vout.$1313.Metal4 9.8038e-05f
Cred_708 \$I17.P0.GatPoly vout.P0.GatPoly 0.00487376f
Cred_709 \$I17.P0.GatPoly vref 0.0069138f
Cred_710 \$I17.P0.GatPoly vref.P0.GatPoly 0.00406274f
Cred_711 \$I17.P0.GatPoly vref.P0.nSD 0.000584968f
Cred_712 \$I17.P0.GatPoly vref.P0.pSD 0.00112541f
Cred_713 \$I17.P0.GatPoly vss.$1282.Metal5 0.00415799f
Cred_714 \$I17.P0.GatPoly vss.$1300.Metal5 0.000107737f
Cred_715 \$I17.P1.GatPoly \$I33.$82.Metal2 1.99288e-05f
Cred_716 \$I17.P1.GatPoly \$I50 0.0196952f
Cred_717 \$I17.P1.GatPoly vss 0.000259686f
Cred_718 \$I17.P1.GatPoly vdd.$2365.Metal1 0.000692615f
Cred_719 \$I17.P1.GatPoly vdd.$2367.Metal1 0.000497888f
Cred_720 \$I17.P1.GatPoly vdd.$2370.Metal1 0.00100462f
Cred_721 \$I17.P1.GatPoly vdd.$2399.Metal1 6.51089e-06f
Cred_722 \$I17.P1.GatPoly vdd.$2747.Metal2 3.39656e-06f
Cred_723 \$I17.P1.GatPoly vdd.$2749.Metal2 0.0134448f
Cred_724 \$I17.P1.GatPoly vdd.$2751.Metal2 0.00869245f
Cred_725 \$I17.P1.GatPoly vdd.$2755.Metal2 9.61444e-06f
Cred_726 \$I17.P1.GatPoly vdd.$2759.Metal2 1.57803e-06f
Cred_727 \$I17.P1.GatPoly vdd.$2761.Metal2 6.52979e-07f
Cred_728 \$I17.P1.GatPoly vdd.$2983.Metal3 0.00129265f
Cred_729 \$I17.P1.GatPoly vdd.$2987.Metal3 0.00129266f
Cred_730 \$I17.P1.GatPoly vdd.$3219.Metal4 0.00260517f
Cred_731 \$I17.P1.GatPoly vdd.P0.nSD 0.00728265f
Cred_732 \$I17.P1.GatPoly vdd.P0.pSD 2.96576e-06f
Cred_733 \$I17.P1.GatPoly vdd.P1.GatPoly 0.0810505f
Cred_734 \$I17.P1.GatPoly vdd.P1.pSD 0.0278749f
Cred_735 \$I17.P1.GatPoly vdd.P2.GatPoly 2.89595e-07f
Cred_736 \$I17.P1.GatPoly vdd.P3.pSD 1.57895e-05f
Cred_737 \$I17.P1.GatPoly vdd.P5.pSD 3.35398e-06f
Cred_738 \$I17.P1.GatPoly vout.$1032.Metal3 8.88553e-06f
Cred_739 \$I17.P1.GatPoly vout.$1034.Metal3 3.84542e-06f
Cred_740 \$I17.P1.GatPoly vout.$1112.Metal3 5.95862e-09f
Cred_741 \$I17.P1.GatPoly vout.$1152.Metal3 2.73324e-07f
Cred_742 \$I17.P1.GatPoly vout.$1328.Metal4 4.12682e-06f
Cred_743 \$I17.P1.GatPoly vout.$1329.Metal4 1.77447e-06f
Cred_744 \$I17.P1.GatPoly vout.$1368.Metal4 1.30165e-07f
Cred_745 \$I17.P1.GatPoly vout.$1369.Metal4 1.06865e-06f
Cred_746 \$I17.P1.GatPoly vout.$1408.Metal4 1.67579e-06f
Cred_747 \$I17.P1.GatPoly vout.$156.Metal1 0.00136826f
Cred_748 \$I17.P1.GatPoly vout.$157.Metal1 6.85085e-06f
Cred_749 \$I17.P1.GatPoly vout.$206.Metal1 0.00546478f
Cred_750 \$I17.P1.GatPoly vout.$207.Metal1 2.52834e-06f
Cred_751 \$I17.P1.GatPoly vout.$226.Metal1 0.00598064f
Cred_752 \$I17.P1.GatPoly vout.$266.Metal1 0.0059635f
Cred_753 \$I17.P1.GatPoly vout.$286.Metal1 0.0212887f
Cred_754 \$I17.P1.GatPoly vout.$326.Metal1 0.00598025f
Cred_755 \$I17.P1.GatPoly vout.$346.Metal1 0.00789348f
Cred_756 \$I17.P1.GatPoly vout.$396.Metal1 0.00868084f
Cred_757 \$I17.P1.GatPoly vout.$584.Metal2 2.21536e-05f
Cred_758 \$I17.P1.GatPoly vout.$586.Metal2 1.47155e-06f
Cred_759 \$I17.P1.GatPoly vout.$604.Metal2 3.20456e-05f
Cred_760 \$I17.P1.GatPoly vout.$606.Metal2 1.32286e-07f
Cred_761 \$I17.P1.GatPoly vout.$644.Metal2 1.81802e-05f
Cred_762 \$I17.P1.GatPoly vout.$664.Metal2 3.58831e-05f
Cred_763 \$I17.P1.GatPoly vout.$684.Metal2 1.05688e-05f
Cred_764 \$I17.P1.GatPoly vout.$704.Metal2 3.54639e-05f
Cred_765 \$I17.P1.GatPoly vout.$724.Metal2 1.92924e-05f
Cred_766 \$I17.P1.GatPoly vout.$764.Metal2 8.43544e-05f
Cred_767 \$I17.P1.GatPoly vout.$784.Metal2 8.69621e-05f
Cred_768 \$I17.P1.GatPoly vout.P0.pSD 0.000199733f
Cred_769 \$I17.P1.GatPoly vout.P2.pSD 2.98009e-06f
Cred_770 \$I17.P1.GatPoly vss.$1282.Metal5 0.00537202f
Cred_771 \$I17.P10.GatPoly \$I33.$82.Metal2 0.00728293f
Cred_772 \$I17.P10.GatPoly \$I33.P1.GatPoly 0.0706484f
Cred_773 \$I17.P10.GatPoly \$I33.P2.GatPoly 4.98876e-05f
Cred_774 \$I17.P10.GatPoly \$I50 0.0191813f
Cred_775 \$I17.P10.GatPoly vss 0.000161574f
Cred_776 \$I17.P10.GatPoly vdd.$2365.Metal1 4.92793e-06f
Cred_777 \$I17.P10.GatPoly vdd.$2379.Metal1 0.0013747f
Cred_778 \$I17.P10.GatPoly vdd.$2382.Metal1 0.000681312f
Cred_779 \$I17.P10.GatPoly vdd.$2399.Metal1 3.36127e-06f
Cred_780 \$I17.P10.GatPoly vdd.$2773.Metal2 0.00778061f
Cred_781 \$I17.P10.GatPoly vdd.$2775.Metal2 0.0149148f
Cred_782 \$I17.P10.GatPoly vdd.$3007.Metal3 0.0102884f
Cred_783 \$I17.P10.GatPoly vdd.P0.nSD 0.000497457f
Cred_784 \$I17.P10.GatPoly vdd.P1.GatPoly 2.19187e-07f
Cred_785 \$I17.P10.GatPoly vdd.P11.pSD 0.0279064f
Cred_786 \$I17.P10.GatPoly vdd.P2.GatPoly 1.49504e-07f
Cred_787 \$I17.P10.GatPoly vout.$1040.Metal3 5.33739e-08f
Cred_788 \$I17.P10.GatPoly vout.$1180.Metal3 2.42643e-07f
Cred_789 \$I17.P10.GatPoly vout.$1332.Metal4 2.00175e-09f
Cred_790 \$I17.P10.GatPoly vout.$1372.Metal4 0.0255338f
Cred_791 \$I17.P10.GatPoly vout.$160.Metal1 0.00145413f
Cred_792 \$I17.P10.GatPoly vout.$210.Metal1 0.00537034f
Cred_793 \$I17.P10.GatPoly vout.$230.Metal1 0.00598064f
Cred_794 \$I17.P10.GatPoly vout.$270.Metal1 0.00594737f
Cred_795 \$I17.P10.GatPoly vout.$290.Metal1 0.00594809f
Cred_796 \$I17.P10.GatPoly vout.$330.Metal1 0.00598025f
Cred_797 \$I17.P10.GatPoly vout.$350.Metal1 0.00789344f
Cred_798 \$I17.P10.GatPoly vout.$400.Metal1 0.00868084f
Cred_799 \$I17.P10.GatPoly vout.$592.Metal2 1.56886e-05f
Cred_800 \$I17.P10.GatPoly vout.$612.Metal2 2.98064e-05f
Cred_801 \$I17.P10.GatPoly vout.$652.Metal2 1.81802e-05f
Cred_802 \$I17.P10.GatPoly vout.$672.Metal2 3.58831e-05f
Cred_803 \$I17.P10.GatPoly vout.$692.Metal2 1.03999e-05f
Cred_804 \$I17.P10.GatPoly vout.$712.Metal2 3.54639e-05f
Cred_805 \$I17.P10.GatPoly vout.$732.Metal2 1.72395e-05f
Cred_806 \$I17.P10.GatPoly vout.$752.Metal2 4.18787e-06f
Cred_807 \$I17.P10.GatPoly vout.$772.Metal2 8.22972e-05f
Cred_808 \$I17.P10.GatPoly vout.$792.Metal2 8.69543e-05f
Cred_809 \$I17.P10.GatPoly vout.P8.pSD 0.000190083f
Cred_810 \$I17.P10.GatPoly vss.$1282.Metal5 0.00214165f
Cred_811 \$I17.P11.GatPoly \$I33.$82.Metal2 0.00725749f
Cred_812 \$I17.P11.GatPoly \$I33.P1.GatPoly 4.97138e-05f
Cred_813 \$I17.P11.GatPoly \$I33.P2.GatPoly 0.0706499f
Cred_814 \$I17.P11.GatPoly \$I50 0.0191995f
Cred_815 \$I17.P11.GatPoly vss 0.000236542f
Cred_816 \$I17.P11.GatPoly vdd.$2365.Metal1 2.97814e-06f
Cred_817 \$I17.P11.GatPoly vdd.$2382.Metal1 0.000681312f
Cred_818 \$I17.P11.GatPoly vdd.$2385.Metal1 0.0013747f
Cred_819 \$I17.P11.GatPoly vdd.$2399.Metal1 4.36754e-06f
Cred_820 \$I17.P11.GatPoly vdd.$2779.Metal2 0.0149164f
Cred_821 \$I17.P11.GatPoly vdd.$2781.Metal2 0.00778115f
Cred_822 \$I17.P11.GatPoly vdd.$3011.Metal3 8.94348e-08f
Cred_823 \$I17.P11.GatPoly vdd.$3015.Metal3 0.0102885f
Cred_824 \$I17.P11.GatPoly vdd.$3247.Metal4 1.05451e-09f
Cred_825 \$I17.P11.GatPoly vdd.P0.nSD 0.000441528f
Cred_826 \$I17.P11.GatPoly vdd.P1.GatPoly 1.32463e-07f
Cred_827 \$I17.P11.GatPoly vdd.P13.pSD 0.0279095f
Cred_828 \$I17.P11.GatPoly vdd.P2.GatPoly 1.94262e-07f
Cred_829 \$I17.P11.GatPoly vout 5.97232e-07f
Cred_830 \$I17.P11.GatPoly vout.$1002.Metal3 1.05917e-06f
Cred_831 \$I17.P11.GatPoly vout.$1162.Metal3 2.59218e-07f
Cred_832 \$I17.P11.GatPoly vout.$1299.Metal4 7.19168e-12f
Cred_833 \$I17.P11.GatPoly vout.$1313.Metal4 6.01628e-06f
Cred_834 \$I17.P11.GatPoly vout.$1373.Metal4 0.00264013f
Cred_835 \$I17.P11.GatPoly vout.$1383.Metal4 0.0211547f
Cred_836 \$I17.P11.GatPoly vout.$161.Metal1 0.000784769f
Cred_837 \$I17.P11.GatPoly vout.$201.Metal1 0.00406978f
Cred_838 \$I17.P11.GatPoly vout.$231.Metal1 0.00794417f
Cred_839 \$I17.P11.GatPoly vout.$271.Metal1 0.00594737f
Cred_840 \$I17.P11.GatPoly vout.$291.Metal1 0.00594809f
Cred_841 \$I17.P11.GatPoly vout.$331.Metal1 0.00598025f
Cred_842 \$I17.P11.GatPoly vout.$351.Metal1 0.00789348f
Cred_843 \$I17.P11.GatPoly vout.$401.Metal1 0.00868084f
Cred_844 \$I17.P11.GatPoly vout.$594.Metal2 4.43308e-06f
Cred_845 \$I17.P11.GatPoly vout.$614.Metal2 2.62284e-07f
Cred_846 \$I17.P11.GatPoly vout.$634.Metal2 4.14339e-05f
Cred_847 \$I17.P11.GatPoly vout.$654.Metal2 1.63559e-05f
Cred_848 \$I17.P11.GatPoly vout.$674.Metal2 3.58831e-05f
Cred_849 \$I17.P11.GatPoly vout.$694.Metal2 1.03999e-05f
Cred_850 \$I17.P11.GatPoly vout.$714.Metal2 3.54639e-05f
Cred_851 \$I17.P11.GatPoly vout.$734.Metal2 1.92924e-05f
Cred_852 \$I17.P11.GatPoly vout.$774.Metal2 8.43544e-05f
Cred_853 \$I17.P11.GatPoly vout.$794.Metal2 8.69621e-05f
Cred_854 \$I17.P11.GatPoly vout.P0.GatPoly 9.36856e-11f
Cred_855 \$I17.P11.GatPoly vout.P10.pSD 0.000190431f
Cred_856 \$I17.P11.GatPoly vref 8.0845e-06f
Cred_857 \$I17.P11.GatPoly vref.P0.GatPoly 3.1466e-07f
Cred_858 \$I17.P11.GatPoly vref.P0.nSD 1.68159e-06f
Cred_859 \$I17.P11.GatPoly vref.P0.pSD 5.46938e-06f
Cred_860 \$I17.P11.GatPoly vss.$1300.Metal5 0.00197917f
Cred_861 \$I17.P12.GatPoly \$I50 0.0193278f
Cred_862 \$I17.P12.GatPoly vss 0.000236187f
Cred_863 \$I17.P12.GatPoly vdd.$2365.Metal1 2.674e-06f
Cred_864 \$I17.P12.GatPoly vdd.$2385.Metal1 0.00193035f
Cred_865 \$I17.P12.GatPoly vdd.$2399.Metal1 5.05769e-06f
Cred_866 \$I17.P12.GatPoly vdd.$2783.Metal2 0.00832253f
Cred_867 \$I17.P12.GatPoly vdd.$2785.Metal2 0.0144443f
Cred_868 \$I17.P12.GatPoly vdd.$3015.Metal3 0.00516426f
Cred_869 \$I17.P12.GatPoly vdd.$3019.Metal3 0.00516426f
Cred_870 \$I17.P12.GatPoly vdd.$3251.Metal4 6.0891e-05f
Cred_871 \$I17.P12.GatPoly vdd.P0.nSD 0.000444937f
Cred_872 \$I17.P12.GatPoly vdd.P1.GatPoly 1.18936e-07f
Cred_873 \$I17.P12.GatPoly vdd.P15.pSD 0.0279565f
Cred_874 \$I17.P12.GatPoly vdd.P2.GatPoly 2.24958e-07f
Cred_875 \$I17.P12.GatPoly vout 5.77491e-05f
Cred_876 \$I17.P12.GatPoly vout.$1002.Metal3 1.92299e-08f
Cred_877 \$I17.P12.GatPoly vout.$1162.Metal3 2.59218e-07f
Cred_878 \$I17.P12.GatPoly vout.$1299.Metal4 6.95397e-10f
Cred_879 \$I17.P12.GatPoly vout.$1313.Metal4 0.000104203f
Cred_880 \$I17.P12.GatPoly vout.$1373.Metal4 0.000158478f
Cred_881 \$I17.P12.GatPoly vout.$1383.Metal4 0.0225827f
Cred_882 \$I17.P12.GatPoly vout.$161.Metal1 0.00086332f
Cred_883 \$I17.P12.GatPoly vout.$201.Metal1 0.00406918f
Cred_884 \$I17.P12.GatPoly vout.$231.Metal1 0.00794417f
Cred_885 \$I17.P12.GatPoly vout.$271.Metal1 0.0059635f
Cred_886 \$I17.P12.GatPoly vout.$291.Metal1 0.00596378f
Cred_887 \$I17.P12.GatPoly vout.$331.Metal1 0.00598025f
Cred_888 \$I17.P12.GatPoly vout.$351.Metal1 0.00789348f
Cred_889 \$I17.P12.GatPoly vout.$401.Metal1 0.00868084f
Cred_890 \$I17.P12.GatPoly vout.$594.Metal2 4.10998e-06f
Cred_891 \$I17.P12.GatPoly vout.$614.Metal2 2.6176e-07f
Cred_892 \$I17.P12.GatPoly vout.$634.Metal2 4.14339e-05f
Cred_893 \$I17.P12.GatPoly vout.$654.Metal2 1.63559e-05f
Cred_894 \$I17.P12.GatPoly vout.$674.Metal2 3.58831e-05f
Cred_895 \$I17.P12.GatPoly vout.$694.Metal2 1.05688e-05f
Cred_896 \$I17.P12.GatPoly vout.$714.Metal2 3.54639e-05f
Cred_897 \$I17.P12.GatPoly vout.$734.Metal2 1.92924e-05f
Cred_898 \$I17.P12.GatPoly vout.$774.Metal2 8.43544e-05f
Cred_899 \$I17.P12.GatPoly vout.$794.Metal2 8.69621e-05f
Cred_900 \$I17.P12.GatPoly vout.P0.GatPoly 9.0589e-09f
Cred_901 \$I17.P12.GatPoly vout.P10.pSD 0.000189753f
Cred_902 \$I17.P13.GatPoly \$I50 0.0193565f
Cred_903 \$I17.P13.GatPoly vss 0.000188426f
Cred_904 \$I17.P13.GatPoly vdd.$2365.Metal1 2.50152e-06f
Cred_905 \$I17.P13.GatPoly vdd.$2385.Metal1 0.000928243f
Cred_906 \$I17.P13.GatPoly vdd.$2387.Metal1 0.000928224f
Cred_907 \$I17.P13.GatPoly vdd.$2399.Metal1 6.06789e-06f
Cred_908 \$I17.P13.GatPoly vdd.$2783.Metal2 0.00529712f
Cred_909 \$I17.P13.GatPoly vdd.$2785.Metal2 0.0172508f
Cred_910 \$I17.P13.GatPoly vdd.$2789.Metal2 1.26129e-06f
Cred_911 \$I17.P13.GatPoly vdd.$2791.Metal2 3.54739e-07f
Cred_912 \$I17.P13.GatPoly vdd.$3019.Metal3 0.0105187f
Cred_913 \$I17.P13.GatPoly vdd.P0.nSD 0.000474343f
Cred_914 \$I17.P13.GatPoly vdd.P1.GatPoly 1.11264e-07f
Cred_915 \$I17.P13.GatPoly vdd.P15.pSD 0.0279641f
Cred_916 \$I17.P13.GatPoly vdd.P17.pSD 2.3877e-06f
Cred_917 \$I17.P13.GatPoly vdd.P2.GatPoly 2.69891e-07f
Cred_918 \$I17.P13.GatPoly vout 5.77836e-05f
Cred_919 \$I17.P13.GatPoly vout.$1004.Metal3 1.68531e-06f
Cred_920 \$I17.P13.GatPoly vout.$1006.Metal3 3.5978e-07f
Cred_921 \$I17.P13.GatPoly vout.$1044.Metal3 3.65666e-08f
Cred_922 \$I17.P13.GatPoly vout.$1164.Metal3 2.59218e-07f
Cred_923 \$I17.P13.GatPoly vout.$1299.Metal4 9.66358e-09f
Cred_924 \$I17.P13.GatPoly vout.$1313.Metal4 0.000120912f
Cred_925 \$I17.P13.GatPoly vout.$1373.Metal4 0.000166178f
Cred_926 \$I17.P13.GatPoly vout.$1394.Metal4 0.0225473f
Cred_927 \$I17.P13.GatPoly vout.$162.Metal1 0.00153137f
Cred_928 \$I17.P13.GatPoly vout.$163.Metal1 6.43986e-07f
Cred_929 \$I17.P13.GatPoly vout.$212.Metal1 0.00537099f
Cred_930 \$I17.P13.GatPoly vout.$213.Metal1 1.30331e-07f
Cred_931 \$I17.P13.GatPoly vout.$232.Metal1 0.00598064f
Cred_932 \$I17.P13.GatPoly vout.$272.Metal1 0.00595921f
Cred_933 \$I17.P13.GatPoly vout.$292.Metal1 0.00595961f
Cred_934 \$I17.P13.GatPoly vout.$332.Metal1 0.00598025f
Cred_935 \$I17.P13.GatPoly vout.$352.Metal1 0.00789348f
Cred_936 \$I17.P13.GatPoly vout.$402.Metal1 0.00868084f
Cred_937 \$I17.P13.GatPoly vout.$596.Metal2 1.61564e-05f
Cred_938 \$I17.P13.GatPoly vout.$598.Metal2 9.43324e-08f
Cred_939 \$I17.P13.GatPoly vout.$616.Metal2 2.98203e-05f
Cred_940 \$I17.P13.GatPoly vout.$618.Metal2 2.84579e-09f
Cred_941 \$I17.P13.GatPoly vout.$656.Metal2 1.81802e-05f
Cred_942 \$I17.P13.GatPoly vout.$676.Metal2 3.58831e-05f
Cred_943 \$I17.P13.GatPoly vout.$696.Metal2 1.05239e-05f
Cred_944 \$I17.P13.GatPoly vout.$716.Metal2 3.54639e-05f
Cred_945 \$I17.P13.GatPoly vout.$736.Metal2 1.92924e-05f
Cred_946 \$I17.P13.GatPoly vout.$776.Metal2 8.43544e-05f
Cred_947 \$I17.P13.GatPoly vout.$796.Metal2 8.69621e-05f
Cred_948 \$I17.P13.GatPoly vout.P0.GatPoly 1.54021e-07f
Cred_949 \$I17.P13.GatPoly vout.P12.pSD 0.000190958f
Cred_950 \$I17.P13.GatPoly vout.P14.pSD 1.7497e-07f
Cred_951 \$I17.P13.GatPoly vref 2.85209e-07f
Cred_952 \$I17.P13.GatPoly vref.P0.GatPoly 1.08529e-08f
Cred_953 \$I17.P13.GatPoly vref.P0.nSD 6.56373e-09f
Cred_954 \$I17.P13.GatPoly vref.P0.pSD 1.15045e-08f
Cred_955 \$I17.P14.GatPoly \$I50 0.0193644f
Cred_956 \$I17.P14.GatPoly vss 0.000199405f
Cred_957 \$I17.P14.GatPoly vdd.$2365.Metal1 1.99473e-06f
Cred_958 \$I17.P14.GatPoly vdd.$2387.Metal1 0.000698169f
Cred_959 \$I17.P14.GatPoly vdd.$2389.Metal1 0.000698139f
Cred_960 \$I17.P14.GatPoly vdd.$2399.Metal1 6.27087e-06f
Cred_961 \$I17.P14.GatPoly vdd.$2783.Metal2 2.66027e-07f
Cred_962 \$I17.P14.GatPoly vdd.$2785.Metal2 7.25528e-07f
Cred_963 \$I17.P14.GatPoly vdd.$2789.Metal2 0.0206095f
Cred_964 \$I17.P14.GatPoly vdd.$2791.Metal2 0.00512974f
Cred_965 \$I17.P14.GatPoly vdd.$3023.Metal3 0.00211274f
Cred_966 \$I17.P14.GatPoly vdd.P0.nSD 0.000430248f
Cred_967 \$I17.P14.GatPoly vdd.P1.GatPoly 8.87227e-08f
Cred_968 \$I17.P14.GatPoly vdd.P15.pSD 1.40642e-06f
Cred_969 \$I17.P14.GatPoly vdd.P17.pSD 0.033534f
Cred_970 \$I17.P14.GatPoly vdd.P2.GatPoly 2.78919e-07f
Cred_971 \$I17.P14.GatPoly vout 7.20542e-05f
Cred_972 \$I17.P14.GatPoly vout.$1004.Metal3 1.91014e-06f
Cred_973 \$I17.P14.GatPoly vout.$1006.Metal3 7.1964e-07f
Cred_974 \$I17.P14.GatPoly vout.$1044.Metal3 3.65666e-08f
Cred_975 \$I17.P14.GatPoly vout.$1164.Metal3 2.59218e-07f
Cred_976 \$I17.P14.GatPoly vout.$1299.Metal4 2.32697e-07f
Cred_977 \$I17.P14.GatPoly vout.$1313.Metal4 0.000125857f
Cred_978 \$I17.P14.GatPoly vout.$1373.Metal4 0.000168745f
Cred_979 \$I17.P14.GatPoly vout.$1394.Metal4 0.0225827f
Cred_980 \$I17.P14.GatPoly vout.$162.Metal1 0.00152771f
Cred_981 \$I17.P14.GatPoly vout.$163.Metal1 1.28811e-06f
Cred_982 \$I17.P14.GatPoly vout.$212.Metal1 0.00537112f
Cred_983 \$I17.P14.GatPoly vout.$213.Metal1 2.60691e-07f
Cred_984 \$I17.P14.GatPoly vout.$232.Metal1 0.00598064f
Cred_985 \$I17.P14.GatPoly vout.$272.Metal1 0.0059635f
Cred_986 \$I17.P14.GatPoly vout.$292.Metal1 0.00596378f
Cred_987 \$I17.P14.GatPoly vout.$332.Metal1 0.00598025f
Cred_988 \$I17.P14.GatPoly vout.$352.Metal1 0.00789348f
Cred_989 \$I17.P14.GatPoly vout.$402.Metal1 0.00868084f
Cred_990 \$I17.P14.GatPoly vout.$596.Metal2 1.6204e-05f
Cred_991 \$I17.P14.GatPoly vout.$598.Metal2 1.88686e-07f
Cred_992 \$I17.P14.GatPoly vout.$616.Metal2 2.98232e-05f
Cred_993 \$I17.P14.GatPoly vout.$618.Metal2 5.69221e-09f
Cred_994 \$I17.P14.GatPoly vout.$656.Metal2 1.81802e-05f
Cred_995 \$I17.P14.GatPoly vout.$676.Metal2 3.58831e-05f
Cred_996 \$I17.P14.GatPoly vout.$696.Metal2 1.05688e-05f
Cred_997 \$I17.P14.GatPoly vout.$716.Metal2 3.54639e-05f
Cred_998 \$I17.P14.GatPoly vout.$736.Metal2 1.92924e-05f
Cred_999 \$I17.P14.GatPoly vout.$776.Metal2 8.43544e-05f
Cred_1000 \$I17.P14.GatPoly vout.$796.Metal2 8.69621e-05f
Cred_1001 \$I17.P14.GatPoly vout.P0.GatPoly 7.33345e-06f
Cred_1002 \$I17.P14.GatPoly vout.P12.pSD 0.000191133f
Cred_1003 \$I17.P14.GatPoly vout.P14.pSD 3.49979e-07f
Cred_1004 \$I17.P14.GatPoly vref 3.53783e-07f
Cred_1005 \$I17.P14.GatPoly vref.P0.GatPoly 1.34623e-08f
Cred_1006 \$I17.P14.GatPoly vref.P0.nSD 8.14188e-09f
Cred_1007 \$I17.P14.GatPoly vref.P0.pSD 1.42706e-08f
Cred_1008 \$I17.P15.GatPoly \$I50 0.0193626f
Cred_1009 \$I17.P15.GatPoly vss 0.000247554f
Cred_1010 \$I17.P15.GatPoly vdd.$2365.Metal1 1.89234e-06f
Cred_1011 \$I17.P15.GatPoly vdd.$2389.Metal1 0.00207979f
Cred_1012 \$I17.P15.GatPoly vdd.$2399.Metal1 7.62327e-06f
Cred_1013 \$I17.P15.GatPoly vdd.$2783.Metal2 1.32999e-07f
Cred_1014 \$I17.P15.GatPoly vdd.$2785.Metal2 3.62724e-07f
Cred_1015 \$I17.P15.GatPoly vdd.$2789.Metal2 0.0154153f
Cred_1016 \$I17.P15.GatPoly vdd.$2791.Metal2 0.0073352f
Cred_1017 \$I17.P15.GatPoly vdd.$3023.Metal3 0.00509498f
Cred_1018 \$I17.P15.GatPoly vdd.$3027.Metal3 0.00509498f
Cred_1019 \$I17.P15.GatPoly vdd.$3259.Metal4 6.00741e-05f
Cred_1020 \$I17.P15.GatPoly vdd.P0.nSD 0.000459074f
Cred_1021 \$I17.P15.GatPoly vdd.P1.GatPoly 8.41684e-08f
Cred_1022 \$I17.P15.GatPoly vdd.P15.pSD 7.03133e-07f
Cred_1023 \$I17.P15.GatPoly vdd.P17.pSD 0.0279568f
Cred_1024 \$I17.P15.GatPoly vdd.P2.GatPoly 3.39071e-07f
Cred_1025 \$I17.P15.GatPoly vout 6.51736e-05f
Cred_1026 \$I17.P15.GatPoly vout.$1004.Metal3 9.45349e-07f
Cred_1027 \$I17.P15.GatPoly vout.$1006.Metal3 1.09974e-06f
Cred_1028 \$I17.P15.GatPoly vout.$1046.Metal3 3.65666e-08f
Cred_1029 \$I17.P15.GatPoly vout.$1166.Metal3 2.59218e-07f
Cred_1030 \$I17.P15.GatPoly vout.$1299.Metal4 6.90655e-09f
Cred_1031 \$I17.P15.GatPoly vout.$1313.Metal4 0.000121219f
Cred_1032 \$I17.P15.GatPoly vout.$1373.Metal4 0.000166178f
Cred_1033 \$I17.P15.GatPoly vout.$1415.Metal4 0.00176241f
Cred_1034 \$I17.P15.GatPoly vout.$162.Metal1 1.92631e-06f
Cred_1035 \$I17.P15.GatPoly vout.$163.Metal1 0.00153009f
Cred_1036 \$I17.P15.GatPoly vout.$212.Metal1 3.91022e-07f
Cred_1037 \$I17.P15.GatPoly vout.$213.Metal1 0.00537073f
Cred_1038 \$I17.P15.GatPoly vout.$233.Metal1 0.0266937f
Cred_1039 \$I17.P15.GatPoly vout.$273.Metal1 0.00595921f
Cred_1040 \$I17.P15.GatPoly vout.$293.Metal1 0.00595961f
Cred_1041 \$I17.P15.GatPoly vout.$333.Metal1 0.00598025f
Cred_1042 \$I17.P15.GatPoly vout.$353.Metal1 0.00789348f
Cred_1043 \$I17.P15.GatPoly vout.$403.Metal1 0.00868084f
Cred_1044 \$I17.P15.GatPoly vout.$596.Metal2 2.80375e-07f
Cred_1045 \$I17.P15.GatPoly vout.$598.Metal2 1.59704e-05f
Cred_1046 \$I17.P15.GatPoly vout.$616.Metal2 8.538e-09f
Cred_1047 \$I17.P15.GatPoly vout.$618.Metal2 2.98146e-05f
Cred_1048 \$I17.P15.GatPoly vout.$658.Metal2 1.81802e-05f
Cred_1049 \$I17.P15.GatPoly vout.$678.Metal2 3.58831e-05f
Cred_1050 \$I17.P15.GatPoly vout.$698.Metal2 1.05239e-05f
Cred_1051 \$I17.P15.GatPoly vout.$718.Metal2 3.54639e-05f
Cred_1052 \$I17.P15.GatPoly vout.$738.Metal2 1.92924e-05f
Cred_1053 \$I17.P15.GatPoly vout.$778.Metal2 8.43544e-05f
Cred_1054 \$I17.P15.GatPoly vout.$798.Metal2 8.69621e-05f
Cred_1055 \$I17.P15.GatPoly vout.P0.GatPoly 1.18105e-07f
Cred_1056 \$I17.P15.GatPoly vout.P12.pSD 5.24948e-07f
Cred_1057 \$I17.P15.GatPoly vout.P14.pSD 0.000190608f
Cred_1058 \$I17.P15.GatPoly vref 4.22436e-07f
Cred_1059 \$I17.P15.GatPoly vref.P0.GatPoly 1.60747e-08f
Cred_1060 \$I17.P15.GatPoly vref.P0.nSD 9.72184e-09f
Cred_1061 \$I17.P15.GatPoly vref.P0.pSD 1.70398e-08f
Cred_1062 \$I17.P16.GatPoly \$I50 0.0193278f
Cred_1063 \$I17.P16.GatPoly vss 0.000243081f
Cred_1064 \$I17.P16.GatPoly vdd.$2365.Metal1 1.60055e-06f
Cred_1065 \$I17.P16.GatPoly vdd.$2389.Metal1 0.00127627f
Cred_1066 \$I17.P16.GatPoly vdd.$2392.Metal1 0.000632538f
Cred_1067 \$I17.P16.GatPoly vdd.$2399.Metal1 8.38079e-06f
Cred_1068 \$I17.P16.GatPoly vdd.$2793.Metal2 0.00877377f
Cred_1069 \$I17.P16.GatPoly vdd.$2795.Metal2 0.0139703f
Cred_1070 \$I17.P16.GatPoly vdd.$3027.Metal3 0.0104378f
Cred_1071 \$I17.P16.GatPoly vdd.P0.nSD 0.000448704f
Cred_1072 \$I17.P16.GatPoly vdd.P1.GatPoly 7.119e-08f
Cred_1073 \$I17.P16.GatPoly vdd.P19.pSD 0.0279591f
Cred_1074 \$I17.P16.GatPoly vdd.P2.GatPoly 3.72765e-07f
Cred_1075 \$I17.P16.GatPoly vout 5.77491e-05f
Cred_1076 \$I17.P16.GatPoly vout.$1006.Metal3 1.92299e-08f
Cred_1077 \$I17.P16.GatPoly vout.$1046.Metal3 3.65666e-08f
Cred_1078 \$I17.P16.GatPoly vout.$1166.Metal3 2.59218e-07f
Cred_1079 \$I17.P16.GatPoly vout.$1299.Metal4 6.95397e-10f
Cred_1080 \$I17.P16.GatPoly vout.$1313.Metal4 0.000107045f
Cred_1081 \$I17.P16.GatPoly vout.$1373.Metal4 0.000158478f
Cred_1082 \$I17.P16.GatPoly vout.$1415.Metal4 0.00176241f
Cred_1083 \$I17.P16.GatPoly vout.$163.Metal1 0.00152386f
Cred_1084 \$I17.P16.GatPoly vout.$213.Metal1 0.00537034f
Cred_1085 \$I17.P16.GatPoly vout.$233.Metal1 0.00598064f
Cred_1086 \$I17.P16.GatPoly vout.$273.Metal1 0.0059635f
Cred_1087 \$I17.P16.GatPoly vout.$293.Metal1 0.0266699f
Cred_1088 \$I17.P16.GatPoly vout.$333.Metal1 0.00598025f
Cred_1089 \$I17.P16.GatPoly vout.$353.Metal1 0.00789348f
Cred_1090 \$I17.P16.GatPoly vout.$403.Metal1 0.00868084f
Cred_1091 \$I17.P16.GatPoly vout.$598.Metal2 1.56432e-05f
Cred_1092 \$I17.P16.GatPoly vout.$618.Metal2 2.98061e-05f
Cred_1093 \$I17.P16.GatPoly vout.$658.Metal2 1.81802e-05f
Cred_1094 \$I17.P16.GatPoly vout.$678.Metal2 3.58831e-05f
Cred_1095 \$I17.P16.GatPoly vout.$698.Metal2 1.05688e-05f
Cred_1096 \$I17.P16.GatPoly vout.$718.Metal2 3.54639e-05f
Cred_1097 \$I17.P16.GatPoly vout.$738.Metal2 1.92924e-05f
Cred_1098 \$I17.P16.GatPoly vout.$778.Metal2 8.43544e-05f
Cred_1099 \$I17.P16.GatPoly vout.$798.Metal2 8.69621e-05f
Cred_1100 \$I17.P16.GatPoly vout.P0.GatPoly 9.0589e-09f
Cred_1101 \$I17.P16.GatPoly vout.P14.pSD 0.000190083f
Cred_1102 \$I17.P17.GatPoly \$I50 0.0194209f
Cred_1103 \$I17.P17.GatPoly vss 0.000259101f
Cred_1104 \$I17.P17.GatPoly vdd.$2365.Metal1 1.51848e-06f
Cred_1105 \$I17.P17.GatPoly vdd.$2389.Metal1 0.000637747f
Cred_1106 \$I17.P17.GatPoly vdd.$2392.Metal1 0.00128684f
Cred_1107 \$I17.P17.GatPoly vdd.$2394.Metal1 4.79581e-09f
Cred_1108 \$I17.P17.GatPoly vdd.$2399.Metal1 1.46068e-05f
Cred_1109 \$I17.P17.GatPoly vdd.$2793.Metal2 0.0057874f
Cred_1110 \$I17.P17.GatPoly vdd.$2795.Metal2 0.0169554f
Cred_1111 \$I17.P17.GatPoly vdd.$2799.Metal2 3.80191e-06f
Cred_1112 \$I17.P17.GatPoly vdd.$2803.Metal2 6.77276e-07f
Cred_1113 \$I17.P17.GatPoly vdd.$2805.Metal2 6.49693e-07f
Cred_1114 \$I17.P17.GatPoly vdd.$2807.Metal2 8.4867e-07f
Cred_1115 \$I17.P17.GatPoly vdd.$3027.Metal3 0.00511964f
Cred_1116 \$I17.P17.GatPoly vdd.$3031.Metal3 0.00511964f
Cred_1117 \$I17.P17.GatPoly vdd.$3035.Metal3 4.79581e-09f
Cred_1118 \$I17.P17.GatPoly vdd.$3263.Metal4 6.03648e-05f
Cred_1119 \$I17.P17.GatPoly vdd.P0.nSD 0.000517097f
Cred_1120 \$I17.P17.GatPoly vdd.P1.GatPoly 6.75395e-08f
Cred_1121 \$I17.P17.GatPoly vdd.P19.pSD 0.0279666f
Cred_1122 \$I17.P17.GatPoly vdd.P2.GatPoly 2.40854e-06f
Cred_1123 \$I17.P17.GatPoly vdd.P21.pSD 6.22705e-06f
Cred_1124 \$I17.P17.GatPoly vdd.P23.pSD 1.58518e-06f
Cred_1125 \$I17.P17.GatPoly vdd.P25.pSD 7.41029e-07f
Cred_1126 \$I17.P17.GatPoly vout 7.3005e-05f
Cred_1127 \$I17.P17.GatPoly vout.$1008.Metal3 2.62856e-06f
Cred_1128 \$I17.P17.GatPoly vout.$1010.Metal3 2.52878e-06f
Cred_1129 \$I17.P17.GatPoly vout.$1048.Metal3 3.65666e-08f
Cred_1130 \$I17.P17.GatPoly vout.$1168.Metal3 4.11479e-08f
Cred_1131 \$I17.P17.GatPoly vout.$1208.Metal3 2.23507e-05f
Cred_1132 \$I17.P17.GatPoly vout.$1299.Metal4 8.79102e-10f
Cred_1133 \$I17.P17.GatPoly vout.$1313.Metal4 0.000140132f
Cred_1134 \$I17.P17.GatPoly vout.$1373.Metal4 0.000173862f
Cred_1135 \$I17.P17.GatPoly vout.$1415.Metal4 0.00108455f
Cred_1136 \$I17.P17.GatPoly vout.$164.Metal1 0.0015333f
Cred_1137 \$I17.P17.GatPoly vout.$165.Metal1 4.88368e-06f
Cred_1138 \$I17.P17.GatPoly vout.$214.Metal1 0.00537138f
Cred_1139 \$I17.P17.GatPoly vout.$215.Metal1 1.04103e-06f
Cred_1140 \$I17.P17.GatPoly vout.$234.Metal1 0.00598064f
Cred_1141 \$I17.P17.GatPoly vout.$274.Metal1 0.00595921f
Cred_1142 \$I17.P17.GatPoly vout.$294.Metal1 0.0273119f
Cred_1143 \$I17.P17.GatPoly vout.$334.Metal1 0.00598025f
Cred_1144 \$I17.P17.GatPoly vout.$354.Metal1 0.00789348f
Cred_1145 \$I17.P17.GatPoly vout.$404.Metal1 0.00868085f
Cred_1146 \$I17.P17.GatPoly vout.$600.Metal2 1.64362e-05f
Cred_1147 \$I17.P17.GatPoly vout.$602.Metal2 7.46723e-07f
Cred_1148 \$I17.P17.GatPoly vout.$620.Metal2 2.98288e-05f
Cred_1149 \$I17.P17.GatPoly vout.$622.Metal2 2.2731e-08f
Cred_1150 \$I17.P17.GatPoly vout.$660.Metal2 1.81802e-05f
Cred_1151 \$I17.P17.GatPoly vout.$680.Metal2 3.58831e-05f
Cred_1152 \$I17.P17.GatPoly vout.$700.Metal2 1.05239e-05f
Cred_1153 \$I17.P17.GatPoly vout.$720.Metal2 3.54639e-05f
Cred_1154 \$I17.P17.GatPoly vout.$740.Metal2 1.92924e-05f
Cred_1155 \$I17.P17.GatPoly vout.$780.Metal2 8.43501e-05f
Cred_1156 \$I17.P17.GatPoly vout.$800.Metal2 8.71537e-05f
Cred_1157 \$I17.P17.GatPoly vout.P0.GatPoly 1.1452e-08f
Cred_1158 \$I17.P17.GatPoly vout.P16.pSD 0.000191482f
Cred_1159 \$I17.P17.GatPoly vout.P18.pSD 1.61043e-06f
Cred_1160 \$I17.P17.GatPoly vref 1.81969e-06f
Cred_1161 \$I17.P17.GatPoly vref.P0.GatPoly 5.49459e-08f
Cred_1162 \$I17.P17.GatPoly vref.P0.nSD 3.32308e-08f
Cred_1163 \$I17.P17.GatPoly vref.P0.pSD 5.82449e-08f
Cred_1164 \$I17.P17.GatPoly vss 1.22654e-06f
Cred_1165 \$I17.P17.GatPoly vss.$1212.Metal5 1.26494e-06f
Cred_1166 \$I17.P17.GatPoly vss.$1230.Metal5 1.26494e-06f
Cred_1167 \$I17.P17.GatPoly vss.$1282.Metal5 4.84195e-06f
Cred_1168 \$I17.P17.GatPoly vss.$1300.Metal5 4.84195e-06f
Cred_1169 \$I17.P18.GatPoly \$I50 0.0194907f
Cred_1170 \$I17.P18.GatPoly vss 0.000271686f
Cred_1171 \$I17.P18.GatPoly vdd.$2365.Metal1 1.37224e-06f
Cred_1172 \$I17.P18.GatPoly vdd.$2392.Metal1 0.000499772f
Cred_1173 \$I17.P18.GatPoly vdd.$2394.Metal1 0.000526715f
Cred_1174 \$I17.P18.GatPoly vdd.$2399.Metal1 2.04986e-05f
Cred_1175 \$I17.P18.GatPoly vdd.$2793.Metal2 5.79706e-07f
Cred_1176 \$I17.P18.GatPoly vdd.$2795.Metal2 1.40096e-06f
Cred_1177 \$I17.P18.GatPoly vdd.$2799.Metal2 0.0235312f
Cred_1178 \$I17.P18.GatPoly vdd.$2803.Metal2 0.00228653f
Cred_1179 \$I17.P18.GatPoly vdd.$2805.Metal2 1.29953e-06f
Cred_1180 \$I17.P18.GatPoly vdd.$2807.Metal2 1.69753e-06f
Cred_1181 \$I17.P18.GatPoly vdd.$3031.Metal3 0.000944627f
Cred_1182 \$I17.P18.GatPoly vdd.$3035.Metal3 0.000971581f
Cred_1183 \$I17.P18.GatPoly vdd.$3267.Metal4 1.1138e-05f
Cred_1184 \$I17.P18.GatPoly vdd.P0.nSD 0.000556041f
Cred_1185 \$I17.P18.GatPoly vdd.P1.GatPoly 6.10351e-08f
Cred_1186 \$I17.P18.GatPoly vdd.P19.pSD 2.80564e-06f
Cred_1187 \$I17.P18.GatPoly vdd.P2.GatPoly 4.42984e-06f
Cred_1188 \$I17.P18.GatPoly vdd.P21.pSD 0.0337115f
Cred_1189 \$I17.P18.GatPoly vdd.P23.pSD 3.17072e-06f
Cred_1190 \$I17.P18.GatPoly vdd.P25.pSD 1.48222e-06f
Cred_1191 \$I17.P18.GatPoly vout 8.34367e-05f
Cred_1192 \$I17.P18.GatPoly vout.$1008.Metal3 3.79686e-06f
Cred_1193 \$I17.P18.GatPoly vout.$1010.Metal3 5.05813e-06f
Cred_1194 \$I17.P18.GatPoly vout.$1048.Metal3 3.65666e-08f
Cred_1195 \$I17.P18.GatPoly vout.$1168.Metal3 4.11479e-08f
Cred_1196 \$I17.P18.GatPoly vout.$1208.Metal3 2.23507e-05f
Cred_1197 \$I17.P18.GatPoly vout.$1299.Metal4 1.00472e-09f
Cred_1198 \$I17.P18.GatPoly vout.$1313.Metal4 0.000163803f
Cred_1199 \$I17.P18.GatPoly vout.$1373.Metal4 0.000184115f
Cred_1200 \$I17.P18.GatPoly vout.$1415.Metal4 0.00108455f
Cred_1201 \$I17.P18.GatPoly vout.$164.Metal1 0.00153155f
Cred_1202 \$I17.P18.GatPoly vout.$165.Metal1 9.76845e-06f
Cred_1203 \$I17.P18.GatPoly vout.$214.Metal1 0.0053719f
Cred_1204 \$I17.P18.GatPoly vout.$215.Metal1 2.0823e-06f
Cred_1205 \$I17.P18.GatPoly vout.$234.Metal1 0.00598064f
Cred_1206 \$I17.P18.GatPoly vout.$274.Metal1 0.0059635f
Cred_1207 \$I17.P18.GatPoly vout.$294.Metal1 0.0273255f
Cred_1208 \$I17.P18.GatPoly vout.$334.Metal1 0.00598025f
Cred_1209 \$I17.P18.GatPoly vout.$354.Metal1 0.00789348f
Cred_1210 \$I17.P18.GatPoly vout.$404.Metal1 0.00868085f
Cred_1211 \$I17.P18.GatPoly vout.$600.Metal2 1.67635e-05f
Cred_1212 \$I17.P18.GatPoly vout.$602.Metal2 1.49361e-06f
Cred_1213 \$I17.P18.GatPoly vout.$620.Metal2 2.98402e-05f
Cred_1214 \$I17.P18.GatPoly vout.$622.Metal2 4.54671e-08f
Cred_1215 \$I17.P18.GatPoly vout.$660.Metal2 1.81802e-05f
Cred_1216 \$I17.P18.GatPoly vout.$680.Metal2 3.58831e-05f
Cred_1217 \$I17.P18.GatPoly vout.$700.Metal2 1.05688e-05f
Cred_1218 \$I17.P18.GatPoly vout.$720.Metal2 3.54639e-05f
Cred_1219 \$I17.P18.GatPoly vout.$740.Metal2 1.92924e-05f
Cred_1220 \$I17.P18.GatPoly vout.$780.Metal2 8.43501e-05f
Cred_1221 \$I17.P18.GatPoly vout.$800.Metal2 8.71537e-05f
Cred_1222 \$I17.P18.GatPoly vout.P0.GatPoly 1.30884e-08f
Cred_1223 \$I17.P18.GatPoly vout.P16.pSD 0.000192181f
Cred_1224 \$I17.P18.GatPoly vout.P18.pSD 3.22122e-06f
Cred_1225 \$I17.P18.GatPoly vref 3.14861e-06f
Cred_1226 \$I17.P18.GatPoly vref.P0.GatPoly 9.12134e-08f
Cred_1227 \$I17.P18.GatPoly vref.P0.nSD 5.51651e-08f
Cred_1228 \$I17.P18.GatPoly vref.P0.pSD 9.66899e-08f
Cred_1229 \$I17.P18.GatPoly vss 2.45336e-06f
Cred_1230 \$I17.P18.GatPoly vss.$1212.Metal5 2.53017e-06f
Cred_1231 \$I17.P18.GatPoly vss.$1230.Metal5 2.53017e-06f
Cred_1232 \$I17.P18.GatPoly vss.$1282.Metal5 9.68497e-06f
Cred_1233 \$I17.P18.GatPoly vss.$1300.Metal5 9.68497e-06f
Cred_1234 \$I17.P19.GatPoly \$I50 0.0193996f
Cred_1235 \$I17.P19.GatPoly vss 0.000280839f
Cred_1236 \$I17.P19.GatPoly vdd.$2365.Metal1 1.23386e-06f
Cred_1237 \$I17.P19.GatPoly vdd.$2394.Metal1 0.00210685f
Cred_1238 \$I17.P19.GatPoly vdd.$2399.Metal1 2.60984e-05f
Cred_1239 \$I17.P19.GatPoly vdd.$2793.Metal2 5.79449e-07f
Cred_1240 \$I17.P19.GatPoly vdd.$2795.Metal2 1.40033e-06f
Cred_1241 \$I17.P19.GatPoly vdd.$2799.Metal2 0.0192507f
Cred_1242 \$I17.P19.GatPoly vdd.$2803.Metal2 0.00335181f
Cred_1243 \$I17.P19.GatPoly vdd.$2805.Metal2 1.94966e-06f
Cred_1244 \$I17.P19.GatPoly vdd.$2807.Metal2 2.54676e-06f
Cred_1245 \$I17.P19.GatPoly vdd.$3035.Metal3 0.0103621f
Cred_1246 \$I17.P19.GatPoly vdd.P0.nSD 0.000585781f
Cred_1247 \$I17.P19.GatPoly vdd.P1.GatPoly 5.48802e-08f
Cred_1248 \$I17.P19.GatPoly vdd.P19.pSD 2.80439e-06f
Cred_1249 \$I17.P19.GatPoly vdd.P2.GatPoly 6.43893e-06f
Cred_1250 \$I17.P19.GatPoly vdd.P21.pSD 0.0279727f
Cred_1251 \$I17.P19.GatPoly vdd.P23.pSD 4.75696e-06f
Cred_1252 \$I17.P19.GatPoly vdd.P25.pSD 2.22374e-06f
Cred_1253 \$I17.P19.GatPoly vout 8.90466e-05f
Cred_1254 \$I17.P19.GatPoly vout.$1008.Metal3 3.77595e-06f
Cred_1255 \$I17.P19.GatPoly vout.$1010.Metal3 7.60868e-06f
Cred_1256 \$I17.P19.GatPoly vout.$1050.Metal3 3.65666e-08f
Cred_1257 \$I17.P19.GatPoly vout.$1110.Metal3 1.03406e-07f
Cred_1258 \$I17.P19.GatPoly vout.$1190.Metal3 2.428e-07f
Cred_1259 \$I17.P19.GatPoly vout.$1299.Metal4 1.07227e-09f
Cred_1260 \$I17.P19.GatPoly vout.$1313.Metal4 0.000173542f
Cred_1261 \$I17.P19.GatPoly vout.$1373.Metal4 0.000189237f
Cred_1262 \$I17.P19.GatPoly vout.$1416.Metal4 1.46197e-08f
Cred_1263 \$I17.P19.GatPoly vout.$164.Metal1 7.69415e-06f
Cred_1264 \$I17.P19.GatPoly vout.$165.Metal1 0.00153834f
Cred_1265 \$I17.P19.GatPoly vout.$214.Metal1 1.56184e-06f
Cred_1266 \$I17.P19.GatPoly vout.$215.Metal1 0.00537347f
Cred_1267 \$I17.P19.GatPoly vout.$235.Metal1 0.00598064f
Cred_1268 \$I17.P19.GatPoly vout.$275.Metal1 0.00595926f
Cred_1269 \$I17.P19.GatPoly vout.$295.Metal1 0.0281748f
Cred_1270 \$I17.P19.GatPoly vout.$335.Metal1 0.00598025f
Cred_1271 \$I17.P19.GatPoly vout.$355.Metal1 0.00789344f
Cred_1272 \$I17.P19.GatPoly vout.$405.Metal1 0.00868084f
Cred_1273 \$I17.P19.GatPoly vout.$600.Metal2 1.11989e-06f
Cred_1274 \$I17.P19.GatPoly vout.$602.Metal2 1.79281e-05f
Cred_1275 \$I17.P19.GatPoly vout.$620.Metal2 3.41028e-08f
Cred_1276 \$I17.P19.GatPoly vout.$622.Metal2 2.98743e-05f
Cred_1277 \$I17.P19.GatPoly vout.$662.Metal2 1.81802e-05f
Cred_1278 \$I17.P19.GatPoly vout.$682.Metal2 4.10419e-05f
Cred_1279 \$I17.P19.GatPoly vout.$722.Metal2 4.06227e-05f
Cred_1280 \$I17.P19.GatPoly vout.$742.Metal2 1.72395e-05f
Cred_1281 \$I17.P19.GatPoly vout.$762.Metal2 4.18787e-06f
Cred_1282 \$I17.P19.GatPoly vout.$782.Metal2 8.22972e-05f
Cred_1283 \$I17.P19.GatPoly vout.$802.Metal2 8.69543e-05f
Cred_1284 \$I17.P19.GatPoly vout.P0.GatPoly 1.39684e-08f
Cred_1285 \$I17.P19.GatPoly vout.P16.pSD 2.09677e-06f
Cred_1286 \$I17.P19.GatPoly vout.P18.pSD 0.000194916f
Cred_1287 \$I17.P19.GatPoly vref 3.98704e-06f
Cred_1288 \$I17.P19.GatPoly vref.P0.GatPoly 1.0881e-07f
Cred_1289 \$I17.P19.GatPoly vref.P0.nSD 6.58076e-08f
Cred_1290 \$I17.P19.GatPoly vref.P0.pSD 1.15344e-07f
Cred_1291 \$I17.P19.GatPoly vss 3.68072e-06f
Cred_1292 \$I17.P19.GatPoly vss.$1212.Metal5 3.79596e-06f
Cred_1293 \$I17.P19.GatPoly vss.$1230.Metal5 3.79596e-06f
Cred_1294 \$I17.P19.GatPoly vss.$1282.Metal5 1.45301e-05f
Cred_1295 \$I17.P19.GatPoly vss.$1300.Metal5 1.45301e-05f
Cred_1296 \$I17.P2.GatPoly \$I33.$82.Metal2 1.9696e-05f
Cred_1297 \$I17.P2.GatPoly \$I50 0.0194007f
Cred_1298 \$I17.P2.GatPoly vss 0.000254218f
Cred_1299 \$I17.P2.GatPoly vdd.$2365.Metal1 2.68906e-05f
Cred_1300 \$I17.P2.GatPoly vdd.$2370.Metal1 0.00210684f
Cred_1301 \$I17.P2.GatPoly vdd.$2399.Metal1 1.30109e-06f
Cred_1302 \$I17.P2.GatPoly vdd.$2747.Metal2 2.54676e-06f
Cred_1303 \$I17.P2.GatPoly vdd.$2749.Metal2 1.94966e-06f
Cred_1304 \$I17.P2.GatPoly vdd.$2751.Metal2 0.00335058f
Cred_1305 \$I17.P2.GatPoly vdd.$2755.Metal2 0.0192393f
Cred_1306 \$I17.P2.GatPoly vdd.$2759.Metal2 1.57838e-06f
Cred_1307 \$I17.P2.GatPoly vdd.$2761.Metal2 6.53124e-07f
Cred_1308 \$I17.P2.GatPoly vdd.$2987.Metal3 0.0103528f
Cred_1309 \$I17.P2.GatPoly vdd.P0.nSD 0.000613107f
Cred_1310 \$I17.P2.GatPoly vdd.P0.pSD 2.22374e-06f
Cred_1311 \$I17.P2.GatPoly vdd.P1.GatPoly 6.50031e-06f
Cred_1312 \$I17.P2.GatPoly vdd.P1.pSD 4.90263e-06f
Cred_1313 \$I17.P2.GatPoly vdd.P2.GatPoly 5.78704e-08f
Cred_1314 \$I17.P2.GatPoly vdd.P3.pSD 0.0279543f
Cred_1315 \$I17.P2.GatPoly vdd.P5.pSD 3.35473e-06f
Cred_1316 \$I17.P2.GatPoly vout.$1032.Metal3 7.59366e-06f
Cred_1317 \$I17.P2.GatPoly vout.$1034.Metal3 3.84627e-06f
Cred_1318 \$I17.P2.GatPoly vout.$1112.Metal3 5.95995e-09f
Cred_1319 \$I17.P2.GatPoly vout.$1152.Metal3 2.73327e-07f
Cred_1320 \$I17.P2.GatPoly vout.$1328.Metal4 3.53388e-06f
Cred_1321 \$I17.P2.GatPoly vout.$1329.Metal4 1.77486e-06f
Cred_1322 \$I17.P2.GatPoly vout.$1368.Metal4 0.0235503f
Cred_1323 \$I17.P2.GatPoly vout.$1369.Metal4 1.06889e-06f
Cred_1324 \$I17.P2.GatPoly vout.$1408.Metal4 0.00169906f
Cred_1325 \$I17.P2.GatPoly vout.$156.Metal1 0.00143946f
Cred_1326 \$I17.P2.GatPoly vout.$157.Metal1 6.85237e-06f
Cred_1327 \$I17.P2.GatPoly vout.$206.Metal1 0.00549713f
Cred_1328 \$I17.P2.GatPoly vout.$207.Metal1 2.5289e-06f
Cred_1329 \$I17.P2.GatPoly vout.$226.Metal1 0.00598064f
Cred_1330 \$I17.P2.GatPoly vout.$266.Metal1 0.00594737f
Cred_1331 \$I17.P2.GatPoly vout.$286.Metal1 0.00594809f
Cred_1332 \$I17.P2.GatPoly vout.$326.Metal1 0.00598025f
Cred_1333 \$I17.P2.GatPoly vout.$346.Metal1 0.00789348f
Cred_1334 \$I17.P2.GatPoly vout.$396.Metal1 0.00868084f
Cred_1335 \$I17.P2.GatPoly vout.$584.Metal2 2.28639e-05f
Cred_1336 \$I17.P2.GatPoly vout.$586.Metal2 1.47188e-06f
Cred_1337 \$I17.P2.GatPoly vout.$604.Metal2 3.2726e-05f
Cred_1338 \$I17.P2.GatPoly vout.$606.Metal2 1.32315e-07f
Cred_1339 \$I17.P2.GatPoly vout.$644.Metal2 1.81802e-05f
Cred_1340 \$I17.P2.GatPoly vout.$664.Metal2 3.58831e-05f
Cred_1341 \$I17.P2.GatPoly vout.$684.Metal2 1.03999e-05f
Cred_1342 \$I17.P2.GatPoly vout.$704.Metal2 3.54639e-05f
Cred_1343 \$I17.P2.GatPoly vout.$724.Metal2 1.92924e-05f
Cred_1344 \$I17.P2.GatPoly vout.$764.Metal2 8.43544e-05f
Cred_1345 \$I17.P2.GatPoly vout.$784.Metal2 8.69621e-05f
Cred_1346 \$I17.P2.GatPoly vout.P0.pSD 0.000199713f
Cred_1347 \$I17.P2.GatPoly vout.P2.pSD 2.98076e-06f
Cred_1348 \$I17.P2.GatPoly vss.$1282.Metal5 0.00245217f
Cred_1349 \$I17.P20.GatPoly \$I50 0.0195606f
Cred_1350 \$I17.P20.GatPoly vss 0.00028656f
Cred_1351 \$I17.P20.GatPoly vdd.$2365.Metal1 6.45921e-06f
Cred_1352 \$I17.P20.GatPoly vdd.$2394.Metal1 0.00100462f
Cred_1353 \$I17.P20.GatPoly vdd.$2397.Metal1 0.000497888f
Cred_1354 \$I17.P20.GatPoly vdd.$2399.Metal1 0.000688729f
Cred_1355 \$I17.P20.GatPoly vdd.$2793.Metal2 5.7932e-07f
Cred_1356 \$I17.P20.GatPoly vdd.$2795.Metal2 1.40002e-06f
Cred_1357 \$I17.P20.GatPoly vdd.$2799.Metal2 9.38703e-06f
Cred_1358 \$I17.P20.GatPoly vdd.$2803.Metal2 0.00869243f
Cred_1359 \$I17.P20.GatPoly vdd.$2805.Metal2 0.0134448f
Cred_1360 \$I17.P20.GatPoly vdd.$2807.Metal2 3.39656e-06f
Cred_1361 \$I17.P20.GatPoly vdd.$3035.Metal3 0.00129266f
Cred_1362 \$I17.P20.GatPoly vdd.$3039.Metal3 0.00129265f
Cred_1363 \$I17.P20.GatPoly vdd.$3271.Metal4 0.00260517f
Cred_1364 \$I17.P20.GatPoly vdd.P0.nSD 0.00723653f
Cred_1365 \$I17.P20.GatPoly vdd.P1.GatPoly 2.87296e-07f
Cred_1366 \$I17.P20.GatPoly vdd.P19.pSD 2.80377e-06f
Cred_1367 \$I17.P20.GatPoly vdd.P2.GatPoly 0.0794292f
Cred_1368 \$I17.P20.GatPoly vdd.P21.pSD 1.52394e-05f
Cred_1369 \$I17.P20.GatPoly vdd.P23.pSD 0.0278672f
Cred_1370 \$I17.P20.GatPoly vdd.P25.pSD 2.96576e-06f
Cred_1371 \$I17.P20.GatPoly vout 3.20868e-05f
Cred_1372 \$I17.P20.GatPoly vout.$1008.Metal3 3.77511e-06f
Cred_1373 \$I17.P20.GatPoly vout.$1010.Metal3 8.77754e-06f
Cred_1374 \$I17.P20.GatPoly vout.$1050.Metal3 3.65666e-08f
Cred_1375 \$I17.P20.GatPoly vout.$1110.Metal3 1.03847e-07f
Cred_1376 \$I17.P20.GatPoly vout.$1190.Metal3 2.428e-07f
Cred_1377 \$I17.P20.GatPoly vout.$1299.Metal4 3.86378e-10f
Cred_1378 \$I17.P20.GatPoly vout.$1313.Metal4 7.58971e-05f
Cred_1379 \$I17.P20.GatPoly vout.$1373.Metal4 3.07522e-05f
Cred_1380 \$I17.P20.GatPoly vout.$1416.Metal4 1.46197e-08f
Cred_1381 \$I17.P20.GatPoly vout.$164.Metal1 7.69245e-06f
Cred_1382 \$I17.P20.GatPoly vout.$165.Metal1 0.00145194f
Cred_1383 \$I17.P20.GatPoly vout.$214.Metal1 1.56149e-06f
Cred_1384 \$I17.P20.GatPoly vout.$215.Metal1 0.00537399f
Cred_1385 \$I17.P20.GatPoly vout.$235.Metal1 0.00598064f
Cred_1386 \$I17.P20.GatPoly vout.$275.Metal1 0.00596355f
Cred_1387 \$I17.P20.GatPoly vout.$295.Metal1 0.0212888f
Cred_1388 \$I17.P20.GatPoly vout.$335.Metal1 0.00598025f
Cred_1389 \$I17.P20.GatPoly vout.$355.Metal1 0.00789344f
Cred_1390 \$I17.P20.GatPoly vout.$405.Metal1 0.00868084f
Cred_1391 \$I17.P20.GatPoly vout.$600.Metal2 1.11964e-06f
Cred_1392 \$I17.P20.GatPoly vout.$602.Metal2 1.82557e-05f
Cred_1393 \$I17.P20.GatPoly vout.$620.Metal2 3.40953e-08f
Cred_1394 \$I17.P20.GatPoly vout.$622.Metal2 2.98857e-05f
Cred_1395 \$I17.P20.GatPoly vout.$662.Metal2 1.81802e-05f
Cred_1396 \$I17.P20.GatPoly vout.$682.Metal2 4.10639e-05f
Cred_1397 \$I17.P20.GatPoly vout.$722.Metal2 4.06447e-05f
Cred_1398 \$I17.P20.GatPoly vout.$742.Metal2 1.72395e-05f
Cred_1399 \$I17.P20.GatPoly vout.$762.Metal2 4.18787e-06f
Cred_1400 \$I17.P20.GatPoly vout.$782.Metal2 8.22972e-05f
Cred_1401 \$I17.P20.GatPoly vout.$802.Metal2 8.69543e-05f
Cred_1402 \$I17.P20.GatPoly vout.P0.GatPoly 5.03333e-09f
Cred_1403 \$I17.P20.GatPoly vout.P16.pSD 2.09631e-06f
Cred_1404 \$I17.P20.GatPoly vout.P18.pSD 0.000195615f
Cred_1405 \$I17.P20.GatPoly vref 4.36264e-06f
Cred_1406 \$I17.P20.GatPoly vref.P0.GatPoly 1.08786e-07f
Cred_1407 \$I17.P20.GatPoly vref.P0.nSD 6.5793e-08f
Cred_1408 \$I17.P20.GatPoly vref.P0.pSD 1.15318e-07f
Cred_1409 \$I17.P20.GatPoly vss 0.000484888f
Cred_1410 \$I17.P20.GatPoly vss.$1212.Metal5 0.000500069f
Cred_1411 \$I17.P20.GatPoly vss.$1230.Metal5 0.000500069f
Cred_1412 \$I17.P20.GatPoly vss.$1282.Metal5 0.00191416f
Cred_1413 \$I17.P20.GatPoly vss.$1300.Metal5 0.00191416f
Cred_1414 \$I17.P21.GatPoly \$I26 2.08086e-09f
Cred_1415 \$I17.P21.GatPoly \$I26.$2169.TopMetal1 3.21859e-06f
Cred_1416 \$I17.P21.GatPoly \$I26.P1.GatPoly 1.0403e-09f
Cred_1417 \$I17.P21.GatPoly \$I26.P2.GatPoly 8.92414e-10f
Cred_1418 \$I17.P21.GatPoly \$I33.$82.Metal2 0.000102204f
Cred_1419 \$I17.P21.GatPoly \$I50 9.20409e-06f
Cred_1420 \$I17.P21.GatPoly vss 0.0245497f
Cred_1421 \$I17.P21.GatPoly vdd.$2365.Metal1 3.40978e-07f
Cred_1422 \$I17.P21.GatPoly vdd.$2399.Metal1 2.74143e-09f
Cred_1423 \$I17.P21.GatPoly vdd.P0.nSD 3.42144e-06f
Cred_1424 \$I17.P21.GatPoly vdd.P1.GatPoly 7.69747e-08f
Cred_1425 \$I17.P21.GatPoly vdd.P2.GatPoly 1.21935e-10f
Cred_1426 \$I17.P21.GatPoly vout.$11.Metal1 0.00900332f
Cred_1427 \$I17.P21.GatPoly vout.$121.Metal1 0.00478957f
Cred_1428 \$I17.P21.GatPoly vout.$1235.Metal4 1.54176e-06f
Cred_1429 \$I17.P21.GatPoly vout.$1264.Metal4 5.72223e-06f
Cred_1430 \$I17.P21.GatPoly vout.$436.Metal2 8.88202e-05f
Cred_1431 \$I17.P21.GatPoly vout.$456.Metal2 8.86066e-05f
Cred_1432 \$I17.P21.GatPoly vout.$496.Metal2 8.50434e-05f
Cred_1433 \$I17.P21.GatPoly vout.$516.Metal2 6.98845e-05f
Cred_1434 \$I17.P21.GatPoly vout.$61.Metal1 0.0203353f
Cred_1435 \$I17.P21.GatPoly vout.$864.Metal3 3.46142e-07f
Cred_1436 \$I17.P21.GatPoly vout.$904.Metal3 1.75818e-05f
Cred_1437 \$I17.P21.GatPoly vout.P0.nSD 0.000239486f
Cred_1438 \$I17.P21.GatPoly vss.$10.Metal1 0.00153953f
Cred_1439 \$I17.P21.GatPoly vss.$1009.Metal4 0.0017689f
Cred_1440 \$I17.P21.GatPoly vss.$1212.Metal5 8.44241e-05f
Cred_1441 \$I17.P21.GatPoly vss.$127.Metal1 0.00205629f
Cred_1442 \$I17.P21.GatPoly vss.$1282.Metal5 0.00379105f
Cred_1443 \$I17.P21.GatPoly vss.$406.Metal1 0.000128252f
Cred_1444 \$I17.P21.GatPoly vss.$457.Metal2 3.00318e-05f
Cred_1445 \$I17.P21.GatPoly vss.$461.Metal2 9.62245e-06f
Cred_1446 \$I17.P21.GatPoly vss.$463.Metal2 0.0127421f
Cred_1447 \$I17.P21.GatPoly vss.$467.Metal2 0.00318918f
Cred_1448 \$I17.P21.GatPoly vss.$469.Metal2 2.28959e-06f
Cred_1449 \$I17.P21.GatPoly vss.$799.Metal3 0.00198412f
Cred_1450 \$I17.P21.GatPoly vss.$801.Metal3 4.69678e-07f
Cred_1451 \$I17.P21.GatPoly vss.P0.GatPoly 0.0440941f
Cred_1452 \$I17.P21.GatPoly vss.P0.nSD 2.7382e-06f
Cred_1453 \$I17.P21.GatPoly vss.P0.pSD 0.00916769f
Cred_1454 \$I17.P21.GatPoly vss.P1.nSD 0.0119731f
Cred_1455 \$I17.P21.GatPoly vss.P3.nSD 2.10707e-06f
Cred_1456 \$I17.P22.GatPoly \$I26 1.04023e-09f
Cred_1457 \$I17.P22.GatPoly \$I26.$2169.TopMetal1 1.60899e-06f
Cred_1458 \$I17.P22.GatPoly \$I26.P1.GatPoly 5.20053e-10f
Cred_1459 \$I17.P22.GatPoly \$I26.P2.GatPoly 4.46123e-10f
Cred_1460 \$I17.P22.GatPoly \$I33.$82.Metal2 6.64591e-05f
Cred_1461 \$I17.P22.GatPoly \$I50 4.60117e-06f
Cred_1462 \$I17.P22.GatPoly vss 0.0240567f
Cred_1463 \$I17.P22.GatPoly vdd.$2365.Metal1 1.70457e-07f
Cred_1464 \$I17.P22.GatPoly vdd.$2399.Metal1 1.37046e-09f
Cred_1465 \$I17.P22.GatPoly vdd.P0.nSD 1.7104e-06f
Cred_1466 \$I17.P22.GatPoly vdd.P1.GatPoly 3.84801e-08f
Cred_1467 \$I17.P22.GatPoly vdd.P2.GatPoly 6.09558e-11f
Cred_1468 \$I17.P22.GatPoly vout.$11.Metal1 0.00900332f
Cred_1469 \$I17.P22.GatPoly vout.$121.Metal1 0.00482151f
Cred_1470 \$I17.P22.GatPoly vout.$1235.Metal4 3.42971e-05f
Cred_1471 \$I17.P22.GatPoly vout.$1264.Metal4 0.00168538f
Cred_1472 \$I17.P22.GatPoly vout.$436.Metal2 8.88625e-05f
Cred_1473 \$I17.P22.GatPoly vout.$456.Metal2 8.86066e-05f
Cred_1474 \$I17.P22.GatPoly vout.$496.Metal2 8.50434e-05f
Cred_1475 \$I17.P22.GatPoly vout.$516.Metal2 7.0711e-05f
Cred_1476 \$I17.P22.GatPoly vout.$61.Metal1 0.0237366f
Cred_1477 \$I17.P22.GatPoly vout.$864.Metal3 1.30312e-06f
Cred_1478 \$I17.P22.GatPoly vout.$904.Metal3 1.08511e-05f
Cred_1479 \$I17.P22.GatPoly vout.P0.nSD 0.000237892f
Cred_1480 \$I17.P22.GatPoly vss.$10.Metal1 0.00147545f
Cred_1481 \$I17.P22.GatPoly vss.$1212.Metal5 4.22041e-05f
Cred_1482 \$I17.P22.GatPoly vss.$127.Metal1 5.78537e-05f
Cred_1483 \$I17.P22.GatPoly vss.$1282.Metal5 0.000555115f
Cred_1484 \$I17.P22.GatPoly vss.$13.Metal1 0.000731264f
Cred_1485 \$I17.P22.GatPoly vss.$406.Metal1 2.28718e-05f
Cred_1486 \$I17.P22.GatPoly vss.$457.Metal2 8.44945e-07f
Cred_1487 \$I17.P22.GatPoly vss.$461.Metal2 4.81031e-06f
Cred_1488 \$I17.P22.GatPoly vss.$463.Metal2 1.06191e-06f
Cred_1489 \$I17.P22.GatPoly vss.$467.Metal2 0.00611439f
Cred_1490 \$I17.P22.GatPoly vss.$469.Metal2 0.0134104f
Cred_1491 \$I17.P22.GatPoly vss.$799.Metal3 4.21739e-07f
Cred_1492 \$I17.P22.GatPoly vss.$801.Metal3 0.00194615f
Cred_1493 \$I17.P22.GatPoly vss.P0.GatPoly 7.24257e-06f
Cred_1494 \$I17.P22.GatPoly vss.P0.nSD 1.36884e-06f
Cred_1495 \$I17.P22.GatPoly vss.P0.pSD 0.00069002f
Cred_1496 \$I17.P22.GatPoly vss.P1.nSD 1.56001e-06f
Cred_1497 \$I17.P22.GatPoly vss.P3.nSD 0.0142236f
Cred_1498 \$I17.P23.GatPoly \$I33.$82.Metal2 3.03307e-05f
Cred_1499 \$I17.P23.GatPoly vss 0.0235236f
Cred_1500 \$I17.P23.GatPoly vout.$12.Metal1 0.00900332f
Cred_1501 \$I17.P23.GatPoly vout.$122.Metal1 0.00481181f
Cred_1502 \$I17.P23.GatPoly vout.$1235.Metal4 0.00358198f
Cred_1503 \$I17.P23.GatPoly vout.$438.Metal2 8.88278e-05f
Cred_1504 \$I17.P23.GatPoly vout.$458.Metal2 8.86121e-05f
Cred_1505 \$I17.P23.GatPoly vout.$498.Metal2 8.50441e-05f
Cred_1506 \$I17.P23.GatPoly vout.$518.Metal2 6.68351e-05f
Cred_1507 \$I17.P23.GatPoly vout.$62.Metal1 0.0221411f
Cred_1508 \$I17.P23.GatPoly vout.$886.Metal3 3.04584e-07f
Cred_1509 \$I17.P23.GatPoly vout.P2.nSD 0.00023539f
Cred_1510 \$I17.P23.GatPoly vss.$1013.Metal4 8.28467e-06f
Cred_1511 \$I17.P23.GatPoly vss.$127.Metal1 3.62441e-05f
Cred_1512 \$I17.P23.GatPoly vss.$1282.Metal5 0.000127628f
Cred_1513 \$I17.P23.GatPoly vss.$406.Metal1 2.47986e-05f
Cred_1514 \$I17.P23.GatPoly vss.$457.Metal2 5.2934e-07f
Cred_1515 \$I17.P23.GatPoly vss.$467.Metal2 0.00352316f
Cred_1516 \$I17.P23.GatPoly vss.$469.Metal2 0.0166304f
Cred_1517 \$I17.P23.GatPoly vss.$801.Metal3 0.000702635f
Cred_1518 \$I17.P23.GatPoly vss.$805.Metal3 0.000702635f
Cred_1519 \$I17.P23.GatPoly vss.P0.GatPoly 1.29576e-06f
Cred_1520 \$I17.P23.GatPoly vss.P0.pSD 0.000617206f
Cred_1521 \$I17.P23.GatPoly vss.P3.nSD 0.0154689f
Cred_1522 \$I17.P24.GatPoly \$I33.$82.Metal2 3.09426e-05f
Cred_1523 \$I17.P24.GatPoly vss 0.0235682f
Cred_1524 \$I17.P24.GatPoly vout.$12.Metal1 0.00900332f
Cred_1525 \$I17.P24.GatPoly vout.$122.Metal1 0.00481874f
Cred_1526 \$I17.P24.GatPoly vout.$123.Metal1 6.39042e-07f
Cred_1527 \$I17.P24.GatPoly vout.$1235.Metal4 0.00358436f
Cred_1528 \$I17.P24.GatPoly vout.$1236.Metal4 1.30417e-06f
Cred_1529 \$I17.P24.GatPoly vout.$438.Metal2 8.88278e-05f
Cred_1530 \$I17.P24.GatPoly vout.$458.Metal2 8.86121e-05f
Cred_1531 \$I17.P24.GatPoly vout.$498.Metal2 8.50932e-05f
Cred_1532 \$I17.P24.GatPoly vout.$500.Metal2 2.41248e-08f
Cred_1533 \$I17.P24.GatPoly vout.$518.Metal2 6.94333e-05f
Cred_1534 \$I17.P24.GatPoly vout.$520.Metal2 4.07725e-07f
Cred_1535 \$I17.P24.GatPoly vout.$62.Metal1 0.0219819f
Cred_1536 \$I17.P24.GatPoly vout.$886.Metal3 2.75188e-06f
Cred_1537 \$I17.P24.GatPoly vout.$888.Metal3 1.20356e-06f
Cred_1538 \$I17.P24.GatPoly vout.P2.nSD 0.000235996f
Cred_1539 \$I17.P24.GatPoly vout.P4.nSD 4.92779e-07f
Cred_1540 \$I17.P24.GatPoly vss.$1017.Metal4 1.1339e-05f
Cred_1541 \$I17.P24.GatPoly vss.$127.Metal1 3.24e-05f
Cred_1542 \$I17.P24.GatPoly vss.$1282.Metal5 0.000133256f
Cred_1543 \$I17.P24.GatPoly vss.$13.Metal1 0.00123095f
Cred_1544 \$I17.P24.GatPoly vss.$136.Metal1 0.000610026f
Cred_1545 \$I17.P24.GatPoly vss.$406.Metal1 2.93103e-05f
Cred_1546 \$I17.P24.GatPoly vss.$457.Metal2 4.73197e-07f
Cred_1547 \$I17.P24.GatPoly vss.$473.Metal2 0.0146863f
Cred_1548 \$I17.P24.GatPoly vss.$475.Metal2 0.0049064f
Cred_1549 \$I17.P24.GatPoly vss.$805.Metal3 0.00096168f
Cred_1550 \$I17.P24.GatPoly vss.$809.Metal3 0.000961858f
Cred_1551 \$I17.P24.GatPoly vss.P0.GatPoly 1.15833e-06f
Cred_1552 \$I17.P24.GatPoly vss.P0.pSD 0.000640611f
Cred_1553 \$I17.P24.GatPoly vss.P5.nSD 0.0143152f
Cred_1554 \$I17.P25.GatPoly \$I33.$82.Metal2 3.11573e-05f
Cred_1555 \$I17.P25.GatPoly vss 0.0235725f
Cred_1556 \$I17.P25.GatPoly vout.$122.Metal1 7.14139e-07f
Cred_1557 \$I17.P25.GatPoly vout.$123.Metal1 0.00472769f
Cred_1558 \$I17.P25.GatPoly vout.$1235.Metal4 1.18508e-06f
Cred_1559 \$I17.P25.GatPoly vout.$1236.Metal4 0.00358459f
Cred_1560 \$I17.P25.GatPoly vout.$13.Metal1 0.00900332f
Cred_1561 \$I17.P25.GatPoly vout.$440.Metal2 8.88278e-05f
Cred_1562 \$I17.P25.GatPoly vout.$460.Metal2 8.86121e-05f
Cred_1563 \$I17.P25.GatPoly vout.$498.Metal2 2.42177e-08f
Cred_1564 \$I17.P25.GatPoly vout.$500.Metal2 8.50924e-05f
Cred_1565 \$I17.P25.GatPoly vout.$518.Metal2 3.59581e-07f
Cred_1566 \$I17.P25.GatPoly vout.$520.Metal2 6.76507e-05f
Cred_1567 \$I17.P25.GatPoly vout.$63.Metal1 0.0219819f
Cred_1568 \$I17.P25.GatPoly vout.$886.Metal3 1.2082e-06f
Cred_1569 \$I17.P25.GatPoly vout.$888.Metal3 2.71217e-06f
Cred_1570 \$I17.P25.GatPoly vout.P2.nSD 3.02916e-07f
Cred_1571 \$I17.P25.GatPoly vout.P4.nSD 0.000236376f
Cred_1572 \$I17.P25.GatPoly vss.$1017.Metal4 1.04092e-09f
Cred_1573 \$I17.P25.GatPoly vss.$127.Metal1 2.85143e-05f
Cred_1574 \$I17.P25.GatPoly vss.$1282.Metal5 0.000135944f
Cred_1575 \$I17.P25.GatPoly vss.$13.Metal1 0.000712751f
Cred_1576 \$I17.P25.GatPoly vss.$136.Metal1 0.00143804f
Cred_1577 \$I17.P25.GatPoly vss.$406.Metal1 3.24001e-05f
Cred_1578 \$I17.P25.GatPoly vss.$457.Metal2 4.16448e-07f
Cred_1579 \$I17.P25.GatPoly vss.$473.Metal2 0.011806f
Cred_1580 \$I17.P25.GatPoly vss.$475.Metal2 0.00783093f
Cred_1581 \$I17.P25.GatPoly vss.$805.Metal3 8.82817e-08f
Cred_1582 \$I17.P25.GatPoly vss.$809.Metal3 0.00194613f
Cred_1583 \$I17.P25.GatPoly vss.P0.GatPoly 1.01942e-06f
Cred_1584 \$I17.P25.GatPoly vss.P0.pSD 0.000632726f
Cred_1585 \$I17.P25.GatPoly vss.P5.nSD 0.0142594f
Cred_1586 \$I17.P26.GatPoly \$I33.$82.Metal2 3.03307e-05f
Cred_1587 \$I17.P26.GatPoly vss 0.0235236f
Cred_1588 \$I17.P26.GatPoly vout.$123.Metal1 0.00473738f
Cred_1589 \$I17.P26.GatPoly vout.$1236.Metal4 0.00358199f
Cred_1590 \$I17.P26.GatPoly vout.$13.Metal1 0.00900332f
Cred_1591 \$I17.P26.GatPoly vout.$440.Metal2 8.88278e-05f
Cred_1592 \$I17.P26.GatPoly vout.$460.Metal2 8.86121e-05f
Cred_1593 \$I17.P26.GatPoly vout.$500.Metal2 8.50445e-05f
Cred_1594 \$I17.P26.GatPoly vout.$520.Metal2 6.81315e-05f
Cred_1595 \$I17.P26.GatPoly vout.$63.Metal1 0.0219819f
Cred_1596 \$I17.P26.GatPoly vout.$888.Metal3 3.25585e-07f
Cred_1597 \$I17.P26.GatPoly vout.P4.nSD 0.00023539f
Cred_1598 \$I17.P26.GatPoly vss.$127.Metal1 2.03909e-05f
Cred_1599 \$I17.P26.GatPoly vss.$1282.Metal5 6.27741e-05f
Cred_1600 \$I17.P26.GatPoly vss.$136.Metal1 0.00229766f
Cred_1601 \$I17.P26.GatPoly vss.$406.Metal1 3.15057e-05f
Cred_1602 \$I17.P26.GatPoly vss.$457.Metal2 2.97807e-07f
Cred_1603 \$I17.P26.GatPoly vss.$475.Metal2 0.00321519f
Cred_1604 \$I17.P26.GatPoly vss.$479.Metal2 0.0161591f
Cred_1605 \$I17.P26.GatPoly vss.$811.Metal3 0.00198359f
Cred_1606 \$I17.P26.GatPoly vss.P0.GatPoly 7.28996e-07f
Cred_1607 \$I17.P26.GatPoly vss.P0.pSD 0.000520629f
Cred_1608 \$I17.P26.GatPoly vss.P7.nSD 0.0141828f
Cred_1609 \$I17.P27.GatPoly \$I33.$82.Metal2 3.54474e-06f
Cred_1610 \$I17.P27.GatPoly \$I33.P0.GatPoly 1.61794e-07f
Cred_1611 \$I17.P27.GatPoly \$I33.P3.GatPoly 1.63342e-08f
Cred_1612 \$I17.P27.GatPoly \$I33.P4.GatPoly 1.61103e-08f
Cred_1613 \$I17.P27.GatPoly vss 0.0235759f
Cred_1614 \$I17.P27.GatPoly vout.$1237.Metal4 0.00358696f
Cred_1615 \$I17.P27.GatPoly vout.$1238.Metal4 9.45588e-07f
Cred_1616 \$I17.P27.GatPoly vout.$124.Metal1 0.00481448f
Cred_1617 \$I17.P27.GatPoly vout.$125.Metal1 5.3205e-07f
Cred_1618 \$I17.P27.GatPoly vout.$1299.Metal4 1.37608e-06f
Cred_1619 \$I17.P27.GatPoly vout.$14.Metal1 0.00900332f
Cred_1620 \$I17.P27.GatPoly vout.$442.Metal2 8.88278e-05f
Cred_1621 \$I17.P27.GatPoly vout.$462.Metal2 8.86121e-05f
Cred_1622 \$I17.P27.GatPoly vout.$502.Metal2 8.51433e-05f
Cred_1623 \$I17.P27.GatPoly vout.$504.Metal2 2.03988e-08f
Cred_1624 \$I17.P27.GatPoly vout.$522.Metal2 6.82222e-05f
Cred_1625 \$I17.P27.GatPoly vout.$524.Metal2 2.79676e-07f
Cred_1626 \$I17.P27.GatPoly vout.$64.Metal1 0.0219819f
Cred_1627 \$I17.P27.GatPoly vout.$890.Metal3 5.25412e-06f
Cred_1628 \$I17.P27.GatPoly vout.$892.Metal3 1.01768e-06f
Cred_1629 \$I17.P27.GatPoly vout.P6.nSD 0.000236953f
Cred_1630 \$I17.P27.GatPoly vout.P8.nSD 3.69421e-07f
Cred_1631 \$I17.P27.GatPoly vref 4.62162e-07f
Cred_1632 \$I17.P27.GatPoly vref.P0.GatPoly 1.80217e-08f
Cred_1633 \$I17.P27.GatPoly vref.P0.nSD 1.25736e-07f
Cred_1634 \$I17.P27.GatPoly vref.P0.pSD 1.8108e-07f
Cred_1635 \$I17.P27.GatPoly vss.$1023.Metal4 9.15888e-06f
Cred_1636 \$I17.P27.GatPoly vss.$1027.Metal4 1.51295e-09f
Cred_1637 \$I17.P27.GatPoly vss.$127.Metal1 2.20887e-05f
Cred_1638 \$I17.P27.GatPoly vss.$1282.Metal5 0.000147864f
Cred_1639 \$I17.P27.GatPoly vss.$1300.Metal5 8.01666e-07f
Cred_1640 \$I17.P27.GatPoly vss.$136.Metal1 0.000538312f
Cred_1641 \$I17.P27.GatPoly vss.$138.Metal1 0.00051626f
Cred_1642 \$I17.P27.GatPoly vss.$406.Metal1 4.25604e-05f
Cred_1643 \$I17.P27.GatPoly vss.$457.Metal2 3.22602e-07f
Cred_1644 \$I17.P27.GatPoly vss.$475.Metal2 0.00187498f
Cred_1645 \$I17.P27.GatPoly vss.$479.Metal2 0.0176736f
Cred_1646 \$I17.P27.GatPoly vss.$483.Metal2 1.56461e-06f
Cred_1647 \$I17.P27.GatPoly vss.$485.Metal2 5.73136e-07f
Cred_1648 \$I17.P27.GatPoly vss.$811.Metal3 0.000798886f
Cred_1649 \$I17.P27.GatPoly vss.$815.Metal3 0.000776907f
Cred_1650 \$I17.P27.GatPoly vss.$819.Metal3 2.5812e-07f
Cred_1651 \$I17.P27.GatPoly vss.P0.GatPoly 7.89691e-07f
Cred_1652 \$I17.P27.GatPoly vss.P0.pSD 0.000627879f
Cred_1653 \$I17.P27.GatPoly vss.P10.nSD 1.61018e-06f
Cred_1654 \$I17.P27.GatPoly vss.P7.nSD 0.0148175f
Cred_1655 \$I17.P28.GatPoly \$I33.$82.Metal2 6.92805e-05f
Cred_1656 \$I17.P28.GatPoly \$I33.P0.GatPoly 5.44456e-06f
Cred_1657 \$I17.P28.GatPoly \$I33.P3.GatPoly 4.96883e-07f
Cred_1658 \$I17.P28.GatPoly \$I33.P4.GatPoly 4.96734e-07f
Cred_1659 \$I17.P28.GatPoly vss 0.0235459f
Cred_1660 \$I17.P28.GatPoly vout.$1237.Metal4 0.00358817f
Cred_1661 \$I17.P28.GatPoly vout.$1238.Metal4 1.89153e-06f
Cred_1662 \$I17.P28.GatPoly vout.$124.Metal1 0.00482052f
Cred_1663 \$I17.P28.GatPoly vout.$125.Metal1 1.0643e-06f
Cred_1664 \$I17.P28.GatPoly vout.$1299.Metal4 9.17097e-07f
Cred_1665 \$I17.P28.GatPoly vout.$14.Metal1 0.00900332f
Cred_1666 \$I17.P28.GatPoly vout.$442.Metal2 8.88278e-05f
Cred_1667 \$I17.P28.GatPoly vout.$462.Metal2 8.86121e-05f
Cred_1668 \$I17.P28.GatPoly vout.$502.Metal2 8.51593e-05f
Cred_1669 \$I17.P28.GatPoly vout.$504.Metal2 4.08052e-08f
Cred_1670 \$I17.P28.GatPoly vout.$522.Metal2 7.03577e-05f
Cred_1671 \$I17.P28.GatPoly vout.$524.Metal2 5.59458e-07f
Cred_1672 \$I17.P28.GatPoly vout.$64.Metal1 0.0219819f
Cred_1673 \$I17.P28.GatPoly vout.$890.Metal3 6.05053e-06f
Cred_1674 \$I17.P28.GatPoly vout.$892.Metal3 2.03574e-06f
Cred_1675 \$I17.P28.GatPoly vout.P6.nSD 0.000237038f
Cred_1676 \$I17.P28.GatPoly vout.P8.nSD 7.38982e-07f
Cred_1677 \$I17.P28.GatPoly vref 3.08011e-07f
Cred_1678 \$I17.P28.GatPoly vref.P0.GatPoly 1.20107e-08f
Cred_1679 \$I17.P28.GatPoly vref.P0.nSD 8.37976e-08f
Cred_1680 \$I17.P28.GatPoly vref.P0.pSD 1.20682e-07f
Cred_1681 \$I17.P28.GatPoly vss.$1023.Metal4 1.41689e-09f
Cred_1682 \$I17.P28.GatPoly vss.$1027.Metal4 1.09039e-05f
Cred_1683 \$I17.P28.GatPoly vss.$127.Metal1 1.96449e-05f
Cred_1684 \$I17.P28.GatPoly vss.$1282.Metal5 0.000130723f
Cred_1685 \$I17.P28.GatPoly vss.$1300.Metal5 5.34275e-07f
Cred_1686 \$I17.P28.GatPoly vss.$136.Metal1 1.83532e-09f
Cred_1687 \$I17.P28.GatPoly vss.$138.Metal1 0.00117648f
Cred_1688 \$I17.P28.GatPoly vss.$141.Metal1 0.000583028f
Cred_1689 \$I17.P28.GatPoly vss.$406.Metal1 4.9679e-05f
Cred_1690 \$I17.P28.GatPoly vss.$457.Metal2 2.86911e-07f
Cred_1691 \$I17.P28.GatPoly vss.$475.Metal2 1.55656e-07f
Cred_1692 \$I17.P28.GatPoly vss.$479.Metal2 1.27701e-06f
Cred_1693 \$I17.P28.GatPoly vss.$483.Metal2 0.0150834f
Cred_1694 \$I17.P28.GatPoly vss.$485.Metal2 0.0045401f
Cred_1695 \$I17.P28.GatPoly vss.$811.Metal3 1.22004e-07f
Cred_1696 \$I17.P28.GatPoly vss.$815.Metal3 0.000924896f
Cred_1697 \$I17.P28.GatPoly vss.$819.Metal3 0.000925035f
Cred_1698 \$I17.P28.GatPoly vss.P0.GatPoly 7.02325e-07f
Cred_1699 \$I17.P28.GatPoly vss.P0.pSD 0.000640013f
Cred_1700 \$I17.P28.GatPoly vss.P10.nSD 0.0144492f
Cred_1701 \$I17.P28.GatPoly vss.P7.nSD 1.15303e-06f
Cred_1702 \$I17.P29.GatPoly \$I33.$82.Metal2 6.78704e-05f
Cred_1703 \$I17.P29.GatPoly \$I33.P0.GatPoly 5.39874e-06f
Cred_1704 \$I17.P29.GatPoly \$I33.P3.GatPoly 4.92178e-07f
Cred_1705 \$I17.P29.GatPoly \$I33.P4.GatPoly 4.92103e-07f
Cred_1706 \$I17.P29.GatPoly vss 0.023523f
Cred_1707 \$I17.P29.GatPoly vout.$1237.Metal4 3.09206e-06f
Cred_1708 \$I17.P29.GatPoly vout.$1238.Metal4 0.00358482f
Cred_1709 \$I17.P29.GatPoly vout.$124.Metal1 1.60302e-06f
Cred_1710 \$I17.P29.GatPoly vout.$125.Metal1 0.00481341f
Cred_1711 \$I17.P29.GatPoly vout.$1299.Metal4 4.58462e-07f
Cred_1712 \$I17.P29.GatPoly vout.$15.Metal1 0.00900332f
Cred_1713 \$I17.P29.GatPoly vout.$444.Metal2 8.88278e-05f
Cred_1714 \$I17.P29.GatPoly vout.$464.Metal2 8.86121e-05f
Cred_1715 \$I17.P29.GatPoly vout.$502.Metal2 5.72713e-08f
Cred_1716 \$I17.P29.GatPoly vout.$504.Metal2 8.51053e-05f
Cred_1717 \$I17.P29.GatPoly vout.$522.Metal2 8.21697e-07f
Cred_1718 \$I17.P29.GatPoly vout.$524.Metal2 6.76746e-05f
Cred_1719 \$I17.P29.GatPoly vout.$65.Metal1 0.0219819f
Cred_1720 \$I17.P29.GatPoly vout.$890.Metal3 2.85721e-06f
Cred_1721 \$I17.P29.GatPoly vout.$892.Metal3 3.35915e-06f
Cred_1722 \$I17.P29.GatPoly vout.P6.nSD 8.23681e-07f
Cred_1723 \$I17.P29.GatPoly vout.P8.nSD 0.000236499f
Cred_1724 \$I17.P29.GatPoly vref 1.53976e-07f
Cred_1725 \$I17.P29.GatPoly vref.P0.GatPoly 6.00421e-09f
Cred_1726 \$I17.P29.GatPoly vref.P0.nSD 4.18909e-08f
Cred_1727 \$I17.P29.GatPoly vref.P0.pSD 6.03295e-08f
Cred_1728 \$I17.P29.GatPoly vss.$1023.Metal4 7.08311e-10f
Cred_1729 \$I17.P29.GatPoly vss.$1027.Metal4 1.51295e-09f
Cred_1730 \$I17.P29.GatPoly vss.$127.Metal1 1.71711e-05f
Cred_1731 \$I17.P29.GatPoly vss.$1282.Metal5 0.000118199f
Cred_1732 \$I17.P29.GatPoly vss.$1300.Metal5 2.67087e-07f
Cred_1733 \$I17.P29.GatPoly vss.$136.Metal1 9.17485e-10f
Cred_1734 \$I17.P29.GatPoly vss.$138.Metal1 0.000708165f
Cred_1735 \$I17.P29.GatPoly vss.$141.Metal1 0.00142875f
Cred_1736 \$I17.P29.GatPoly vss.$406.Metal1 5.44214e-05f
Cred_1737 \$I17.P29.GatPoly vss.$457.Metal2 2.50781e-07f
Cred_1738 \$I17.P29.GatPoly vss.$475.Metal2 7.78133e-08f
Cred_1739 \$I17.P29.GatPoly vss.$479.Metal2 6.38385e-07f
Cred_1740 \$I17.P29.GatPoly vss.$483.Metal2 0.0122198f
Cred_1741 \$I17.P29.GatPoly vss.$485.Metal2 0.00740574f
Cred_1742 \$I17.P29.GatPoly vss.$811.Metal3 6.09904e-08f
Cred_1743 \$I17.P29.GatPoly vss.$815.Metal3 1.88389e-07f
Cred_1744 \$I17.P29.GatPoly vss.$819.Metal3 0.0019462f
Cred_1745 \$I17.P29.GatPoly vss.P0.GatPoly 6.13882e-07f
Cred_1746 \$I17.P29.GatPoly vss.P0.pSD 0.00062395f
Cred_1747 \$I17.P29.GatPoly vss.P10.nSD 0.014265f
Cred_1748 \$I17.P29.GatPoly vss.P7.nSD 5.76406e-07f
Cred_1749 \$I17.P3.GatPoly \$I33.$82.Metal2 1.92303e-05f
Cred_1750 \$I17.P3.GatPoly \$I50 0.0194914f
Cred_1751 \$I17.P3.GatPoly vss 0.000245541f
Cred_1752 \$I17.P3.GatPoly vdd.$2365.Metal1 2.07761e-05f
Cred_1753 \$I17.P3.GatPoly vdd.$2370.Metal1 0.000526705f
Cred_1754 \$I17.P3.GatPoly vdd.$2372.Metal1 0.000499772f
Cred_1755 \$I17.P3.GatPoly vdd.$2399.Metal1 1.40096e-06f
Cred_1756 \$I17.P3.GatPoly vdd.$2747.Metal2 1.69753e-06f
Cred_1757 \$I17.P3.GatPoly vdd.$2749.Metal2 1.29953e-06f
Cred_1758 \$I17.P3.GatPoly vdd.$2751.Metal2 0.00228561f
Cred_1759 \$I17.P3.GatPoly vdd.$2755.Metal2 0.0235227f
Cred_1760 \$I17.P3.GatPoly vdd.$2759.Metal2 1.57908e-06f
Cred_1761 \$I17.P3.GatPoly vdd.$2761.Metal2 6.53413e-07f
Cred_1762 \$I17.P3.GatPoly vdd.$2987.Metal3 0.00097157f
Cred_1763 \$I17.P3.GatPoly vdd.$2991.Metal3 0.000944627f
Cred_1764 \$I17.P3.GatPoly vdd.$3223.Metal4 1.1138e-05f
Cred_1765 \$I17.P3.GatPoly vdd.P0.nSD 0.000566505f
Cred_1766 \$I17.P3.GatPoly vdd.P0.pSD 1.48222e-06f
Cred_1767 \$I17.P3.GatPoly vdd.P1.GatPoly 4.45961e-06f
Cred_1768 \$I17.P3.GatPoly vdd.P1.pSD 3.26782e-06f
Cred_1769 \$I17.P3.GatPoly vdd.P2.GatPoly 6.23126e-08f
Cred_1770 \$I17.P3.GatPoly vdd.P3.pSD 0.0336975f
Cred_1771 \$I17.P3.GatPoly vdd.P5.pSD 3.35621e-06f
Cred_1772 \$I17.P3.GatPoly vout.$1032.Metal3 5.02593e-06f
Cred_1773 \$I17.P3.GatPoly vout.$1034.Metal3 3.90064e-06f
Cred_1774 \$I17.P3.GatPoly vout.$1112.Metal3 3.97256e-09f
Cred_1775 \$I17.P3.GatPoly vout.$1152.Metal3 9.4046e-09f
Cred_1776 \$I17.P3.GatPoly vout.$1154.Metal3 2.59218e-07f
Cred_1777 \$I17.P3.GatPoly vout.$1328.Metal4 2.35415e-06f
Cred_1778 \$I17.P3.GatPoly vout.$1329.Metal4 1.77756e-06f
Cred_1779 \$I17.P3.GatPoly vout.$1368.Metal4 8.67797e-08f
Cred_1780 \$I17.P3.GatPoly vout.$1369.Metal4 0.0291228f
Cred_1781 \$I17.P3.GatPoly vout.$1408.Metal4 1.09916e-06f
Cred_1782 \$I17.P3.GatPoly vout.$156.Metal1 8.81651e-06f
Cred_1783 \$I17.P3.GatPoly vout.$157.Metal1 0.00142778f
Cred_1784 \$I17.P3.GatPoly vout.$206.Metal1 3.20549e-06f
Cred_1785 \$I17.P3.GatPoly vout.$207.Metal1 0.00549578f
Cred_1786 \$I17.P3.GatPoly vout.$227.Metal1 0.00598064f
Cred_1787 \$I17.P3.GatPoly vout.$267.Metal1 0.00594737f
Cred_1788 \$I17.P3.GatPoly vout.$287.Metal1 0.00594809f
Cred_1789 \$I17.P3.GatPoly vout.$327.Metal1 0.00598025f
Cred_1790 \$I17.P3.GatPoly vout.$347.Metal1 0.00789348f
Cred_1791 \$I17.P3.GatPoly vout.$397.Metal1 0.00868084f
Cred_1792 \$I17.P3.GatPoly vout.$584.Metal2 1.94626e-06f
Cred_1793 \$I17.P3.GatPoly vout.$586.Metal2 2.14046e-05f
Cred_1794 \$I17.P3.GatPoly vout.$604.Metal2 1.70734e-07f
Cred_1795 \$I17.P3.GatPoly vout.$606.Metal2 3.26225e-05f
Cred_1796 \$I17.P3.GatPoly vout.$646.Metal2 1.81802e-05f
Cred_1797 \$I17.P3.GatPoly vout.$666.Metal2 3.58831e-05f
Cred_1798 \$I17.P3.GatPoly vout.$686.Metal2 1.03999e-05f
Cred_1799 \$I17.P3.GatPoly vout.$706.Metal2 3.54639e-05f
Cred_1800 \$I17.P3.GatPoly vout.$724.Metal2 4.16181e-11f
Cred_1801 \$I17.P3.GatPoly vout.$726.Metal2 1.92924e-05f
Cred_1802 \$I17.P3.GatPoly vout.$766.Metal2 8.43544e-05f
Cred_1803 \$I17.P3.GatPoly vout.$786.Metal2 8.69621e-05f
Cred_1804 \$I17.P3.GatPoly vout.P0.pSD 3.68453e-06f
Cred_1805 \$I17.P3.GatPoly vout.P2.pSD 0.000197199f
Cred_1806 \$I17.P3.GatPoly vss.$1282.Metal5 0.00237804f
Cred_1807 \$I17.P30.GatPoly \$I33.$82.Metal2 0.00980646f
Cred_1808 \$I17.P30.GatPoly \$I33.P0.GatPoly 0.000789841f
Cred_1809 \$I17.P30.GatPoly \$I33.P3.GatPoly 0.0390159f
Cred_1810 \$I17.P30.GatPoly \$I33.P4.GatPoly 0.000110502f
Cred_1811 \$I17.P30.GatPoly vss 0.0233622f
Cred_1812 \$I17.P30.GatPoly vout.$1238.Metal4 0.00348538f
Cred_1813 \$I17.P30.GatPoly vout.$125.Metal1 0.00478903f
Cred_1814 \$I17.P30.GatPoly vout.$15.Metal1 0.00900332f
Cred_1815 \$I17.P30.GatPoly vout.$444.Metal2 8.88278e-05f
Cred_1816 \$I17.P30.GatPoly vout.$464.Metal2 8.86121e-05f
Cred_1817 \$I17.P30.GatPoly vout.$504.Metal2 8.50446e-05f
Cred_1818 \$I17.P30.GatPoly vout.$524.Metal2 6.85079e-05f
Cred_1819 \$I17.P30.GatPoly vout.$65.Metal1 0.0204988f
Cred_1820 \$I17.P30.GatPoly vout.$892.Metal3 3.31682e-07f
Cred_1821 \$I17.P30.GatPoly vout.P8.nSD 0.00023539f
Cred_1822 \$I17.P30.GatPoly vss.$127.Metal1 1.4925e-05f
Cred_1823 \$I17.P30.GatPoly vss.$1282.Metal5 7.21705e-05f
Cred_1824 \$I17.P30.GatPoly vss.$141.Metal1 0.00218612f
Cred_1825 \$I17.P30.GatPoly vss.$406.Metal1 6.24562e-05f
Cred_1826 \$I17.P30.GatPoly vss.$457.Metal2 2.17977e-07f
Cred_1827 \$I17.P30.GatPoly vss.$485.Metal2 0.00336919f
Cred_1828 \$I17.P30.GatPoly vss.$489.Metal2 0.0155548f
Cred_1829 \$I17.P30.GatPoly vss.$821.Metal3 0.00198541f
Cred_1830 \$I17.P30.GatPoly vss.P0.GatPoly 5.33582e-07f
Cred_1831 \$I17.P30.GatPoly vss.P0.pSD 0.000609294f
Cred_1832 \$I17.P30.GatPoly vss.P11.nSD 0.0137867f
Cred_1833 \$I17.P31.GatPoly \$I33.$82.Metal2 0.00993193f
Cred_1834 \$I17.P31.GatPoly \$I33.P0.GatPoly 0.000800063f
Cred_1835 \$I17.P31.GatPoly \$I33.P3.GatPoly 0.00011187f
Cred_1836 \$I17.P31.GatPoly \$I33.P4.GatPoly 0.0390219f
Cred_1837 \$I17.P31.GatPoly vss 0.0234802f
Cred_1838 \$I17.P31.GatPoly vout.$1239.Metal4 0.0018872f
Cred_1839 \$I17.P31.GatPoly vout.$126.Metal1 0.00479566f
Cred_1840 \$I17.P31.GatPoly vout.$1269.Metal4 0.00163731f
Cred_1841 \$I17.P31.GatPoly vout.$127.Metal1 1.06831e-06f
Cred_1842 \$I17.P31.GatPoly vout.$1299.Metal4 5.52179e-05f
Cred_1843 \$I17.P31.GatPoly vout.$16.Metal1 0.00900332f
Cred_1844 \$I17.P31.GatPoly vout.$446.Metal2 8.88278e-05f
Cred_1845 \$I17.P31.GatPoly vout.$466.Metal2 8.86121e-05f
Cred_1846 \$I17.P31.GatPoly vout.$506.Metal2 8.50434e-05f
Cred_1847 \$I17.P31.GatPoly vout.$526.Metal2 7.04879e-05f
Cred_1848 \$I17.P31.GatPoly vout.$528.Metal2 3.98601e-07f
Cred_1849 \$I17.P31.GatPoly vout.$66.Metal1 0.0205616f
Cred_1850 \$I17.P31.GatPoly vout.$894.Metal3 2.70299e-07f
Cred_1851 \$I17.P31.GatPoly vout.$934.Metal3 1.04875e-05f
Cred_1852 \$I17.P31.GatPoly vout.$936.Metal3 2.22385e-06f
Cred_1853 \$I17.P31.GatPoly vout.P10.nSD 0.000238088f
Cred_1854 \$I17.P31.GatPoly vout.P12.nSD 4.53973e-07f
Cred_1855 \$I17.P31.GatPoly vref 3.04139e-05f
Cred_1856 \$I17.P31.GatPoly vref.P0.GatPoly 1.1795e-06f
Cred_1857 \$I17.P31.GatPoly vref.P0.nSD 9.56778e-06f
Cred_1858 \$I17.P31.GatPoly vref.P0.pSD 9.50228e-06f
Cred_1859 \$I17.P31.GatPoly vss.$1037.Metal4 5.90699e-09f
Cred_1860 \$I17.P31.GatPoly vss.$1043.Metal4 1.512e-09f
Cred_1861 \$I17.P31.GatPoly vss.$127.Metal1 1.04416e-05f
Cred_1862 \$I17.P31.GatPoly vss.$1300.Metal5 9.33755e-05f
Cred_1863 \$I17.P31.GatPoly vss.$143.Metal1 0.000698991f
Cred_1864 \$I17.P31.GatPoly vss.$146.Metal1 0.00141024f
Cred_1865 \$I17.P31.GatPoly vss.$406.Metal1 9.33004e-05f
Cred_1866 \$I17.P31.GatPoly vss.$457.Metal2 1.52498e-07f
Cred_1867 \$I17.P31.GatPoly vss.$493.Metal2 0.0122763f
Cred_1868 \$I17.P31.GatPoly vss.$495.Metal2 0.00686504f
Cred_1869 \$I17.P31.GatPoly vss.$499.Metal2 4.27151e-06f
Cred_1870 \$I17.P31.GatPoly vss.$825.Metal3 5.00981e-07f
Cred_1871 \$I17.P31.GatPoly vss.$829.Metal3 0.00194694f
Cred_1872 \$I17.P31.GatPoly vss.$831.Metal3 6.55044e-07f
Cred_1873 \$I17.P31.GatPoly vss.$835.Metal3 1.28235e-07f
Cred_1874 \$I17.P31.GatPoly vss.P0.GatPoly 3.73296e-07f
Cred_1875 \$I17.P31.GatPoly vss.P0.pSD 0.000607876f
Cred_1876 \$I17.P31.GatPoly vss.P13.nSD 0.0138643f
Cred_1877 \$I17.P31.GatPoly vss.P15.nSD 3.87761e-06f
Cred_1878 \$I17.P32.GatPoly \$I33.$82.Metal2 0.000150295f
Cred_1879 \$I17.P32.GatPoly \$I33.P0.GatPoly 1.22597e-05f
Cred_1880 \$I17.P32.GatPoly \$I33.P3.GatPoly 1.40115e-06f
Cred_1881 \$I17.P32.GatPoly \$I33.P4.GatPoly 4.45747e-06f
Cred_1882 \$I17.P32.GatPoly vss 0.0235765f
Cred_1883 \$I17.P32.GatPoly vout.$1239.Metal4 0.00185097f
Cred_1884 \$I17.P32.GatPoly vout.$126.Metal1 0.00481621f
Cred_1885 \$I17.P32.GatPoly vout.$1269.Metal4 0.000241755f
Cred_1886 \$I17.P32.GatPoly vout.$127.Metal1 1.42482e-06f
Cred_1887 \$I17.P32.GatPoly vout.$1299.Metal4 0.000121815f
Cred_1888 \$I17.P32.GatPoly vout.$16.Metal1 0.00900332f
Cred_1889 \$I17.P32.GatPoly vout.$446.Metal2 8.88278e-05f
Cred_1890 \$I17.P32.GatPoly vout.$466.Metal2 8.86121e-05f
Cred_1891 \$I17.P32.GatPoly vout.$506.Metal2 8.50434e-05f
Cred_1892 \$I17.P32.GatPoly vout.$526.Metal2 6.86706e-05f
Cred_1893 \$I17.P32.GatPoly vout.$528.Metal2 5.31619e-07f
Cred_1894 \$I17.P32.GatPoly vout.$66.Metal1 0.0219594f
Cred_1895 \$I17.P32.GatPoly vout.$894.Metal3 2.70299e-07f
Cred_1896 \$I17.P32.GatPoly vout.$934.Metal3 9.60127e-06f
Cred_1897 \$I17.P32.GatPoly vout.$936.Metal3 2.96598e-06f
Cred_1898 \$I17.P32.GatPoly vout.P10.nSD 0.000237794f
Cred_1899 \$I17.P32.GatPoly vout.P12.nSD 6.05469e-07f
Cred_1900 \$I17.P32.GatPoly vref 2.17969e-05f
Cred_1901 \$I17.P32.GatPoly vref.P0.GatPoly 8.44204e-07f
Cred_1902 \$I17.P32.GatPoly vref.P0.nSD 6.41166e-06f
Cred_1903 \$I17.P32.GatPoly vref.P0.pSD 6.39446e-06f
Cred_1904 \$I17.P32.GatPoly vss.$1037.Metal4 3.93675e-09f
Cred_1905 \$I17.P32.GatPoly vss.$1043.Metal4 2.01657e-09f
Cred_1906 \$I17.P32.GatPoly vss.$127.Metal1 8.94025e-06f
Cred_1907 \$I17.P32.GatPoly vss.$1300.Metal5 1.41322e-05f
Cred_1908 \$I17.P32.GatPoly vss.$146.Metal1 0.00221806f
Cred_1909 \$I17.P32.GatPoly vss.$406.Metal1 0.000105247f
Cred_1910 \$I17.P32.GatPoly vss.$457.Metal2 1.30571e-07f
Cred_1911 \$I17.P32.GatPoly vss.$493.Metal2 3.9656e-06f
Cred_1912 \$I17.P32.GatPoly vss.$495.Metal2 0.00367083f
Cred_1913 \$I17.P32.GatPoly vss.$499.Metal2 0.0159901f
Cred_1914 \$I17.P32.GatPoly vss.$825.Metal3 3.33882e-07f
Cred_1915 \$I17.P32.GatPoly vss.$829.Metal3 8.36488e-07f
Cred_1916 \$I17.P32.GatPoly vss.$831.Metal3 0.00198981f
Cred_1917 \$I17.P32.GatPoly vss.$835.Metal3 1.71028e-07f
Cred_1918 \$I17.P32.GatPoly vss.P0.GatPoly 3.19623e-07f
Cred_1919 \$I17.P32.GatPoly vss.P0.pSD 0.000583347f
Cred_1920 \$I17.P32.GatPoly vss.P13.nSD 3.4156e-06f
Cred_1921 \$I17.P32.GatPoly vss.P15.nSD 0.0144095f
Cred_1922 \$I17.P33.GatPoly \$I33.$82.Metal2 0.000166013f
Cred_1923 \$I17.P33.GatPoly \$I33.P0.GatPoly 2.22667e-05f
Cred_1924 \$I17.P33.GatPoly \$I33.P3.GatPoly 1.36703e-06f
Cred_1925 \$I17.P33.GatPoly \$I33.P4.GatPoly 2.8949e-06f
Cred_1926 \$I17.P33.GatPoly vss 0.0234869f
Cred_1927 \$I17.P33.GatPoly vout.$1239.Metal4 1.29189e-06f
Cred_1928 \$I17.P33.GatPoly vout.$1240.Metal4 0.00184838f
Cred_1929 \$I17.P33.GatPoly vout.$126.Metal1 2.45067e-06f
Cred_1930 \$I17.P33.GatPoly vout.$1269.Metal4 0.000235061f
Cred_1931 \$I17.P33.GatPoly vout.$127.Metal1 0.0048186f
Cred_1932 \$I17.P33.GatPoly vout.$1299.Metal4 0.000101843f
Cred_1933 \$I17.P33.GatPoly vout.$17.Metal1 0.00900332f
Cred_1934 \$I17.P33.GatPoly vout.$448.Metal2 8.88278e-05f
Cred_1935 \$I17.P33.GatPoly vout.$468.Metal2 8.86121e-05f
Cred_1936 \$I17.P33.GatPoly vout.$508.Metal2 8.50434e-05f
Cred_1937 \$I17.P33.GatPoly vout.$526.Metal2 9.18936e-07f
Cred_1938 \$I17.P33.GatPoly vout.$528.Metal2 6.937e-05f
Cred_1939 \$I17.P33.GatPoly vout.$67.Metal1 0.0219594f
Cred_1940 \$I17.P33.GatPoly vout.$896.Metal3 2.70299e-07f
Cred_1941 \$I17.P33.GatPoly vout.$934.Metal3 4.77937e-06f
Cred_1942 \$I17.P33.GatPoly vout.$936.Metal3 3.78605e-06f
Cred_1943 \$I17.P33.GatPoly vout.P10.nSD 1.20171e-06f
Cred_1944 \$I17.P33.GatPoly vout.P12.nSD 0.000236147f
Cred_1945 \$I17.P33.GatPoly vref 1.16602e-05f
Cred_1946 \$I17.P33.GatPoly vref.P0.GatPoly 4.51087e-07f
Cred_1947 \$I17.P33.GatPoly vref.P0.nSD 3.2228e-06f
Cred_1948 \$I17.P33.GatPoly vref.P0.pSD 3.22744e-06f
Cred_1949 \$I17.P33.GatPoly vss.$1037.Metal4 1.968e-09f
Cred_1950 \$I17.P33.GatPoly vss.$1043.Metal4 1.09034e-05f
Cred_1951 \$I17.P33.GatPoly vss.$127.Metal1 8.13893e-06f
Cred_1952 \$I17.P33.GatPoly vss.$1300.Metal5 7.06478e-06f
Cred_1953 \$I17.P33.GatPoly vss.$146.Metal1 0.000914105f
Cred_1954 \$I17.P33.GatPoly vss.$148.Metal1 0.000887503f
Cred_1955 \$I17.P33.GatPoly vss.$406.Metal1 0.000120798f
Cred_1956 \$I17.P33.GatPoly vss.$457.Metal2 1.18868e-07f
Cred_1957 \$I17.P33.GatPoly vss.$493.Metal2 1.98243e-06f
Cred_1958 \$I17.P33.GatPoly vss.$495.Metal2 0.00226025f
Cred_1959 \$I17.P33.GatPoly vss.$499.Metal2 0.0174504f
Cred_1960 \$I17.P33.GatPoly vss.$825.Metal3 1.66909e-07f
Cred_1961 \$I17.P33.GatPoly vss.$829.Metal3 4.18165e-07f
Cred_1962 \$I17.P33.GatPoly vss.$831.Metal3 0.000951722f
Cred_1963 \$I17.P33.GatPoly vss.$835.Metal3 0.000924733f
Cred_1964 \$I17.P33.GatPoly vss.P0.GatPoly 2.90975e-07f
Cred_1965 \$I17.P33.GatPoly vss.P0.pSD 0.000589769f
Cred_1966 \$I17.P33.GatPoly vss.P13.nSD 1.70748e-06f
Cred_1967 \$I17.P33.GatPoly vss.P15.nSD 0.0145887f
Cred_1968 \$I17.P34.GatPoly \$I33.$82.Metal2 4.45511e-05f
Cred_1969 \$I17.P34.GatPoly \$I33.P0.GatPoly 6.77591e-06f
Cred_1970 \$I17.P34.GatPoly \$I33.P3.GatPoly 3.26772e-07f
Cred_1971 \$I17.P34.GatPoly \$I33.P4.GatPoly 3.26772e-07f
Cred_1972 \$I17.P34.GatPoly vss 0.0234557f
Cred_1973 \$I17.P34.GatPoly vout.$1240.Metal4 0.00184838f
Cred_1974 \$I17.P34.GatPoly vout.$1269.Metal4 0.000220427f
Cred_1975 \$I17.P34.GatPoly vout.$127.Metal1 0.00481131f
Cred_1976 \$I17.P34.GatPoly vout.$1299.Metal4 6.65242e-05f
Cred_1977 \$I17.P34.GatPoly vout.$17.Metal1 0.00900332f
Cred_1978 \$I17.P34.GatPoly vout.$448.Metal2 8.88278e-05f
Cred_1979 \$I17.P34.GatPoly vout.$468.Metal2 8.86121e-05f
Cred_1980 \$I17.P34.GatPoly vout.$508.Metal2 8.50434e-05f
Cred_1981 \$I17.P34.GatPoly vout.$528.Metal2 6.68324e-05f
Cred_1982 \$I17.P34.GatPoly vout.$67.Metal1 0.0219594f
Cred_1983 \$I17.P34.GatPoly vout.$896.Metal3 2.70299e-07f
Cred_1984 \$I17.P34.GatPoly vout.$936.Metal3 4.0734e-08f
Cred_1985 \$I17.P34.GatPoly vout.P12.nSD 0.00023539f
Cred_1986 \$I17.P34.GatPoly vss.$1047.Metal4 9.15675e-06f
Cred_1987 \$I17.P34.GatPoly vss.$127.Metal1 6.52861e-06f
Cred_1988 \$I17.P34.GatPoly vss.$148.Metal1 0.00051626f
Cred_1989 \$I17.P34.GatPoly vss.$150.Metal1 0.000538565f
Cred_1990 \$I17.P34.GatPoly vss.$406.Metal1 0.000129725f
Cred_1991 \$I17.P34.GatPoly vss.$457.Metal2 9.53495e-08f
Cred_1992 \$I17.P34.GatPoly vss.$503.Metal2 0.0178495f
Cred_1993 \$I17.P34.GatPoly vss.$507.Metal2 0.00189644f
Cred_1994 \$I17.P34.GatPoly vss.$835.Metal3 0.000776598f
Cred_1995 \$I17.P34.GatPoly vss.$839.Metal3 0.000798959f
Cred_1996 \$I17.P34.GatPoly vss.P0.GatPoly 2.33404e-07f
Cred_1997 \$I17.P34.GatPoly vss.P0.pSD 0.0005346f
Cred_1998 \$I17.P34.GatPoly vss.P17.nSD 0.0149872f
Cred_1999 \$I17.P35.GatPoly vss 0.0236243f
Cred_2000 \$I17.P35.GatPoly vout.$1241.Metal4 6.50038e-09f
Cred_2001 \$I17.P35.GatPoly vout.$1269.Metal4 0.000232339f
Cred_2002 \$I17.P35.GatPoly vout.$128.Metal1 0.00481948f
Cred_2003 \$I17.P35.GatPoly vout.$129.Metal1 5.34392e-07f
Cred_2004 \$I17.P35.GatPoly vout.$1299.Metal4 0.00011382f
Cred_2005 \$I17.P35.GatPoly vout.$18.Metal1 0.00900332f
Cred_2006 \$I17.P35.GatPoly vout.$450.Metal2 8.88066e-05f
Cred_2007 \$I17.P35.GatPoly vout.$470.Metal2 8.86066e-05f
Cred_2008 \$I17.P35.GatPoly vout.$510.Metal2 8.50434e-05f
Cred_2009 \$I17.P35.GatPoly vout.$530.Metal2 6.96951e-05f
Cred_2010 \$I17.P35.GatPoly vout.$532.Metal2 1.99389e-07f
Cred_2011 \$I17.P35.GatPoly vout.$68.Metal1 0.0238077f
Cred_2012 \$I17.P35.GatPoly vout.$858.Metal3 3.24298e-07f
Cred_2013 \$I17.P35.GatPoly vout.$938.Metal3 5.37973e-06f
Cred_2014 \$I17.P35.GatPoly vout.$940.Metal3 1.11242e-06f
Cred_2015 \$I17.P35.GatPoly vout.P14.nSD 0.000236526f
Cred_2016 \$I17.P35.GatPoly vout.P16.nSD 2.27087e-07f
Cred_2017 \$I17.P35.GatPoly vref 2.29045e-06f
Cred_2018 \$I17.P35.GatPoly vref.P0.GatPoly 8.71571e-08f
Cred_2019 \$I17.P35.GatPoly vref.P0.nSD 5.27119e-08f
Cred_2020 \$I17.P35.GatPoly vref.P0.pSD 9.23901e-08f
Cred_2021 \$I17.P35.GatPoly vss.$1053.Metal4 7.80343e-10f
Cred_2022 \$I17.P35.GatPoly vss.$127.Metal1 5.24192e-06f
Cred_2023 \$I17.P35.GatPoly vss.$150.Metal1 0.00229792f
Cred_2024 \$I17.P35.GatPoly vss.$406.Metal1 0.000129616f
Cred_2025 \$I17.P35.GatPoly vss.$457.Metal2 7.65575e-08f
Cred_2026 \$I17.P35.GatPoly vss.$503.Metal2 0.0163413f
Cred_2027 \$I17.P35.GatPoly vss.$507.Metal2 0.00323814f
Cred_2028 \$I17.P35.GatPoly vss.$509.Metal2 1.74164e-06f
Cred_2029 \$I17.P35.GatPoly vss.$839.Metal3 0.00198422f
Cred_2030 \$I17.P35.GatPoly vss.$841.Metal3 3.34082e-07f
Cred_2031 \$I17.P35.GatPoly vss.$845.Metal3 6.61821e-08f
Cred_2032 \$I17.P35.GatPoly vss.P0.GatPoly 1.87404e-07f
Cred_2033 \$I17.P35.GatPoly vss.P0.pSD 0.000467464f
Cred_2034 \$I17.P35.GatPoly vss.P17.nSD 0.0143583f
Cred_2035 \$I17.P35.GatPoly vss.P19.nSD 1.93443e-06f
Cred_2036 \$I17.P36.GatPoly vss 0.0236444f
Cred_2037 \$I17.P36.GatPoly vout.$1241.Metal4 0.00115086f
Cred_2038 \$I17.P36.GatPoly vout.$1269.Metal4 0.000236309f
Cred_2039 \$I17.P36.GatPoly vout.$128.Metal1 0.0048145f
Cred_2040 \$I17.P36.GatPoly vout.$129.Metal1 1.06899e-06f
Cred_2041 \$I17.P36.GatPoly vout.$1299.Metal4 0.000123844f
Cred_2042 \$I17.P36.GatPoly vout.$18.Metal1 0.00900332f
Cred_2043 \$I17.P36.GatPoly vout.$450.Metal2 8.88066e-05f
Cred_2044 \$I17.P36.GatPoly vout.$470.Metal2 8.86066e-05f
Cred_2045 \$I17.P36.GatPoly vout.$510.Metal2 8.50434e-05f
Cred_2046 \$I17.P36.GatPoly vout.$530.Metal2 6.80144e-05f
Cred_2047 \$I17.P36.GatPoly vout.$532.Metal2 3.98853e-07f
Cred_2048 \$I17.P36.GatPoly vout.$68.Metal1 0.0226569f
Cred_2049 \$I17.P36.GatPoly vout.$858.Metal3 3.24298e-07f
Cred_2050 \$I17.P36.GatPoly vout.$938.Metal3 6.19468e-06f
Cred_2051 \$I17.P36.GatPoly vout.$940.Metal3 2.22525e-06f
Cred_2052 \$I17.P36.GatPoly vout.P14.nSD 0.000236753f
Cred_2053 \$I17.P36.GatPoly vout.P16.nSD 4.54259e-07f
Cred_2054 \$I17.P36.GatPoly vref 3.05384e-06f
Cred_2055 \$I17.P36.GatPoly vref.P0.GatPoly 1.16206e-07f
Cred_2056 \$I17.P36.GatPoly vref.P0.nSD 7.02803e-08f
Cred_2057 \$I17.P36.GatPoly vref.P0.pSD 1.23183e-07f
Cred_2058 \$I17.P36.GatPoly vss.$1053.Metal4 1.56098e-09f
Cred_2059 \$I17.P36.GatPoly vss.$127.Metal1 5.08237e-06f
Cred_2060 \$I17.P36.GatPoly vss.$150.Metal1 0.00143804f
Cred_2061 \$I17.P36.GatPoly vss.$153.Metal1 0.000712751f
Cred_2062 \$I17.P36.GatPoly vss.$406.Metal1 0.000172422f
Cred_2063 \$I17.P36.GatPoly vss.$457.Metal2 7.42274e-08f
Cred_2064 \$I17.P36.GatPoly vss.$503.Metal2 1.47444e-06f
Cred_2065 \$I17.P36.GatPoly vss.$507.Metal2 0.00787756f
Cred_2066 \$I17.P36.GatPoly vss.$509.Metal2 0.0119182f
Cred_2067 \$I17.P36.GatPoly vss.$839.Metal3 2.45292e-07f
Cred_2068 \$I17.P36.GatPoly vss.$841.Metal3 0.00194635f
Cred_2069 \$I17.P36.GatPoly vss.$845.Metal3 1.32389e-07f
Cred_2070 \$I17.P36.GatPoly vss.P0.GatPoly 1.817e-07f
Cred_2071 \$I17.P36.GatPoly vss.P0.pSD 0.000520307f
Cred_2072 \$I17.P36.GatPoly vss.P17.nSD 1.09376e-06f
Cred_2073 \$I17.P36.GatPoly vss.P19.nSD 0.0143954f
Cred_2074 \$I17.P37.GatPoly vss 0.0236243f
Cred_2075 \$I17.P37.GatPoly vout.$1241.Metal4 6.4441e-09f
Cred_2076 \$I17.P37.GatPoly vout.$1269.Metal4 0.000232339f
Cred_2077 \$I17.P37.GatPoly vout.$128.Metal1 1.59637e-06f
Cred_2078 \$I17.P37.GatPoly vout.$129.Metal1 0.00481842f
Cred_2079 \$I17.P37.GatPoly vout.$1299.Metal4 0.000111328f
Cred_2080 \$I17.P37.GatPoly vout.$19.Metal1 0.00900332f
Cred_2081 \$I17.P37.GatPoly vout.$452.Metal2 8.88066e-05f
Cred_2082 \$I17.P37.GatPoly vout.$472.Metal2 8.86066e-05f
Cred_2083 \$I17.P37.GatPoly vout.$512.Metal2 8.50434e-05f
Cred_2084 \$I17.P37.GatPoly vout.$530.Metal2 5.90855e-07f
Cred_2085 \$I17.P37.GatPoly vout.$532.Metal2 6.93037e-05f
Cred_2086 \$I17.P37.GatPoly vout.$69.Metal1 0.0238077f
Cred_2087 \$I17.P37.GatPoly vout.$860.Metal3 3.24353e-07f
Cred_2088 \$I17.P37.GatPoly vout.$938.Metal3 3.07639e-06f
Cred_2089 \$I17.P37.GatPoly vout.$940.Metal3 3.41576e-06f
Cred_2090 \$I17.P37.GatPoly vout.P14.nSD 6.81346e-07f
Cred_2091 \$I17.P37.GatPoly vout.P16.nSD 0.000236072f
Cred_2092 \$I17.P37.GatPoly vref 2.29045e-06f
Cred_2093 \$I17.P37.GatPoly vref.P0.GatPoly 8.71571e-08f
Cred_2094 \$I17.P37.GatPoly vref.P0.nSD 5.27119e-08f
Cred_2095 \$I17.P37.GatPoly vref.P0.pSD 9.23901e-08f
Cred_2096 \$I17.P37.GatPoly vss.$1053.Metal4 1.13393e-05f
Cred_2097 \$I17.P37.GatPoly vss.$127.Metal1 4.64675e-06f
Cred_2098 \$I17.P37.GatPoly vss.$150.Metal1 0.000610027f
Cred_2099 \$I17.P37.GatPoly vss.$153.Metal1 0.00123095f
Cred_2100 \$I17.P37.GatPoly vss.$406.Metal1 0.000201367f
Cred_2101 \$I17.P37.GatPoly vss.$457.Metal2 6.78652e-08f
Cred_2102 \$I17.P37.GatPoly vss.$503.Metal2 7.37083e-07f
Cred_2103 \$I17.P37.GatPoly vss.$507.Metal2 0.00492932f
Cred_2104 \$I17.P37.GatPoly vss.$509.Metal2 0.0147415f
Cred_2105 \$I17.P37.GatPoly vss.$839.Metal3 1.22623e-07f
Cred_2106 \$I17.P37.GatPoly vss.$841.Metal3 0.00096197f
Cred_2107 \$I17.P37.GatPoly vss.$845.Metal3 0.000961702f
Cred_2108 \$I17.P37.GatPoly vss.P0.GatPoly 1.66126e-07f
Cred_2109 \$I17.P37.GatPoly vss.P0.pSD 0.000520004f
Cred_2110 \$I17.P37.GatPoly vss.P17.nSD 5.46775e-07f
Cred_2111 \$I17.P37.GatPoly vss.P19.nSD 0.0143819f
Cred_2112 \$I17.P38.GatPoly vss 0.0235638f
Cred_2113 \$I17.P38.GatPoly vout.$1241.Metal4 6.4441e-09f
Cred_2114 \$I17.P38.GatPoly vout.$1269.Metal4 0.000220427f
Cred_2115 \$I17.P38.GatPoly vout.$129.Metal1 0.00481131f
Cred_2116 \$I17.P38.GatPoly vout.$1299.Metal4 7.62553e-05f
Cred_2117 \$I17.P38.GatPoly vout.$19.Metal1 0.00900332f
Cred_2118 \$I17.P38.GatPoly vout.$452.Metal2 8.88066e-05f
Cred_2119 \$I17.P38.GatPoly vout.$472.Metal2 8.86066e-05f
Cred_2120 \$I17.P38.GatPoly vout.$512.Metal2 8.50434e-05f
Cred_2121 \$I17.P38.GatPoly vout.$532.Metal2 6.68324e-05f
Cred_2122 \$I17.P38.GatPoly vout.$69.Metal1 0.0238077f
Cred_2123 \$I17.P38.GatPoly vout.$860.Metal3 3.24353e-07f
Cred_2124 \$I17.P38.GatPoly vout.$940.Metal3 4.0734e-08f
Cred_2125 \$I17.P38.GatPoly vout.P16.nSD 0.00023539f
Cred_2126 \$I17.P38.GatPoly vss.$1057.Metal4 8.28467e-06f
Cred_2127 \$I17.P38.GatPoly vss.$127.Metal1 3.69842e-06f
Cred_2128 \$I17.P38.GatPoly vss.$406.Metal1 0.000218752f
Cred_2129 \$I17.P38.GatPoly vss.$457.Metal2 5.40149e-08f
Cred_2130 \$I17.P38.GatPoly vss.$513.Metal2 0.0167718f
Cred_2131 \$I17.P38.GatPoly vss.$515.Metal2 0.00355745f
Cred_2132 \$I17.P38.GatPoly vss.$845.Metal3 0.000702635f
Cred_2133 \$I17.P38.GatPoly vss.$849.Metal3 0.000702635f
Cred_2134 \$I17.P38.GatPoly vss.P0.GatPoly 1.32222e-07f
Cred_2135 \$I17.P38.GatPoly vss.P0.pSD 0.000457438f
Cred_2136 \$I17.P38.GatPoly vss.P21.nSD 0.0156195f
Cred_2137 \$I17.P39.GatPoly vss 0.0236496f
Cred_2138 \$I17.P39.GatPoly vout.$1252.Metal4 6.47596e-09f
Cred_2139 \$I17.P39.GatPoly vout.$1269.Metal4 0.000228367f
Cred_2140 \$I17.P39.GatPoly vout.$1299.Metal4 0.000108186f
Cred_2141 \$I17.P39.GatPoly vout.$130.Metal1 0.0048196f
Cred_2142 \$I17.P39.GatPoly vout.$20.Metal1 0.00900332f
Cred_2143 \$I17.P39.GatPoly vout.$454.Metal2 8.88066e-05f
Cred_2144 \$I17.P39.GatPoly vout.$474.Metal2 8.86066e-05f
Cred_2145 \$I17.P39.GatPoly vout.$514.Metal2 8.50434e-05f
Cred_2146 \$I17.P39.GatPoly vout.$534.Metal2 7.02728e-05f
Cred_2147 \$I17.P39.GatPoly vout.$70.Metal1 0.0236513f
Cred_2148 \$I17.P39.GatPoly vout.$862.Metal3 3.24322e-07f
Cred_2149 \$I17.P39.GatPoly vout.$942.Metal3 8.32155e-06f
Cred_2150 \$I17.P39.GatPoly vout.P18.nSD 0.000237492f
Cred_2151 \$I17.P39.GatPoly vref 3.46846e-06f
Cred_2152 \$I17.P39.GatPoly vref.P0.GatPoly 5.80974e-08f
Cred_2153 \$I17.P39.GatPoly vref.P0.nSD 3.51368e-08f
Cred_2154 \$I17.P39.GatPoly vref.P0.pSD 6.15856e-08f
Cred_2155 \$I17.P39.GatPoly vss 1.01539e-06f
Cred_2156 \$I17.P39.GatPoly vss.$1212.Metal5 1.04718e-06f
Cred_2157 \$I17.P39.GatPoly vss.$1230.Metal5 1.04718e-06f
Cred_2158 \$I17.P39.GatPoly vss.$127.Metal1 3.26958e-06f
Cred_2159 \$I17.P39.GatPoly vss.$1282.Metal5 4.0084e-06f
Cred_2160 \$I17.P39.GatPoly vss.$1300.Metal5 1.26167e-05f
Cred_2161 \$I17.P39.GatPoly vss.$153.Metal1 0.000731264f
Cred_2162 \$I17.P39.GatPoly vss.$156.Metal1 0.00147545f
Cred_2163 \$I17.P39.GatPoly vss.$159.Metal1 2.89486e-06f
Cred_2164 \$I17.P39.GatPoly vss.$406.Metal1 0.000317736f
Cred_2165 \$I17.P39.GatPoly vss.$457.Metal2 4.77517e-08f
Cred_2166 \$I17.P39.GatPoly vss.$513.Metal2 0.0135522f
Cred_2167 \$I17.P39.GatPoly vss.$515.Metal2 0.00614878f
Cred_2168 \$I17.P39.GatPoly vss.$519.Metal2 9.30847e-07f
Cred_2169 \$I17.P39.GatPoly vss.$521.Metal2 3.15015e-06f
Cred_2170 \$I17.P39.GatPoly vss.$525.Metal2 4.22791e-08f
Cred_2171 \$I17.P39.GatPoly vss.$849.Metal3 0.00194615f
Cred_2172 \$I17.P39.GatPoly vss.$851.Metal3 4.21739e-07f
Cred_2173 \$I17.P39.GatPoly vss.P0.GatPoly 1.1689e-07f
Cred_2174 \$I17.P39.GatPoly vss.P0.pSD 0.000451823f
Cred_2175 \$I17.P39.GatPoly vss.P1.GatPoly 4.44921e-06f
Cred_2176 \$I17.P39.GatPoly vss.P21.nSD 0.0143742f
Cred_2177 \$I17.P39.GatPoly vss.P23.nSD 1.09009e-06f
Cred_2178 \$I17.P39.GatPoly vss.P25.nSD 9.03569e-07f
Cred_2179 \$I17.P4.GatPoly \$I33.$82.Metal2 1.85316e-05f
Cred_2180 \$I17.P4.GatPoly \$I50 0.0194212f
Cred_2181 \$I17.P4.GatPoly vss 0.000233654f
Cred_2182 \$I17.P4.GatPoly vdd.$2365.Metal1 1.45929e-05f
Cred_2183 \$I17.P4.GatPoly vdd.$2370.Metal1 4.7959e-09f
Cred_2184 \$I17.P4.GatPoly vdd.$2372.Metal1 0.00128684f
Cred_2185 \$I17.P4.GatPoly vdd.$2375.Metal1 0.000637747f
Cred_2186 \$I17.P4.GatPoly vdd.$2399.Metal1 1.50812e-06f
Cred_2187 \$I17.P4.GatPoly vdd.$2747.Metal2 8.4867e-07f
Cred_2188 \$I17.P4.GatPoly vdd.$2749.Metal2 6.49693e-07f
Cred_2189 \$I17.P4.GatPoly vdd.$2751.Metal2 6.77284e-07f
Cred_2190 \$I17.P4.GatPoly vdd.$2755.Metal2 3.80198e-06f
Cred_2191 \$I17.P4.GatPoly vdd.$2759.Metal2 0.0169464f
Cred_2192 \$I17.P4.GatPoly vdd.$2761.Metal2 0.00578368f
Cred_2193 \$I17.P4.GatPoly vdd.$2987.Metal3 4.7959e-09f
Cred_2194 \$I17.P4.GatPoly vdd.$2991.Metal3 0.00511499f
Cred_2195 \$I17.P4.GatPoly vdd.$2995.Metal3 0.00511499f
Cred_2196 \$I17.P4.GatPoly vdd.$3227.Metal4 6.03101e-05f
Cred_2197 \$I17.P4.GatPoly vdd.P0.nSD 0.000514951f
Cred_2198 \$I17.P4.GatPoly vdd.P0.pSD 7.41029e-07f
Cred_2199 \$I17.P4.GatPoly vdd.P1.GatPoly 2.41663e-06f
Cred_2200 \$I17.P4.GatPoly vdd.P1.pSD 1.63373e-06f
Cred_2201 \$I17.P4.GatPoly vdd.P2.GatPoly 6.70791e-08f
Cred_2202 \$I17.P4.GatPoly vdd.P3.pSD 6.22662e-06f
Cred_2203 \$I17.P4.GatPoly vdd.P5.pSD 0.0279481f
Cred_2204 \$I17.P4.GatPoly vout.$1032.Metal3 2.51268e-06f
Cred_2205 \$I17.P4.GatPoly vout.$1034.Metal3 2.54452e-06f
Cred_2206 \$I17.P4.GatPoly vout.$1112.Metal3 1.98606e-09f
Cred_2207 \$I17.P4.GatPoly vout.$1152.Metal3 4.70178e-09f
Cred_2208 \$I17.P4.GatPoly vout.$1154.Metal3 2.59218e-07f
Cred_2209 \$I17.P4.GatPoly vout.$1328.Metal4 1.17694e-06f
Cred_2210 \$I17.P4.GatPoly vout.$1329.Metal4 1.17716e-06f
Cred_2211 \$I17.P4.GatPoly vout.$1368.Metal4 4.3385e-08f
Cred_2212 \$I17.P4.GatPoly vout.$1369.Metal4 0.0253913f
Cred_2213 \$I17.P4.GatPoly vout.$1408.Metal4 5.49519e-07f
Cred_2214 \$I17.P4.GatPoly vout.$156.Metal1 4.40776e-06f
Cred_2215 \$I17.P4.GatPoly vout.$157.Metal1 0.00142135f
Cred_2216 \$I17.P4.GatPoly vout.$206.Metal1 1.60257e-06f
Cred_2217 \$I17.P4.GatPoly vout.$207.Metal1 0.00548928f
Cred_2218 \$I17.P4.GatPoly vout.$227.Metal1 0.00598064f
Cred_2219 \$I17.P4.GatPoly vout.$267.Metal1 0.00594737f
Cred_2220 \$I17.P4.GatPoly vout.$287.Metal1 0.00594809f
Cred_2221 \$I17.P4.GatPoly vout.$327.Metal1 0.00598025f
Cred_2222 \$I17.P4.GatPoly vout.$347.Metal1 0.00789348f
Cred_2223 \$I17.P4.GatPoly vout.$397.Metal1 0.00868084f
Cred_2224 \$I17.P4.GatPoly vout.$584.Metal2 9.7302e-07f
Cred_2225 \$I17.P4.GatPoly vout.$586.Metal2 2.07532e-05f
Cred_2226 \$I17.P4.GatPoly vout.$604.Metal2 8.53575e-08f
Cred_2227 \$I17.P4.GatPoly vout.$606.Metal2 3.24533e-05f
Cred_2228 \$I17.P4.GatPoly vout.$646.Metal2 1.81802e-05f
Cred_2229 \$I17.P4.GatPoly vout.$666.Metal2 3.58831e-05f
Cred_2230 \$I17.P4.GatPoly vout.$686.Metal2 1.03999e-05f
Cred_2231 \$I17.P4.GatPoly vout.$706.Metal2 3.54639e-05f
Cred_2232 \$I17.P4.GatPoly vout.$724.Metal2 2.08067e-11f
Cred_2233 \$I17.P4.GatPoly vout.$726.Metal2 1.92924e-05f
Cred_2234 \$I17.P4.GatPoly vout.$766.Metal2 8.43544e-05f
Cred_2235 \$I17.P4.GatPoly vout.$786.Metal2 8.69621e-05f
Cred_2236 \$I17.P4.GatPoly vout.P0.pSD 1.84206e-06f
Cred_2237 \$I17.P4.GatPoly vout.P2.pSD 0.000195873f
Cred_2238 \$I17.P4.GatPoly vss.$1282.Metal5 0.00234755f
Cred_2239 \$I17.P40.GatPoly vss 0.0236951f
Cred_2240 \$I17.P40.GatPoly vout.$1252.Metal4 6.47596e-09f
Cred_2241 \$I17.P40.GatPoly vout.$1269.Metal4 7.93755e-06f
Cred_2242 \$I17.P40.GatPoly vout.$1299.Metal4 4.13072e-05f
Cred_2243 \$I17.P40.GatPoly vout.$130.Metal1 0.00478956f
Cred_2244 \$I17.P40.GatPoly vout.$20.Metal1 0.00900332f
Cred_2245 \$I17.P40.GatPoly vout.$454.Metal2 8.88066e-05f
Cred_2246 \$I17.P40.GatPoly vout.$474.Metal2 8.86066e-05f
Cred_2247 \$I17.P40.GatPoly vout.$514.Metal2 8.50434e-05f
Cred_2248 \$I17.P40.GatPoly vout.$534.Metal2 6.91928e-05f
Cred_2249 \$I17.P40.GatPoly vout.$70.Metal1 0.0199927f
Cred_2250 \$I17.P40.GatPoly vout.$862.Metal3 3.24322e-07f
Cred_2251 \$I17.P40.GatPoly vout.$942.Metal3 1.2212e-05f
Cred_2252 \$I17.P40.GatPoly vout.P18.nSD 0.0002384f
Cred_2253 \$I17.P40.GatPoly vref 5.4103e-06f
Cred_2254 \$I17.P40.GatPoly vref.P0.GatPoly 5.80755e-08f
Cred_2255 \$I17.P40.GatPoly vref.P0.nSD 3.51235e-08f
Cred_2256 \$I17.P40.GatPoly vref.P0.pSD 6.15624e-08f
Cred_2257 \$I17.P40.GatPoly vss 2.03117e-06f
Cred_2258 \$I17.P40.GatPoly vss.$1061.Metal4 0.0017689f
Cred_2259 \$I17.P40.GatPoly vss.$1212.Metal5 2.09476e-06f
Cred_2260 \$I17.P40.GatPoly vss.$1230.Metal5 2.09476e-06f
Cred_2261 \$I17.P40.GatPoly vss.$127.Metal1 2.43336e-06f
Cred_2262 \$I17.P40.GatPoly vss.$1282.Metal5 8.01831e-06f
Cred_2263 \$I17.P40.GatPoly vss.$1300.Metal5 0.00294801f
Cred_2264 \$I17.P40.GatPoly vss.$156.Metal1 0.00153953f
Cred_2265 \$I17.P40.GatPoly vss.$159.Metal1 0.000410871f
Cred_2266 \$I17.P40.GatPoly vss.$406.Metal1 0.00987732f
Cred_2267 \$I17.P40.GatPoly vss.$457.Metal2 3.55388e-08f
Cred_2268 \$I17.P40.GatPoly vss.$513.Metal2 2.68112e-06f
Cred_2269 \$I17.P40.GatPoly vss.$515.Metal2 0.00318928f
Cred_2270 \$I17.P40.GatPoly vss.$519.Metal2 0.0127418f
Cred_2271 \$I17.P40.GatPoly vss.$521.Metal2 6.30148e-06f
Cred_2272 \$I17.P40.GatPoly vss.$525.Metal2 6.00072e-06f
Cred_2273 \$I17.P40.GatPoly vss.$849.Metal3 4.69678e-07f
Cred_2274 \$I17.P40.GatPoly vss.$851.Metal3 0.00198412f
Cred_2275 \$I17.P40.GatPoly vss.P0.GatPoly 8.69949e-08f
Cred_2276 \$I17.P40.GatPoly vss.P0.pSD 0.00110747f
Cred_2277 \$I17.P40.GatPoly vss.P1.GatPoly 0.04436f
Cred_2278 \$I17.P40.GatPoly vss.P21.nSD 2.18804e-06f
Cred_2279 \$I17.P40.GatPoly vss.P23.nSD 0.0119722f
Cred_2280 \$I17.P40.GatPoly vss.P25.nSD 1.80748e-06f
Cred_2281 \$I17.P5.GatPoly \$I33.$82.Metal2 1.75998e-05f
Cred_2282 \$I17.P5.GatPoly \$I50 0.0193278f
Cred_2283 \$I17.P5.GatPoly vss 0.000218554f
Cred_2284 \$I17.P5.GatPoly vdd.$2365.Metal1 8.56212e-06f
Cred_2285 \$I17.P5.GatPoly vdd.$2372.Metal1 0.000632538f
Cred_2286 \$I17.P5.GatPoly vdd.$2375.Metal1 0.00127627f
Cred_2287 \$I17.P5.GatPoly vdd.$2399.Metal1 1.63518e-06f
Cred_2288 \$I17.P5.GatPoly vdd.$2759.Metal2 0.0139636f
Cred_2289 \$I17.P5.GatPoly vdd.$2761.Metal2 0.00877098f
Cred_2290 \$I17.P5.GatPoly vdd.$2995.Metal3 0.0104378f
Cred_2291 \$I17.P5.GatPoly vdd.P0.nSD 0.00045828f
Cred_2292 \$I17.P5.GatPoly vdd.P1.GatPoly 3.8083e-07f
Cred_2293 \$I17.P5.GatPoly vdd.P2.GatPoly 7.27303e-08f
Cred_2294 \$I17.P5.GatPoly vdd.P5.pSD 0.0279451f
Cred_2295 \$I17.P5.GatPoly vout.$1036.Metal3 5.26623e-08f
Cred_2296 \$I17.P5.GatPoly vout.$1096.Metal3 1.02187e-07f
Cred_2297 \$I17.P5.GatPoly vout.$1156.Metal3 2.59218e-07f
Cred_2298 \$I17.P5.GatPoly vout.$1330.Metal4 1.917e-09f
Cred_2299 \$I17.P5.GatPoly vout.$1370.Metal4 0.0285377f
Cred_2300 \$I17.P5.GatPoly vout.$158.Metal1 0.0013789f
Cred_2301 \$I17.P5.GatPoly vout.$208.Metal1 0.00547222f
Cred_2302 \$I17.P5.GatPoly vout.$228.Metal1 0.00598064f
Cred_2303 \$I17.P5.GatPoly vout.$268.Metal1 0.00594742f
Cred_2304 \$I17.P5.GatPoly vout.$288.Metal1 0.00594814f
Cred_2305 \$I17.P5.GatPoly vout.$328.Metal1 0.00598025f
Cred_2306 \$I17.P5.GatPoly vout.$348.Metal1 0.00789348f
Cred_2307 \$I17.P5.GatPoly vout.$398.Metal1 0.00868084f
Cred_2308 \$I17.P5.GatPoly vout.$588.Metal2 1.91984e-05f
Cred_2309 \$I17.P5.GatPoly vout.$608.Metal2 3.20309e-05f
Cred_2310 \$I17.P5.GatPoly vout.$648.Metal2 1.81802e-05f
Cred_2311 \$I17.P5.GatPoly vout.$668.Metal2 4.09811e-05f
Cred_2312 \$I17.P5.GatPoly vout.$708.Metal2 4.05619e-05f
Cred_2313 \$I17.P5.GatPoly vout.$728.Metal2 1.92924e-05f
Cred_2314 \$I17.P5.GatPoly vout.$768.Metal2 8.43544e-05f
Cred_2315 \$I17.P5.GatPoly vout.$788.Metal2 8.69621e-05f
Cred_2316 \$I17.P5.GatPoly vout.P4.pSD 0.000193509f
Cred_2317 \$I17.P5.GatPoly vss.$1282.Metal5 0.00230853f
Cred_2318 \$I17.P6.GatPoly \$I33.$82.Metal2 1.91226e-05f
Cred_2319 \$I17.P6.GatPoly \$I33.P1.GatPoly 1.7412e-09f
Cred_2320 \$I17.P6.GatPoly \$I33.P2.GatPoly 1.65854e-09f
Cred_2321 \$I17.P6.GatPoly \$I50 0.0193391f
Cred_2322 \$I17.P6.GatPoly vss 0.000219521f
Cred_2323 \$I17.P6.GatPoly vdd.$2365.Metal1 7.65699e-06f
Cred_2324 \$I17.P6.GatPoly vdd.$2375.Metal1 0.00207979f
Cred_2325 \$I17.P6.GatPoly vdd.$2399.Metal1 1.90111e-06f
Cred_2326 \$I17.P6.GatPoly vdd.$2763.Metal2 0.00732773f
Cred_2327 \$I17.P6.GatPoly vdd.$2765.Metal2 0.0153889f
Cred_2328 \$I17.P6.GatPoly vdd.$2995.Metal3 0.00509038f
Cred_2329 \$I17.P6.GatPoly vdd.$2999.Metal3 0.00509038f
Cred_2330 \$I17.P6.GatPoly vdd.$3231.Metal4 6.00199e-05f
Cred_2331 \$I17.P6.GatPoly vdd.P0.nSD 0.000461198f
Cred_2332 \$I17.P6.GatPoly vdd.P1.GatPoly 3.40571e-07f
Cred_2333 \$I17.P6.GatPoly vdd.P2.GatPoly 8.45587e-08f
Cred_2334 \$I17.P6.GatPoly vdd.P7.pSD 0.027905f
Cred_2335 \$I17.P6.GatPoly vout.$1036.Metal3 6.03291e-07f
Cred_2336 \$I17.P6.GatPoly vout.$1096.Metal3 1.02187e-07f
Cred_2337 \$I17.P6.GatPoly vout.$1156.Metal3 2.59218e-07f
Cred_2338 \$I17.P6.GatPoly vout.$1330.Metal4 6.7497e-08f
Cred_2339 \$I17.P6.GatPoly vout.$1370.Metal4 0.025391f
Cred_2340 \$I17.P6.GatPoly vout.$158.Metal1 0.00149835f
Cred_2341 \$I17.P6.GatPoly vout.$208.Metal1 0.00537059f
Cred_2342 \$I17.P6.GatPoly vout.$228.Metal1 0.00598064f
Cred_2343 \$I17.P6.GatPoly vout.$268.Metal1 0.00594742f
Cred_2344 \$I17.P6.GatPoly vout.$288.Metal1 0.00594814f
Cred_2345 \$I17.P6.GatPoly vout.$328.Metal1 0.00598025f
Cred_2346 \$I17.P6.GatPoly vout.$348.Metal1 0.00789348f
Cred_2347 \$I17.P6.GatPoly vout.$398.Metal1 0.00868084f
Cred_2348 \$I17.P6.GatPoly vout.$588.Metal2 1.61236e-05f
Cred_2349 \$I17.P6.GatPoly vout.$608.Metal2 2.98229e-05f
Cred_2350 \$I17.P6.GatPoly vout.$648.Metal2 1.81802e-05f
Cred_2351 \$I17.P6.GatPoly vout.$668.Metal2 4.09811e-05f
Cred_2352 \$I17.P6.GatPoly vout.$708.Metal2 4.05619e-05f
Cred_2353 \$I17.P6.GatPoly vout.$728.Metal2 1.92924e-05f
Cred_2354 \$I17.P6.GatPoly vout.$768.Metal2 8.43544e-05f
Cred_2355 \$I17.P6.GatPoly vout.$788.Metal2 8.69621e-05f
Cred_2356 \$I17.P6.GatPoly vout.P4.pSD 0.000190418f
Cred_2357 \$I17.P6.GatPoly vref 3.12266e-06f
Cred_2358 \$I17.P6.GatPoly vref.P0.GatPoly 1.21766e-07f
Cred_2359 \$I17.P6.GatPoly vref.P0.nSD 6.98045e-07f
Cred_2360 \$I17.P6.GatPoly vref.P0.pSD 2.03824e-06f
Cred_2361 \$I17.P6.GatPoly vss.$1282.Metal5 0.00237877f
Cred_2362 \$I17.P7.GatPoly \$I33.$82.Metal2 2.41943e-05f
Cred_2363 \$I17.P7.GatPoly \$I50 0.0193278f
Cred_2364 \$I17.P7.GatPoly vss 0.000208121f
Cred_2365 \$I17.P7.GatPoly vdd.$2365.Metal1 6.7704e-06f
Cred_2366 \$I17.P7.GatPoly vdd.$2375.Metal1 0.000698139f
Cred_2367 \$I17.P7.GatPoly vdd.$2377.Metal1 0.000698169f
Cred_2368 \$I17.P7.GatPoly vdd.$2399.Metal1 2.15355e-06f
Cred_2369 \$I17.P7.GatPoly vdd.$2763.Metal2 0.00515221f
Cred_2370 \$I17.P7.GatPoly vdd.$2765.Metal2 0.0206894f
Cred_2371 \$I17.P7.GatPoly vdd.$2999.Metal3 0.00211274f
Cred_2372 \$I17.P7.GatPoly vdd.P0.nSD 0.000464384f
Cred_2373 \$I17.P7.GatPoly vdd.P1.GatPoly 3.01137e-07f
Cred_2374 \$I17.P7.GatPoly vdd.P2.GatPoly 9.57867e-08f
Cred_2375 \$I17.P7.GatPoly vdd.P7.pSD 0.0333529f
Cred_2376 \$I17.P7.GatPoly vout.$1038.Metal3 5.26623e-08f
Cred_2377 \$I17.P7.GatPoly vout.$1158.Metal3 2.59218e-07f
Cred_2378 \$I17.P7.GatPoly vout.$1331.Metal4 1.917e-09f
Cred_2379 \$I17.P7.GatPoly vout.$1371.Metal4 0.0285377f
Cred_2380 \$I17.P7.GatPoly vout.$159.Metal1 0.00154033f
Cred_2381 \$I17.P7.GatPoly vout.$209.Metal1 0.00537034f
Cred_2382 \$I17.P7.GatPoly vout.$229.Metal1 0.00598064f
Cred_2383 \$I17.P7.GatPoly vout.$269.Metal1 0.00594737f
Cred_2384 \$I17.P7.GatPoly vout.$289.Metal1 0.00594809f
Cred_2385 \$I17.P7.GatPoly vout.$329.Metal1 0.00598025f
Cred_2386 \$I17.P7.GatPoly vout.$349.Metal1 0.00789348f
Cred_2387 \$I17.P7.GatPoly vout.$399.Metal1 0.00868084f
Cred_2388 \$I17.P7.GatPoly vout.$590.Metal2 1.56444e-05f
Cred_2389 \$I17.P7.GatPoly vout.$610.Metal2 2.98064e-05f
Cred_2390 \$I17.P7.GatPoly vout.$650.Metal2 1.81802e-05f
Cred_2391 \$I17.P7.GatPoly vout.$670.Metal2 3.58831e-05f
Cred_2392 \$I17.P7.GatPoly vout.$690.Metal2 1.03999e-05f
Cred_2393 \$I17.P7.GatPoly vout.$710.Metal2 3.54639e-05f
Cred_2394 \$I17.P7.GatPoly vout.$730.Metal2 1.92924e-05f
Cred_2395 \$I17.P7.GatPoly vout.$770.Metal2 8.43544e-05f
Cred_2396 \$I17.P7.GatPoly vout.$790.Metal2 8.69621e-05f
Cred_2397 \$I17.P7.GatPoly vout.P6.pSD 0.000190083f
Cred_2398 \$I17.P7.GatPoly vss.$1282.Metal5 0.00240482f
Cred_2399 \$I17.P8.GatPoly \$I33.$82.Metal2 4.20867e-05f
Cred_2400 \$I17.P8.GatPoly \$I33.P1.GatPoly 2.99731e-07f
Cred_2401 \$I17.P8.GatPoly \$I33.P2.GatPoly 2.85502e-07f
Cred_2402 \$I17.P8.GatPoly \$I50 0.0193511f
Cred_2403 \$I17.P8.GatPoly vss 0.000165778f
Cred_2404 \$I17.P8.GatPoly vdd.$2365.Metal1 5.82482e-06f
Cred_2405 \$I17.P8.GatPoly vdd.$2377.Metal1 0.000928224f
Cred_2406 \$I17.P8.GatPoly vdd.$2379.Metal1 0.000928243f
Cred_2407 \$I17.P8.GatPoly vdd.$2399.Metal1 2.42846e-06f
Cred_2408 \$I17.P8.GatPoly vdd.$2769.Metal2 0.0172418f
Cred_2409 \$I17.P8.GatPoly vdd.$2771.Metal2 0.00529381f
Cred_2410 \$I17.P8.GatPoly vdd.$3003.Metal3 0.0105093f
Cred_2411 \$I17.P8.GatPoly vdd.P0.nSD 0.000458058f
Cred_2412 \$I17.P8.GatPoly vdd.P1.GatPoly 2.59079e-07f
Cred_2413 \$I17.P8.GatPoly vdd.P10.pSD 0.0279461f
Cred_2414 \$I17.P8.GatPoly vdd.P2.GatPoly 1.08014e-07f
Cred_2415 \$I17.P8.GatPoly vout.$1038.Metal3 8.09809e-07f
Cred_2416 \$I17.P8.GatPoly vout.$1040.Metal3 4.64793e-07f
Cred_2417 \$I17.P8.GatPoly vout.$1158.Metal3 2.59218e-07f
Cred_2418 \$I17.P8.GatPoly vout.$1331.Metal4 3.85217e-07f
Cred_2419 \$I17.P8.GatPoly vout.$1332.Metal4 2.11602e-07f
Cred_2420 \$I17.P8.GatPoly vout.$1371.Metal4 0.0250989f
Cred_2421 \$I17.P8.GatPoly vout.$1372.Metal4 1.20553e-07f
Cred_2422 \$I17.P8.GatPoly vout.$159.Metal1 0.00156101f
Cred_2423 \$I17.P8.GatPoly vout.$160.Metal1 8.83061e-07f
Cred_2424 \$I17.P8.GatPoly vout.$209.Metal1 0.00537069f
Cred_2425 \$I17.P8.GatPoly vout.$210.Metal1 1.7382e-07f
Cred_2426 \$I17.P8.GatPoly vout.$229.Metal1 0.00598064f
Cred_2427 \$I17.P8.GatPoly vout.$269.Metal1 0.00594737f
Cred_2428 \$I17.P8.GatPoly vout.$289.Metal1 0.00594809f
Cred_2429 \$I17.P8.GatPoly vout.$329.Metal1 0.00598025f
Cred_2430 \$I17.P8.GatPoly vout.$349.Metal1 0.00789348f
Cred_2431 \$I17.P8.GatPoly vout.$399.Metal1 0.00868084f
Cred_2432 \$I17.P8.GatPoly vout.$590.Metal2 1.59986e-05f
Cred_2433 \$I17.P8.GatPoly vout.$592.Metal2 1.63776e-07f
Cred_2434 \$I17.P8.GatPoly vout.$610.Metal2 2.98292e-05f
Cred_2435 \$I17.P8.GatPoly vout.$612.Metal2 1.31119e-08f
Cred_2436 \$I17.P8.GatPoly vout.$650.Metal2 1.81802e-05f
Cred_2437 \$I17.P8.GatPoly vout.$670.Metal2 3.58831e-05f
Cred_2438 \$I17.P8.GatPoly vout.$690.Metal2 1.03999e-05f
Cred_2439 \$I17.P8.GatPoly vout.$710.Metal2 3.54639e-05f
Cred_2440 \$I17.P8.GatPoly vout.$730.Metal2 1.92924e-05f
Cred_2441 \$I17.P8.GatPoly vout.$770.Metal2 8.43544e-05f
Cred_2442 \$I17.P8.GatPoly vout.$790.Metal2 8.69621e-05f
Cred_2443 \$I17.P8.GatPoly vout.P6.pSD 0.00019055f
Cred_2444 \$I17.P8.GatPoly vout.P8.pSD 3.75489e-07f
Cred_2445 \$I17.P8.GatPoly vss.$1282.Metal5 0.00240255f
Cred_2446 \$I17.P9.GatPoly \$I33.$82.Metal2 4.20572e-05f
Cred_2447 \$I17.P9.GatPoly \$I33.P1.GatPoly 3.0088e-07f
Cred_2448 \$I17.P9.GatPoly \$I33.P2.GatPoly 2.86596e-07f
Cred_2449 \$I17.P9.GatPoly \$I50 0.0193511f
Cred_2450 \$I17.P9.GatPoly vss 0.000165847f
Cred_2451 \$I17.P9.GatPoly vdd.$2365.Metal1 5.35729e-06f
Cred_2452 \$I17.P9.GatPoly vdd.$2379.Metal1 0.00193035f
Cred_2453 \$I17.P9.GatPoly vdd.$2399.Metal1 2.83057e-06f
Cred_2454 \$I17.P9.GatPoly vdd.$2769.Metal2 0.0144388f
Cred_2455 \$I17.P9.GatPoly vdd.$2771.Metal2 0.00832053f
Cred_2456 \$I17.P9.GatPoly vdd.$3003.Metal3 0.00516426f
Cred_2457 \$I17.P9.GatPoly vdd.$3007.Metal3 0.00516426f
Cred_2458 \$I17.P9.GatPoly vdd.$3239.Metal4 6.0891e-05f
Cred_2459 \$I17.P9.GatPoly vdd.P0.nSD 0.000471132f
Cred_2460 \$I17.P9.GatPoly vdd.P1.GatPoly 2.38284e-07f
Cred_2461 \$I17.P9.GatPoly vdd.P10.pSD 0.0279456f
Cred_2462 \$I17.P9.GatPoly vdd.P2.GatPoly 1.25899e-07f
Cred_2463 \$I17.P9.GatPoly vout.$1038.Metal3 3.78175e-07f
Cred_2464 \$I17.P9.GatPoly vout.$1040.Metal3 9.82351e-07f
Cred_2465 \$I17.P9.GatPoly vout.$1180.Metal3 2.42643e-07f
Cred_2466 \$I17.P9.GatPoly vout.$1331.Metal4 1.91586e-07f
Cred_2467 \$I17.P9.GatPoly vout.$1332.Metal4 4.25167e-07f
Cred_2468 \$I17.P9.GatPoly vout.$1371.Metal4 1.1577e-07f
Cred_2469 \$I17.P9.GatPoly vout.$1372.Metal4 0.0250989f
Cred_2470 \$I17.P9.GatPoly vout.$159.Metal1 8.86781e-07f
Cred_2471 \$I17.P9.GatPoly vout.$160.Metal1 0.0015567f
Cred_2472 \$I17.P9.GatPoly vout.$209.Metal1 1.7382e-07f
Cred_2473 \$I17.P9.GatPoly vout.$210.Metal1 0.00537069f
Cred_2474 \$I17.P9.GatPoly vout.$230.Metal1 0.00598064f
Cred_2475 \$I17.P9.GatPoly vout.$270.Metal1 0.00594737f
Cred_2476 \$I17.P9.GatPoly vout.$290.Metal1 0.00594809f
Cred_2477 \$I17.P9.GatPoly vout.$330.Metal1 0.00598025f
Cred_2478 \$I17.P9.GatPoly vout.$350.Metal1 0.00789344f
Cred_2479 \$I17.P9.GatPoly vout.$400.Metal1 0.00868084f
Cred_2480 \$I17.P9.GatPoly vout.$590.Metal2 1.55002e-07f
Cred_2481 \$I17.P9.GatPoly vout.$592.Metal2 1.5972e-05f
Cred_2482 \$I17.P9.GatPoly vout.$610.Metal2 1.13757e-08f
Cred_2483 \$I17.P9.GatPoly vout.$612.Metal2 2.98326e-05f
Cred_2484 \$I17.P9.GatPoly vout.$652.Metal2 1.81802e-05f
Cred_2485 \$I17.P9.GatPoly vout.$672.Metal2 3.58831e-05f
Cred_2486 \$I17.P9.GatPoly vout.$692.Metal2 1.03999e-05f
Cred_2487 \$I17.P9.GatPoly vout.$712.Metal2 3.54639e-05f
Cred_2488 \$I17.P9.GatPoly vout.$732.Metal2 1.72395e-05f
Cred_2489 \$I17.P9.GatPoly vout.$752.Metal2 4.18787e-06f
Cred_2490 \$I17.P9.GatPoly vout.$772.Metal2 8.22972e-05f
Cred_2491 \$I17.P9.GatPoly vout.$792.Metal2 8.69543e-05f
Cred_2492 \$I17.P9.GatPoly vout.P6.pSD 2.33354e-07f
Cred_2493 \$I17.P9.GatPoly vout.P8.pSD 0.000190834f
Cred_2494 \$I17.P9.GatPoly vss.$1282.Metal5 0.00240255f
Cred_2495 \$I26 \$I28 8.03625e-05f
Cred_2496 \$I26 \$I28.P0.Metal5 0.00902031f
Cred_2497 \$I26 \$I30 0.000551125f
Cred_2498 \$I26 \$I30.P0.Metal1 0.00155675f
Cred_2499 \$I26 \$I33 0.00214308f
Cred_2500 \$I26 \$I33.$82.Metal2 0.000213276f
Cred_2501 \$I26 \$I50 5.90304e-05f
Cred_2502 \$I26 rfin 0.00627987f
Cred_2503 \$I26 vss 0.823829f
Cred_2504 \$I26 vdd 0.00129678f
Cred_2505 \$I26 vdd.$2365.Metal1 1.56137e-06f
Cred_2506 \$I26 vdd.$2370.Metal1 1.4632e-09f
Cred_2507 \$I26 vdd.$2394.Metal1 1.4632e-09f
Cred_2508 \$I26 vdd.$2399.Metal1 1.56137e-06f
Cred_2509 \$I26 vdd.$2747.Metal2 1.19436e-06f
Cred_2510 \$I26 vdd.$2749.Metal2 9.72784e-07f
Cred_2511 \$I26 vdd.$2751.Metal2 5.31968e-07f
Cred_2512 \$I26 vdd.$2755.Metal2 1.15996e-06f
Cred_2513 \$I26 vdd.$2759.Metal2 9.09971e-07f
Cred_2514 \$I26 vdd.$2761.Metal2 3.7654e-07f
Cred_2515 \$I26 vdd.$2763.Metal2 2.82525e-07f
Cred_2516 \$I26 vdd.$2765.Metal2 1.00453e-06f
Cred_2517 \$I26 vdd.$2769.Metal2 9.41469e-07f
Cred_2518 \$I26 vdd.$2771.Metal2 3.45205e-07f
Cred_2519 \$I26 vdd.$2773.Metal2 1.99325e-07f
Cred_2520 \$I26 vdd.$2775.Metal2 6.17908e-07f
Cred_2521 \$I26 vdd.$2779.Metal2 6.17908e-07f
Cred_2522 \$I26 vdd.$2781.Metal2 1.99325e-07f
Cred_2523 \$I26 vdd.$2783.Metal2 3.45205e-07f
Cred_2524 \$I26 vdd.$2785.Metal2 9.41469e-07f
Cred_2525 \$I26 vdd.$2789.Metal2 1.00453e-06f
Cred_2526 \$I26 vdd.$2791.Metal2 2.82525e-07f
Cred_2527 \$I26 vdd.$2793.Metal2 3.7654e-07f
Cred_2528 \$I26 vdd.$2795.Metal2 9.09971e-07f
Cred_2529 \$I26 vdd.$2799.Metal2 1.15996e-06f
Cred_2530 \$I26 vdd.$2803.Metal2 5.31968e-07f
Cred_2531 \$I26 vdd.$2805.Metal2 9.72784e-07f
Cred_2532 \$I26 vdd.$2807.Metal2 1.19436e-06f
Cred_2533 \$I26 vdd.$2987.Metal3 1.4632e-09f
Cred_2534 \$I26 vdd.$3035.Metal3 1.4632e-09f
Cred_2535 \$I26 vdd.$3213.Metal4 4.62563e-12f
Cred_2536 \$I26 vdd.$3215.Metal4 1.65333e-11f
Cred_2537 \$I26 vdd.$3223.Metal4 8.87263e-11f
Cred_2538 \$I26 vdd.$3231.Metal4 5.33484e-11f
Cred_2539 \$I26 vdd.$3259.Metal4 5.33484e-11f
Cred_2540 \$I26 vdd.$3267.Metal4 8.87263e-11f
Cred_2541 \$I26 vdd.$3275.Metal4 1.65333e-11f
Cred_2542 \$I26 vdd.$3277.Metal4 4.62563e-12f
Cred_2543 \$I26 vdd.$3448.Metal5 6.08607e-09f
Cred_2544 \$I26 vdd.$3450.Metal5 7.52502e-09f
Cred_2545 \$I26 vdd.$3452.Metal5 5.44552e-08f
Cred_2546 \$I26 vdd.$3454.Metal5 4.52456e-09f
Cred_2547 \$I26 vdd.$3456.Metal5 5.76223e-08f
Cred_2548 \$I26 vdd.$3459.Metal5 3.42059e-09f
Cred_2549 \$I26 vdd.$3460.Metal5 6.67016e-08f
Cred_2550 \$I26 vdd.$3462.Metal5 5.60968e-08f
Cred_2551 \$I26 vdd.$3468.Metal5 5.76223e-08f
Cred_2552 \$I26 vdd.$3470.Metal5 4.52456e-09f
Cred_2553 \$I26 vdd.$3472.Metal5 5.44552e-08f
Cred_2554 \$I26 vdd.$3474.Metal5 7.52502e-09f
Cred_2555 \$I26 vdd.$3476.Metal5 6.08607e-09f
Cred_2556 \$I26 vdd.$3480.Metal5 1.7623e-07f
Cred_2557 \$I26 vdd.$3496.Metal5 1.7623e-07f
Cred_2558 \$I26 vdd.$3615.TopMetal1 4.58285e-05f
Cred_2559 \$I26 vdd.$3617.TopMetal1 5.95232e-05f
Cred_2560 \$I26 vdd.$3619.TopMetal1 6.1432e-05f
Cred_2561 \$I26 vdd.$3622.TopMetal1 3.35608e-05f
Cred_2562 \$I26 vdd.$3623.TopMetal1 4.46867e-05f
Cred_2563 \$I26 vdd.$3625.TopMetal1 5.95232e-05f
Cred_2564 \$I26 vdd.$3627.TopMetal1 4.58285e-05f
Cred_2565 \$I26 vdd.$3700.TopMetal1 0.000162006f
Cred_2566 \$I26 vdd.$3707.TopMetal1 0.000162006f
Cred_2567 \$I26 vdd.$4071.TopMetal1 0.0189032f
Cred_2568 \$I26 vdd.$4456.TopMetal1 1.0137e-06f
Cred_2569 \$I26 vdd.$4841.TopMetal1 5.43605e-11f
Cred_2570 \$I26 vdd.$5226.TopMetal1 2.91528e-15f
Cred_2571 \$I26 vdd.P0.GatPoly 0.0056354f
Cred_2572 \$I26 vdd.P0.nSD 2.67183e-06f
Cred_2573 \$I26 vdd.P0.pSD 3.09664e-07f
Cred_2574 \$I26 vdd.P1.GatPoly 1.40254e-09f
Cred_2575 \$I26 vdd.P1.pSD 3.11947e-07f
Cred_2576 \$I26 vdd.P10.pSD 3.11637e-07f
Cred_2577 \$I26 vdd.P11.pSD 1.97793e-07f
Cred_2578 \$I26 vdd.P13.pSD 1.97793e-07f
Cred_2579 \$I26 vdd.P15.pSD 3.11637e-07f
Cred_2580 \$I26 vdd.P17.pSD 3.11254e-07f
Cred_2581 \$I26 vdd.P19.pSD 3.11801e-07f
Cred_2582 \$I26 vdd.P2.GatPoly 1.40254e-09f
Cred_2583 \$I26 vdd.P21.pSD 3.11323e-07f
Cred_2584 \$I26 vdd.P23.pSD 3.11947e-07f
Cred_2585 \$I26 vdd.P25.pSD 3.09664e-07f
Cred_2586 \$I26 vdd.P3.pSD 3.11323e-07f
Cred_2587 \$I26 vdd.P5.pSD 3.11801e-07f
Cred_2588 \$I26 vdd.P7.pSD 3.11254e-07f
Cred_2589 \$I26 vout 4.10768e-05f
Cred_2590 \$I26 vout.$1238.Metal4 4.54195e-06f
Cred_2591 \$I26 vout.$1239.Metal4 1.0332e-06f
Cred_2592 \$I26 vout.$1299.Metal4 1.32041e-06f
Cred_2593 \$I26 vout.$1313.Metal4 6.88103e-10f
Cred_2594 \$I26 vout.$1372.Metal4 2.99227e-05f
Cred_2595 \$I26 vout.$1383.Metal4 4.97206e-06f
Cred_2596 \$I26 vout.P0.GatPoly 6.44357e-09f
Cred_2597 \$I26 vref 9.13341e-05f
Cred_2598 \$I26 vref.P0.GatPoly 2.60349e-06f
Cred_2599 \$I26 vref.P0.nSD 1.4841e-05f
Cred_2600 \$I26 vref.P0.pSD 2.74265e-05f
Cred_2601 \$I26 vss 0.0816624f
Cred_2602 \$I26 vss.$1033.Metal4 2.61976e-06f
Cred_2603 \$I26 vss.$1037.Metal4 2.61976e-06f
Cred_2604 \$I26 vss.$1212.Metal5 0.344726f
Cred_2605 \$I26 vss.$1230.Metal5 0.192248f
Cred_2606 \$I26 vss.$1247.Metal5 0.00990987f
Cred_2607 \$I26 vss.$1282.Metal5 0.697035f
Cred_2608 \$I26 vss.$1300.Metal5 0.388507f
Cred_2609 \$I26 vss.$825.Metal3 3.08891e-08f
Cred_2610 \$I26.$2169.TopMetal1 \$I28 0.000155987f
Cred_2611 \$I26.$2169.TopMetal1 \$I28.P0.Metal5 0.0175089f
Cred_2612 \$I26.$2169.TopMetal1 \$I30 0.00106976f
Cred_2613 \$I26.$2169.TopMetal1 \$I30.P0.Metal1 0.00302172f
Cred_2614 \$I26.$2169.TopMetal1 \$I33 0.0474975f
Cred_2615 \$I26.$2169.TopMetal1 \$I33.$82.Metal2 0.0215051f
Cred_2616 \$I26.$2169.TopMetal1 \$I50 0.079274f
Cred_2617 \$I26.$2169.TopMetal1 rfin 0.0121895f
Cred_2618 \$I26.$2169.TopMetal1 vss 11.5546f
Cred_2619 \$I26.$2169.TopMetal1 vdd 1.74149f
Cred_2620 \$I26.$2169.TopMetal1 vdd.$2365.Metal1 0.00209682f
Cred_2621 \$I26.$2169.TopMetal1 vdd.$2370.Metal1 1.96499e-06f
Cred_2622 \$I26.$2169.TopMetal1 vdd.$2394.Metal1 1.96499e-06f
Cred_2623 \$I26.$2169.TopMetal1 vdd.$2399.Metal1 0.00209682f
Cred_2624 \$I26.$2169.TopMetal1 vdd.$2747.Metal2 0.00160394f
Cred_2625 \$I26.$2169.TopMetal1 vdd.$2749.Metal2 0.00130639f
Cred_2626 \$I26.$2169.TopMetal1 vdd.$2751.Metal2 0.000714399f
Cred_2627 \$I26.$2169.TopMetal1 vdd.$2755.Metal2 0.00155776f
Cred_2628 \$I26.$2169.TopMetal1 vdd.$2759.Metal2 0.00122203f
Cred_2629 \$I26.$2169.TopMetal1 vdd.$2761.Metal2 0.000505668f
Cred_2630 \$I26.$2169.TopMetal1 vdd.$2763.Metal2 0.000379412f
Cred_2631 \$I26.$2169.TopMetal1 vdd.$2765.Metal2 0.00134902f
Cred_2632 \$I26.$2169.TopMetal1 vdd.$2769.Metal2 0.00126433f
Cred_2633 \$I26.$2169.TopMetal1 vdd.$2771.Metal2 0.000463588f
Cred_2634 \$I26.$2169.TopMetal1 vdd.$2773.Metal2 0.00026768f
Cred_2635 \$I26.$2169.TopMetal1 vdd.$2775.Metal2 0.000829809f
Cred_2636 \$I26.$2169.TopMetal1 vdd.$2779.Metal2 0.000829809f
Cred_2637 \$I26.$2169.TopMetal1 vdd.$2781.Metal2 0.00026768f
Cred_2638 \$I26.$2169.TopMetal1 vdd.$2783.Metal2 0.000463588f
Cred_2639 \$I26.$2169.TopMetal1 vdd.$2785.Metal2 0.00126433f
Cred_2640 \$I26.$2169.TopMetal1 vdd.$2789.Metal2 0.00134902f
Cred_2641 \$I26.$2169.TopMetal1 vdd.$2791.Metal2 0.000379412f
Cred_2642 \$I26.$2169.TopMetal1 vdd.$2793.Metal2 0.000505668f
Cred_2643 \$I26.$2169.TopMetal1 vdd.$2795.Metal2 0.00122203f
Cred_2644 \$I26.$2169.TopMetal1 vdd.$2799.Metal2 0.00155776f
Cred_2645 \$I26.$2169.TopMetal1 vdd.$2803.Metal2 0.000714399f
Cred_2646 \$I26.$2169.TopMetal1 vdd.$2805.Metal2 0.00130639f
Cred_2647 \$I26.$2169.TopMetal1 vdd.$2807.Metal2 0.00160394f
Cred_2648 \$I26.$2169.TopMetal1 vdd.$2987.Metal3 1.96499e-06f
Cred_2649 \$I26.$2169.TopMetal1 vdd.$3035.Metal3 1.96499e-06f
Cred_2650 \$I26.$2169.TopMetal1 vdd.$3213.Metal4 6.21192e-09f
Cred_2651 \$I26.$2169.TopMetal1 vdd.$3215.Metal4 2.22032e-08f
Cred_2652 \$I26.$2169.TopMetal1 vdd.$3223.Metal4 1.19154e-07f
Cred_2653 \$I26.$2169.TopMetal1 vdd.$3231.Metal4 7.16435e-08f
Cred_2654 \$I26.$2169.TopMetal1 vdd.$3259.Metal4 7.16435e-08f
Cred_2655 \$I26.$2169.TopMetal1 vdd.$3267.Metal4 1.19154e-07f
Cred_2656 \$I26.$2169.TopMetal1 vdd.$3275.Metal4 2.22032e-08f
Cred_2657 \$I26.$2169.TopMetal1 vdd.$3277.Metal4 6.21192e-09f
Cred_2658 \$I26.$2169.TopMetal1 vdd.$3448.Metal5 8.1732e-06f
Cred_2659 \$I26.$2169.TopMetal1 vdd.$3450.Metal5 1.01056e-05f
Cred_2660 \$I26.$2169.TopMetal1 vdd.$3452.Metal5 7.31298e-05f
Cred_2661 \$I26.$2169.TopMetal1 vdd.$3454.Metal5 6.07619e-06f
Cred_2662 \$I26.$2169.TopMetal1 vdd.$3456.Metal5 7.7383e-05f
Cred_2663 \$I26.$2169.TopMetal1 vdd.$3459.Metal5 4.59364e-06f
Cred_2664 \$I26.$2169.TopMetal1 vdd.$3460.Metal5 8.95759e-05f
Cred_2665 \$I26.$2169.TopMetal1 vdd.$3462.Metal5 7.53343e-05f
Cred_2666 \$I26.$2169.TopMetal1 vdd.$3468.Metal5 7.7383e-05f
Cred_2667 \$I26.$2169.TopMetal1 vdd.$3470.Metal5 6.07619e-06f
Cred_2668 \$I26.$2169.TopMetal1 vdd.$3472.Metal5 7.31298e-05f
Cred_2669 \$I26.$2169.TopMetal1 vdd.$3474.Metal5 1.01056e-05f
Cred_2670 \$I26.$2169.TopMetal1 vdd.$3476.Metal5 8.1732e-06f
Cred_2671 \$I26.$2169.TopMetal1 vdd.$3480.Metal5 0.000236665f
Cred_2672 \$I26.$2169.TopMetal1 vdd.$3496.Metal5 0.000236665f
Cred_2673 \$I26.$2169.TopMetal1 vdd.$3615.TopMetal1 0.0615447f
Cred_2674 \$I26.$2169.TopMetal1 vdd.$3617.TopMetal1 0.0799359f
Cred_2675 \$I26.$2169.TopMetal1 vdd.$3619.TopMetal1 0.0824993f
Cred_2676 \$I26.$2169.TopMetal1 vdd.$3622.TopMetal1 0.04507f
Cred_2677 \$I26.$2169.TopMetal1 vdd.$3623.TopMetal1 0.0600114f
Cred_2678 \$I26.$2169.TopMetal1 vdd.$3625.TopMetal1 0.0799359f
Cred_2679 \$I26.$2169.TopMetal1 vdd.$3627.TopMetal1 0.0615447f
Cred_2680 \$I26.$2169.TopMetal1 vdd.$3700.TopMetal1 0.217564f
Cred_2681 \$I26.$2169.TopMetal1 vdd.$3707.TopMetal1 0.217564f
Cred_2682 \$I26.$2169.TopMetal1 vdd.$4071.TopMetal1 0.673958f
Cred_2683 \$I26.$2169.TopMetal1 vdd.$4456.TopMetal1 3.61416e-05f
Cred_2684 \$I26.$2169.TopMetal1 vdd.$4841.TopMetal1 1.93812e-09f
Cred_2685 \$I26.$2169.TopMetal1 vdd.$5226.TopMetal1 1.03939e-13f
Cred_2686 \$I26.$2169.TopMetal1 vdd.P0.GatPoly 0.00696241f
Cred_2687 \$I26.$2169.TopMetal1 vdd.P0.nSD 0.00358809f
Cred_2688 \$I26.$2169.TopMetal1 vdd.P0.pSD 0.000415859f
Cred_2689 \$I26.$2169.TopMetal1 vdd.P1.GatPoly 1.88352e-06f
Cred_2690 \$I26.$2169.TopMetal1 vdd.P1.pSD 0.000418924f
Cred_2691 \$I26.$2169.TopMetal1 vdd.P10.pSD 0.000418508f
Cred_2692 \$I26.$2169.TopMetal1 vdd.P11.pSD 0.000265622f
Cred_2693 \$I26.$2169.TopMetal1 vdd.P13.pSD 0.000265622f
Cred_2694 \$I26.$2169.TopMetal1 vdd.P15.pSD 0.000418508f
Cred_2695 \$I26.$2169.TopMetal1 vdd.P17.pSD 0.000417993f
Cred_2696 \$I26.$2169.TopMetal1 vdd.P19.pSD 0.000418728f
Cred_2697 \$I26.$2169.TopMetal1 vdd.P2.GatPoly 1.88352e-06f
Cred_2698 \$I26.$2169.TopMetal1 vdd.P21.pSD 0.000418087f
Cred_2699 \$I26.$2169.TopMetal1 vdd.P23.pSD 0.000418924f
Cred_2700 \$I26.$2169.TopMetal1 vdd.P25.pSD 0.000415859f
Cred_2701 \$I26.$2169.TopMetal1 vdd.P3.pSD 0.000418087f
Cred_2702 \$I26.$2169.TopMetal1 vdd.P5.pSD 0.000418728f
Cred_2703 \$I26.$2169.TopMetal1 vdd.P7.pSD 0.000417993f
Cred_2704 \$I26.$2169.TopMetal1 vout 0.0630552f
Cred_2705 \$I26.$2169.TopMetal1 vout.$1238.Metal4 0.00867843f
Cred_2706 \$I26.$2169.TopMetal1 vout.$1239.Metal4 0.00197416f
Cred_2707 \$I26.$2169.TopMetal1 vout.$1299.Metal4 0.00202691f
Cred_2708 \$I26.$2169.TopMetal1 vout.$1313.Metal4 1.05628e-06f
Cred_2709 \$I26.$2169.TopMetal1 vout.$1372.Metal4 0.0401842f
Cred_2710 \$I26.$2169.TopMetal1 vout.$1383.Metal4 0.00667715f
Cred_2711 \$I26.$2169.TopMetal1 vout.P0.GatPoly 9.89123e-06f
Cred_2712 \$I26.$2169.TopMetal1 vref 0.139684f
Cred_2713 \$I26.$2169.TopMetal1 vref.P0.GatPoly 0.00397716f
Cred_2714 \$I26.$2169.TopMetal1 vref.P0.nSD 0.0227347f
Cred_2715 \$I26.$2169.TopMetal1 vref.P0.pSD 0.0415898f
Cred_2716 \$I26.$2169.TopMetal1 vss 197.942f
Cred_2717 \$I26.$2169.TopMetal1 vss.$1033.Metal4 0.00476898f
Cred_2718 \$I26.$2169.TopMetal1 vss.$1037.Metal4 0.00476898f
Cred_2719 \$I26.$2169.TopMetal1 vss.$1212.Metal5 1.42339p
Cred_2720 \$I26.$2169.TopMetal1 vss.$1230.Metal5 709.103f
Cred_2721 \$I26.$2169.TopMetal1 vss.$1247.Metal5 19.9419f
Cred_2722 \$I26.$2169.TopMetal1 vss.$1282.Metal5 1.34603p
Cred_2723 \$I26.$2169.TopMetal1 vss.$1300.Metal5 893.291f
Cred_2724 \$I26.$2169.TopMetal1 vss.$825.Metal3 5.62303e-05f
Cred_2725 \$I26.P1.GatPoly \$I28 0.000278514f
Cred_2726 \$I26.P1.GatPoly \$I28.P0.Metal5 0.0282873f
Cred_2727 \$I26.P1.GatPoly \$I30 0.00309566f
Cred_2728 \$I26.P1.GatPoly \$I30.P0.Metal1 0.00540241f
Cred_2729 \$I26.P1.GatPoly \$I33 0.00107615f
Cred_2730 \$I26.P1.GatPoly \$I33.$82.Metal2 0.000107072f
Cred_2731 \$I26.P1.GatPoly \$I50 2.95116e-05f
Cred_2732 \$I26.P1.GatPoly rfin 0.0187476f
Cred_2733 \$I26.P1.GatPoly vss 0.928244f
Cred_2734 \$I26.P1.GatPoly vdd 0.000648309f
Cred_2735 \$I26.P1.GatPoly vdd.$2365.Metal1 7.8059e-07f
Cred_2736 \$I26.P1.GatPoly vdd.$2370.Metal1 7.31512e-10f
Cred_2737 \$I26.P1.GatPoly vdd.$2394.Metal1 7.31512e-10f
Cred_2738 \$I26.P1.GatPoly vdd.$2399.Metal1 7.8059e-07f
Cred_2739 \$I26.P1.GatPoly vdd.$2747.Metal2 5.97104e-07f
Cred_2740 \$I26.P1.GatPoly vdd.$2749.Metal2 4.86332e-07f
Cred_2741 \$I26.P1.GatPoly vdd.$2751.Metal2 2.65951e-07f
Cred_2742 \$I26.P1.GatPoly vdd.$2755.Metal2 5.79911e-07f
Cred_2743 \$I26.P1.GatPoly vdd.$2759.Metal2 4.54929e-07f
Cred_2744 \$I26.P1.GatPoly vdd.$2761.Metal2 1.88247e-07f
Cred_2745 \$I26.P1.GatPoly vdd.$2763.Metal2 1.41245e-07f
Cred_2746 \$I26.P1.GatPoly vdd.$2765.Metal2 5.02204e-07f
Cred_2747 \$I26.P1.GatPoly vdd.$2769.Metal2 4.70677e-07f
Cred_2748 \$I26.P1.GatPoly vdd.$2771.Metal2 1.72581e-07f
Cred_2749 \$I26.P1.GatPoly vdd.$2773.Metal2 9.96503e-08f
Cred_2750 \$I26.P1.GatPoly vdd.$2775.Metal2 3.08916e-07f
Cred_2751 \$I26.P1.GatPoly vdd.$2779.Metal2 3.08916e-07f
Cred_2752 \$I26.P1.GatPoly vdd.$2781.Metal2 9.96503e-08f
Cred_2753 \$I26.P1.GatPoly vdd.$2783.Metal2 1.72581e-07f
Cred_2754 \$I26.P1.GatPoly vdd.$2785.Metal2 4.70677e-07f
Cred_2755 \$I26.P1.GatPoly vdd.$2789.Metal2 5.02204e-07f
Cred_2756 \$I26.P1.GatPoly vdd.$2791.Metal2 1.41245e-07f
Cred_2757 \$I26.P1.GatPoly vdd.$2793.Metal2 1.88247e-07f
Cred_2758 \$I26.P1.GatPoly vdd.$2795.Metal2 4.54929e-07f
Cred_2759 \$I26.P1.GatPoly vdd.$2799.Metal2 5.79911e-07f
Cred_2760 \$I26.P1.GatPoly vdd.$2803.Metal2 2.65951e-07f
Cred_2761 \$I26.P1.GatPoly vdd.$2805.Metal2 4.86332e-07f
Cred_2762 \$I26.P1.GatPoly vdd.$2807.Metal2 5.97104e-07f
Cred_2763 \$I26.P1.GatPoly vdd.$2987.Metal3 7.31512e-10f
Cred_2764 \$I26.P1.GatPoly vdd.$3035.Metal3 7.31512e-10f
Cred_2765 \$I26.P1.GatPoly vdd.$3213.Metal4 2.31253e-12f
Cred_2766 \$I26.P1.GatPoly vdd.$3215.Metal4 8.26565e-12f
Cred_2767 \$I26.P1.GatPoly vdd.$3223.Metal4 4.43577e-11f
Cred_2768 \$I26.P1.GatPoly vdd.$3231.Metal4 2.66709e-11f
Cred_2769 \$I26.P1.GatPoly vdd.$3259.Metal4 2.66709e-11f
Cred_2770 \$I26.P1.GatPoly vdd.$3267.Metal4 4.43577e-11f
Cred_2771 \$I26.P1.GatPoly vdd.$3275.Metal4 8.26565e-12f
Cred_2772 \$I26.P1.GatPoly vdd.$3277.Metal4 2.31253e-12f
Cred_2773 \$I26.P1.GatPoly vdd.$3448.Metal5 3.04266e-09f
Cred_2774 \$I26.P1.GatPoly vdd.$3450.Metal5 3.76204e-09f
Cred_2775 \$I26.P1.GatPoly vdd.$3452.Metal5 2.72242e-08f
Cred_2776 \$I26.P1.GatPoly vdd.$3454.Metal5 2.262e-09f
Cred_2777 \$I26.P1.GatPoly vdd.$3456.Metal5 2.88076e-08f
Cred_2778 \$I26.P1.GatPoly vdd.$3459.Metal5 1.71009e-09f
Cred_2779 \$I26.P1.GatPoly vdd.$3460.Metal5 3.33467e-08f
Cred_2780 \$I26.P1.GatPoly vdd.$3462.Metal5 2.80449e-08f
Cred_2781 \$I26.P1.GatPoly vdd.$3468.Metal5 2.88076e-08f
Cred_2782 \$I26.P1.GatPoly vdd.$3470.Metal5 2.262e-09f
Cred_2783 \$I26.P1.GatPoly vdd.$3472.Metal5 2.72242e-08f
Cred_2784 \$I26.P1.GatPoly vdd.$3474.Metal5 3.76204e-09f
Cred_2785 \$I26.P1.GatPoly vdd.$3476.Metal5 3.04266e-09f
Cred_2786 \$I26.P1.GatPoly vdd.$3480.Metal5 8.8104e-08f
Cred_2787 \$I26.P1.GatPoly vdd.$3496.Metal5 8.8104e-08f
Cred_2788 \$I26.P1.GatPoly vdd.$3615.TopMetal1 2.29114e-05f
Cred_2789 \$I26.P1.GatPoly vdd.$3617.TopMetal1 2.9758e-05f
Cred_2790 \$I26.P1.GatPoly vdd.$3619.TopMetal1 3.07122e-05f
Cred_2791 \$I26.P1.GatPoly vdd.$3622.TopMetal1 1.67783e-05f
Cred_2792 \$I26.P1.GatPoly vdd.$3623.TopMetal1 2.23406e-05f
Cred_2793 \$I26.P1.GatPoly vdd.$3625.TopMetal1 2.9758e-05f
Cred_2794 \$I26.P1.GatPoly vdd.$3627.TopMetal1 2.29114e-05f
Cred_2795 \$I26.P1.GatPoly vdd.$3700.TopMetal1 8.09929e-05f
Cred_2796 \$I26.P1.GatPoly vdd.$3707.TopMetal1 8.09929e-05f
Cred_2797 \$I26.P1.GatPoly vdd.$4071.TopMetal1 0.00545946f
Cred_2798 \$I26.P1.GatPoly vdd.$4456.TopMetal1 2.92768e-07f
Cred_2799 \$I26.P1.GatPoly vdd.$4841.TopMetal1 1.56999e-11f
Cred_2800 \$I26.P1.GatPoly vdd.$5226.TopMetal1 8.41967e-16f
Cred_2801 \$I26.P1.GatPoly vdd.P0.GatPoly 0.00112728f
Cred_2802 \$I26.P1.GatPoly vdd.P0.nSD 1.33575e-06f
Cred_2803 \$I26.P1.GatPoly vdd.P0.pSD 1.54813e-07f
Cred_2804 \$I26.P1.GatPoly vdd.P1.GatPoly 7.01183e-10f
Cred_2805 \$I26.P1.GatPoly vdd.P1.pSD 1.55954e-07f
Cred_2806 \$I26.P1.GatPoly vdd.P10.pSD 1.55799e-07f
Cred_2807 \$I26.P1.GatPoly vdd.P11.pSD 9.88841e-08f
Cred_2808 \$I26.P1.GatPoly vdd.P13.pSD 9.88841e-08f
Cred_2809 \$I26.P1.GatPoly vdd.P15.pSD 1.55799e-07f
Cred_2810 \$I26.P1.GatPoly vdd.P17.pSD 1.55608e-07f
Cred_2811 \$I26.P1.GatPoly vdd.P19.pSD 1.55881e-07f
Cred_2812 \$I26.P1.GatPoly vdd.P2.GatPoly 7.01183e-10f
Cred_2813 \$I26.P1.GatPoly vdd.P21.pSD 1.55642e-07f
Cred_2814 \$I26.P1.GatPoly vdd.P23.pSD 1.55954e-07f
Cred_2815 \$I26.P1.GatPoly vdd.P25.pSD 1.54813e-07f
Cred_2816 \$I26.P1.GatPoly vdd.P3.pSD 1.55642e-07f
Cred_2817 \$I26.P1.GatPoly vdd.P5.pSD 1.55881e-07f
Cred_2818 \$I26.P1.GatPoly vdd.P7.pSD 1.55608e-07f
Cred_2819 \$I26.P1.GatPoly vout 2.05359e-05f
Cred_2820 \$I26.P1.GatPoly vout.$1238.Metal4 2.2707e-06f
Cred_2821 \$I26.P1.GatPoly vout.$1239.Metal4 5.16535e-07f
Cred_2822 \$I26.P1.GatPoly vout.$1299.Metal4 6.60125e-07f
Cred_2823 \$I26.P1.GatPoly vout.$1313.Metal4 3.44009e-10f
Cred_2824 \$I26.P1.GatPoly vout.$1372.Metal4 1.49595e-05f
Cred_2825 \$I26.P1.GatPoly vout.$1383.Metal4 2.48572e-06f
Cred_2826 \$I26.P1.GatPoly vout.P0.GatPoly 3.22139e-09f
Cred_2827 \$I26.P1.GatPoly vref 4.56615e-05f
Cred_2828 \$I26.P1.GatPoly vref.P0.GatPoly 1.30159e-06f
Cred_2829 \$I26.P1.GatPoly vref.P0.nSD 7.41956e-06f
Cred_2830 \$I26.P1.GatPoly vref.P0.pSD 1.37116e-05f
Cred_2831 \$I26.P1.GatPoly vss 0.0408262f
Cred_2832 \$I26.P1.GatPoly vss.$1033.Metal4 1.30972e-06f
Cred_2833 \$I26.P1.GatPoly vss.$1037.Metal4 1.30972e-06f
Cred_2834 \$I26.P1.GatPoly vss.$1212.Metal5 0.172342f
Cred_2835 \$I26.P1.GatPoly vss.$1230.Metal5 0.0961124f
Cred_2836 \$I26.P1.GatPoly vss.$1247.Metal5 0.00495432f
Cred_2837 \$I26.P1.GatPoly vss.$1282.Metal5 0.347837f
Cred_2838 \$I26.P1.GatPoly vss.$1300.Metal5 0.19423f
Cred_2839 \$I26.P1.GatPoly vss.$825.Metal3 1.54427e-08f
Cred_2840 \$I26.P2.GatPoly \$I28 0.00154489f
Cred_2841 \$I26.P2.GatPoly \$I28.P0.Metal5 0.0292356f
Cred_2842 \$I26.P2.GatPoly \$I30 0.00164069f
Cred_2843 \$I26.P2.GatPoly \$I30.P0.Metal1 0.00463441f
Cred_2844 \$I26.P2.GatPoly \$I33 0.000923166f
Cred_2845 \$I26.P2.GatPoly \$I33.$82.Metal2 9.18506e-05f
Cred_2846 \$I26.P2.GatPoly \$I50 2.53162e-05f
Cred_2847 \$I26.P2.GatPoly rfin 0.019734f
Cred_2848 \$I26.P2.GatPoly vss 0.843644f
Cred_2849 \$I26.P2.GatPoly vdd 0.000556146f
Cred_2850 \$I26.P2.GatPoly vdd.$2365.Metal1 6.69622e-07f
Cred_2851 \$I26.P2.GatPoly vdd.$2370.Metal1 6.27521e-10f
Cred_2852 \$I26.P2.GatPoly vdd.$2394.Metal1 6.27521e-10f
Cred_2853 \$I26.P2.GatPoly vdd.$2399.Metal1 6.69622e-07f
Cred_2854 \$I26.P2.GatPoly vdd.$2747.Metal2 5.1222e-07f
Cred_2855 \$I26.P2.GatPoly vdd.$2749.Metal2 4.17196e-07f
Cred_2856 \$I26.P2.GatPoly vdd.$2751.Metal2 2.28144e-07f
Cred_2857 \$I26.P2.GatPoly vdd.$2755.Metal2 4.97471e-07f
Cred_2858 \$I26.P2.GatPoly vdd.$2759.Metal2 3.90257e-07f
Cred_2859 \$I26.P2.GatPoly vdd.$2761.Metal2 1.61486e-07f
Cred_2860 \$I26.P2.GatPoly vdd.$2763.Metal2 1.21166e-07f
Cred_2861 \$I26.P2.GatPoly vdd.$2765.Metal2 4.30811e-07f
Cred_2862 \$I26.P2.GatPoly vdd.$2769.Metal2 4.03766e-07f
Cred_2863 \$I26.P2.GatPoly vdd.$2771.Metal2 1.48047e-07f
Cred_2864 \$I26.P2.GatPoly vdd.$2773.Metal2 8.54841e-08f
Cred_2865 \$I26.P2.GatPoly vdd.$2775.Metal2 2.65001e-07f
Cred_2866 \$I26.P2.GatPoly vdd.$2779.Metal2 2.65001e-07f
Cred_2867 \$I26.P2.GatPoly vdd.$2781.Metal2 8.54841e-08f
Cred_2868 \$I26.P2.GatPoly vdd.$2783.Metal2 1.48047e-07f
Cred_2869 \$I26.P2.GatPoly vdd.$2785.Metal2 4.03766e-07f
Cred_2870 \$I26.P2.GatPoly vdd.$2789.Metal2 4.30811e-07f
Cred_2871 \$I26.P2.GatPoly vdd.$2791.Metal2 1.21166e-07f
Cred_2872 \$I26.P2.GatPoly vdd.$2793.Metal2 1.61486e-07f
Cred_2873 \$I26.P2.GatPoly vdd.$2795.Metal2 3.90257e-07f
Cred_2874 \$I26.P2.GatPoly vdd.$2799.Metal2 4.97471e-07f
Cred_2875 \$I26.P2.GatPoly vdd.$2803.Metal2 2.28144e-07f
Cred_2876 \$I26.P2.GatPoly vdd.$2805.Metal2 4.17196e-07f
Cred_2877 \$I26.P2.GatPoly vdd.$2807.Metal2 5.1222e-07f
Cred_2878 \$I26.P2.GatPoly vdd.$2987.Metal3 6.27521e-10f
Cred_2879 \$I26.P2.GatPoly vdd.$3035.Metal3 6.27521e-10f
Cred_2880 \$I26.P2.GatPoly vdd.$3213.Metal4 1.98378e-12f
Cred_2881 \$I26.P2.GatPoly vdd.$3215.Metal4 7.09061e-12f
Cred_2882 \$I26.P2.GatPoly vdd.$3223.Metal4 3.80518e-11f
Cred_2883 \$I26.P2.GatPoly vdd.$3231.Metal4 2.28794e-11f
Cred_2884 \$I26.P2.GatPoly vdd.$3259.Metal4 2.28794e-11f
Cred_2885 \$I26.P2.GatPoly vdd.$3267.Metal4 3.80518e-11f
Cred_2886 \$I26.P2.GatPoly vdd.$3275.Metal4 7.09061e-12f
Cred_2887 \$I26.P2.GatPoly vdd.$3277.Metal4 1.98378e-12f
Cred_2888 \$I26.P2.GatPoly vdd.$3448.Metal5 2.61012e-09f
Cred_2889 \$I26.P2.GatPoly vdd.$3450.Metal5 3.22724e-09f
Cred_2890 \$I26.P2.GatPoly vdd.$3452.Metal5 2.33541e-08f
Cred_2891 \$I26.P2.GatPoly vdd.$3454.Metal5 1.94044e-09f
Cred_2892 \$I26.P2.GatPoly vdd.$3456.Metal5 2.47123e-08f
Cred_2893 \$I26.P2.GatPoly vdd.$3459.Metal5 1.46698e-09f
Cred_2894 \$I26.P2.GatPoly vdd.$3460.Metal5 2.86061e-08f
Cred_2895 \$I26.P2.GatPoly vdd.$3462.Metal5 2.40581e-08f
Cred_2896 \$I26.P2.GatPoly vdd.$3468.Metal5 2.47123e-08f
Cred_2897 \$I26.P2.GatPoly vdd.$3470.Metal5 1.94044e-09f
Cred_2898 \$I26.P2.GatPoly vdd.$3472.Metal5 2.33541e-08f
Cred_2899 \$I26.P2.GatPoly vdd.$3474.Metal5 3.22724e-09f
Cred_2900 \$I26.P2.GatPoly vdd.$3476.Metal5 2.61012e-09f
Cred_2901 \$I26.P2.GatPoly vdd.$3480.Metal5 7.55792e-08f
Cred_2902 \$I26.P2.GatPoly vdd.$3496.Metal5 7.55792e-08f
Cred_2903 \$I26.P2.GatPoly vdd.$3615.TopMetal1 1.96543e-05f
Cred_2904 \$I26.P2.GatPoly vdd.$3617.TopMetal1 2.55276e-05f
Cred_2905 \$I26.P2.GatPoly vdd.$3619.TopMetal1 2.63462e-05f
Cred_2906 \$I26.P2.GatPoly vdd.$3622.TopMetal1 1.43931e-05f
Cred_2907 \$I26.P2.GatPoly vdd.$3623.TopMetal1 1.91647e-05f
Cred_2908 \$I26.P2.GatPoly vdd.$3625.TopMetal1 2.55276e-05f
Cred_2909 \$I26.P2.GatPoly vdd.$3627.TopMetal1 1.96543e-05f
Cred_2910 \$I26.P2.GatPoly vdd.$3700.TopMetal1 6.9479e-05f
Cred_2911 \$I26.P2.GatPoly vdd.$3707.TopMetal1 6.9479e-05f
Cred_2912 \$I26.P2.GatPoly vdd.$4071.TopMetal1 0.00468335f
Cred_2913 \$I26.P2.GatPoly vdd.$4456.TopMetal1 2.51148e-07f
Cred_2914 \$I26.P2.GatPoly vdd.$4841.TopMetal1 1.3468e-11f
Cred_2915 \$I26.P2.GatPoly vdd.$5226.TopMetal1 7.22274e-16f
Cred_2916 \$I26.P2.GatPoly vdd.P0.GatPoly 0.000967026f
Cred_2917 \$I26.P2.GatPoly vdd.P0.nSD 1.14586e-06f
Cred_2918 \$I26.P2.GatPoly vdd.P0.pSD 1.32805e-07f
Cred_2919 \$I26.P2.GatPoly vdd.P1.GatPoly 6.01504e-10f
Cred_2920 \$I26.P2.GatPoly vdd.P1.pSD 1.33784e-07f
Cred_2921 \$I26.P2.GatPoly vdd.P10.pSD 1.33651e-07f
Cred_2922 \$I26.P2.GatPoly vdd.P11.pSD 8.48268e-08f
Cred_2923 \$I26.P2.GatPoly vdd.P13.pSD 8.48268e-08f
Cred_2924 \$I26.P2.GatPoly vdd.P15.pSD 1.33651e-07f
Cred_2925 \$I26.P2.GatPoly vdd.P17.pSD 1.33487e-07f
Cred_2926 \$I26.P2.GatPoly vdd.P19.pSD 1.33721e-07f
Cred_2927 \$I26.P2.GatPoly vdd.P2.GatPoly 6.01504e-10f
Cred_2928 \$I26.P2.GatPoly vdd.P21.pSD 1.33516e-07f
Cred_2929 \$I26.P2.GatPoly vdd.P23.pSD 1.33784e-07f
Cred_2930 \$I26.P2.GatPoly vdd.P25.pSD 1.32805e-07f
Cred_2931 \$I26.P2.GatPoly vdd.P3.pSD 1.33516e-07f
Cred_2932 \$I26.P2.GatPoly vdd.P5.pSD 1.33721e-07f
Cred_2933 \$I26.P2.GatPoly vdd.P7.pSD 1.33487e-07f
Cred_2934 \$I26.P2.GatPoly vout 1.76165e-05f
Cred_2935 \$I26.P2.GatPoly vout.$1238.Metal4 1.94789e-06f
Cred_2936 \$I26.P2.GatPoly vout.$1239.Metal4 4.43104e-07f
Cred_2937 \$I26.P2.GatPoly vout.$1299.Metal4 5.66282e-07f
Cred_2938 \$I26.P2.GatPoly vout.$1313.Metal4 2.95105e-10f
Cred_2939 \$I26.P2.GatPoly vout.$1372.Metal4 1.28329e-05f
Cred_2940 \$I26.P2.GatPoly vout.$1383.Metal4 2.13236e-06f
Cred_2941 \$I26.P2.GatPoly vout.P0.GatPoly 2.76344e-09f
Cred_2942 \$I26.P2.GatPoly vref 3.91703e-05f
Cred_2943 \$I26.P2.GatPoly vref.P0.GatPoly 1.11655e-06f
Cred_2944 \$I26.P2.GatPoly vref.P0.nSD 6.3648e-06f
Cred_2945 \$I26.P2.GatPoly vref.P0.pSD 1.17623e-05f
Cred_2946 \$I26.P2.GatPoly vss 0.0350224f
Cred_2947 \$I26.P2.GatPoly vss.$1033.Metal4 1.12353e-06f
Cred_2948 \$I26.P2.GatPoly vss.$1037.Metal4 1.12353e-06f
Cred_2949 \$I26.P2.GatPoly vss.$1212.Metal5 0.147842f
Cred_2950 \$I26.P2.GatPoly vss.$1230.Metal5 0.0824491f
Cred_2951 \$I26.P2.GatPoly vss.$1247.Metal5 0.00425002f
Cred_2952 \$I26.P2.GatPoly vss.$1282.Metal5 0.298389f
Cred_2953 \$I26.P2.GatPoly vss.$1300.Metal5 0.166618f
Cred_2954 \$I26.P2.GatPoly vss.$825.Metal3 1.32474e-08f
Cred_2955 \$I28 \$I28.P0.Metal5 0.011165f
Cred_2956 \$I28 \$I30 0.00117376f
Cred_2957 \$I28 \$I30.P0.Metal1 0.00453798f
Cred_2958 \$I28 \$I33 1.19397e-05f
Cred_2959 \$I28 \$I33.$82.Metal2 3.72558e-07f
Cred_2960 \$I28 rfin 0.0302534f
Cred_2961 \$I28 vss 0.273119f
Cred_2962 \$I28.P0.Metal5 \$I30 0.0381769f
Cred_2963 \$I28.P0.Metal5 \$I30.P0.Metal1 0.154662f
Cred_2964 \$I28.P0.Metal5 \$I33 0.0852715f
Cred_2965 \$I28.P0.Metal5 \$I33.$82.Metal2 0.00477776f
Cred_2966 \$I28.P0.Metal5 rfin 152.664f
Cred_2967 \$I28.P0.Metal5 vss 2.9881f
Cred_2968 \$I30 \$I30.P0.Metal1 0.00369928f
Cred_2969 \$I30 \$I33 0.0334664f
Cred_2970 \$I30 \$I33.$82.Metal2 0.000795407f
Cred_2971 \$I30 rfin 0.01518f
Cred_2972 \$I30 vss 0.262374f
Cred_2973 \$I30.P0.Metal1 \$I33 0.282692f
Cred_2974 \$I30.P0.Metal1 \$I33.$82.Metal2 0.00442781f
Cred_2975 \$I30.P0.Metal1 rfin 0.0711189f
Cred_2976 \$I30.P0.Metal1 vss 0.652956f
Cred_2977 \$I33 \$I33.$82.Metal2 0.00110237f
Cred_2978 \$I33 rfin 0.0349537f
Cred_2979 \$I33 vss 2.00445f
Cred_2980 \$I33 vss.$1282.Metal5 0.187146f
Cred_2981 \$I33.$82.Metal2 \$I50 0.298049f
Cred_2982 \$I33.$82.Metal2 rfin 0.00148323f
Cred_2983 \$I33.$82.Metal2 vss 2.25518f
Cred_2984 \$I33.$82.Metal2 vdd.$2365.Metal1 0.00321052f
Cred_2985 \$I33.$82.Metal2 vdd.$2399.Metal1 0.000976182f
Cred_2986 \$I33.$82.Metal2 vdd.$2769.Metal2 0.000631483f
Cred_2987 \$I33.$82.Metal2 vdd.$2771.Metal2 0.000231544f
Cred_2988 \$I33.$82.Metal2 vdd.$2773.Metal2 0.00133961f
Cred_2989 \$I33.$82.Metal2 vdd.$2775.Metal2 0.00415279f
Cred_2990 \$I33.$82.Metal2 vdd.$2779.Metal2 0.00349984f
Cred_2991 \$I33.$82.Metal2 vdd.$2781.Metal2 0.00112898f
Cred_2992 \$I33.$82.Metal2 vdd.P0.nSD 0.123857f
Cred_2993 \$I33.$82.Metal2 vdd.P1.GatPoly 0.000539086f
Cred_2994 \$I33.$82.Metal2 vdd.P10.pSD 0.000700819f
Cred_2995 \$I33.$82.Metal2 vdd.P11.pSD 0.0101298f
Cred_2996 \$I33.$82.Metal2 vdd.P13.pSD 0.00942955f
Cred_2997 \$I33.$82.Metal2 vdd.P2.GatPoly 4.34191e-05f
Cred_2998 \$I33.$82.Metal2 vout 0.0744487f
Cred_2999 \$I33.$82.Metal2 vout.$1038.Metal3 9.27155e-05f
Cred_3000 \$I33.$82.Metal2 vout.$1040.Metal3 4.64135e-05f
Cred_3001 \$I33.$82.Metal2 vout.$1237.Metal4 0.00305712f
Cred_3002 \$I33.$82.Metal2 vout.$1238.Metal4 0.00146524f
Cred_3003 \$I33.$82.Metal2 vout.$1239.Metal4 0.00146302f
Cred_3004 \$I33.$82.Metal2 vout.$124.Metal1 2.44233e-05f
Cred_3005 \$I33.$82.Metal2 vout.$125.Metal1 2.42723e-05f
Cred_3006 \$I33.$82.Metal2 vout.$126.Metal1 2.42574e-05f
Cred_3007 \$I33.$82.Metal2 vout.$127.Metal1 2.27698e-05f
Cred_3008 \$I33.$82.Metal2 vout.$1299.Metal4 0.0481958f
Cred_3009 \$I33.$82.Metal2 vout.$1313.Metal4 0.01193f
Cred_3010 \$I33.$82.Metal2 vout.$1331.Metal4 0.00151172f
Cred_3011 \$I33.$82.Metal2 vout.$1332.Metal4 5.52786e-06f
Cred_3012 \$I33.$82.Metal2 vout.$159.Metal1 2.30832e-05f
Cred_3013 \$I33.$82.Metal2 vout.$160.Metal1 5.73424e-05f
Cred_3014 \$I33.$82.Metal2 vout.$502.Metal2 3.74651e-06f
Cred_3015 \$I33.$82.Metal2 vout.$504.Metal2 3.96452e-07f
Cred_3016 \$I33.$82.Metal2 vout.$522.Metal2 0.00123466f
Cred_3017 \$I33.$82.Metal2 vout.$524.Metal2 0.00122089f
Cred_3018 \$I33.$82.Metal2 vout.$526.Metal2 0.00121934f
Cred_3019 \$I33.$82.Metal2 vout.$528.Metal2 0.00114456f
Cred_3020 \$I33.$82.Metal2 vout.$590.Metal2 0.00116277f
Cred_3021 \$I33.$82.Metal2 vout.$592.Metal2 0.00288097f
Cred_3022 \$I33.$82.Metal2 vout.$610.Metal2 1.85843e-06f
Cred_3023 \$I33.$82.Metal2 vout.$612.Metal2 9.30333e-07f
Cred_3024 \$I33.$82.Metal2 vout.$890.Metal3 0.00018691f
Cred_3025 \$I33.$82.Metal2 vout.$892.Metal3 1.97786e-05f
Cred_3026 \$I33.$82.Metal2 vout.$934.Metal3 2.34989e-05f
Cred_3027 \$I33.$82.Metal2 vout.$936.Metal3 2.20578e-05f
Cred_3028 \$I33.$82.Metal2 vout.P0.GatPoly 0.00558299f
Cred_3029 \$I33.$82.Metal2 vref 0.34256f
Cred_3030 \$I33.$82.Metal2 vref.P0.GatPoly 0.023564f
Cred_3031 \$I33.$82.Metal2 vref.P0.nSD 0.0419982f
Cred_3032 \$I33.$82.Metal2 vref.P0.pSD 0.0764666f
Cred_3033 \$I33.$82.Metal2 vss 0.00135058f
Cred_3034 \$I33.$82.Metal2 vss.$1212.Metal5 0.00139286f
Cred_3035 \$I33.$82.Metal2 vss.$1230.Metal5 0.00139286f
Cred_3036 \$I33.$82.Metal2 vss.$127.Metal1 0.00468839f
Cred_3037 \$I33.$82.Metal2 vss.$1282.Metal5 0.763281f
Cred_3038 \$I33.$82.Metal2 vss.$1300.Metal5 0.0312733f
Cred_3039 \$I33.$82.Metal2 vss.$141.Metal1 5.16879e-06f
Cred_3040 \$I33.$82.Metal2 vss.$146.Metal1 1.4675e-06f
Cred_3041 \$I33.$82.Metal2 vss.$406.Metal1 0.0144152f
Cred_3042 \$I33.$82.Metal2 vss.$457.Metal2 6.84732e-05f
Cred_3043 \$I33.$82.Metal2 vss.$483.Metal2 0.00073196f
Cred_3044 \$I33.$82.Metal2 vss.$485.Metal2 0.000706758f
Cred_3045 \$I33.$82.Metal2 vss.$489.Metal2 0.00318833f
Cred_3046 \$I33.$82.Metal2 vss.$493.Metal2 0.00275059f
Cred_3047 \$I33.$82.Metal2 vss.$495.Metal2 0.00101175f
Cred_3048 \$I33.$82.Metal2 vss.$499.Metal2 0.000811342f
Cred_3049 \$I33.$82.Metal2 vss.$821.Metal3 5.16879e-06f
Cred_3050 \$I33.$82.Metal2 vss.$831.Metal3 1.4675e-06f
Cred_3051 \$I33.$82.Metal2 vss.P0.GatPoly 0.000542515f
Cred_3052 \$I33.$82.Metal2 vss.P0.pSD 0.102924f
Cred_3053 \$I33.$82.Metal2 vss.P10.nSD 0.000267217f
Cred_3054 \$I33.$82.Metal2 vss.P11.nSD 0.00479512f
Cred_3055 \$I33.$82.Metal2 vss.P13.nSD 0.00479428f
Cred_3056 \$I33.$82.Metal2 vss.P15.nSD 0.000251093f
Cred_3057 \$I33.P0.GatPoly \$I50 0.000234292f
Cred_3058 \$I33.P0.GatPoly vss 0.172011f
Cred_3059 \$I33.P0.GatPoly vout 0.00610467f
Cred_3060 \$I33.P0.GatPoly vout.$1237.Metal4 1.79033e-07f
Cred_3061 \$I33.P0.GatPoly vout.$1238.Metal4 0.000118015f
Cred_3062 \$I33.P0.GatPoly vout.$1239.Metal4 0.000117836f
Cred_3063 \$I33.P0.GatPoly vout.$124.Metal1 1.95496e-06f
Cred_3064 \$I33.P0.GatPoly vout.$125.Metal1 1.95496e-06f
Cred_3065 \$I33.P0.GatPoly vout.$126.Metal1 1.95376e-06f
Cred_3066 \$I33.P0.GatPoly vout.$127.Metal1 3.46313e-06f
Cred_3067 \$I33.P0.GatPoly vout.$1299.Metal4 0.00521745f
Cred_3068 \$I33.P0.GatPoly vout.$1313.Metal4 8.35665e-05f
Cred_3069 \$I33.P0.GatPoly vout.$502.Metal2 3.19314e-08f
Cred_3070 \$I33.P0.GatPoly vout.$504.Metal2 3.19314e-08f
Cred_3071 \$I33.P0.GatPoly vout.$522.Metal2 9.83343e-05f
Cred_3072 \$I33.P0.GatPoly vout.$524.Metal2 9.83343e-05f
Cred_3073 \$I33.P0.GatPoly vout.$526.Metal2 9.82089e-05f
Cred_3074 \$I33.P0.GatPoly vout.$528.Metal2 0.00017408f
Cred_3075 \$I33.P0.GatPoly vout.$890.Metal3 1.59303e-06f
Cred_3076 \$I33.P0.GatPoly vout.$892.Metal3 1.59303e-06f
Cred_3077 \$I33.P0.GatPoly vout.$934.Metal3 1.89267e-06f
Cred_3078 \$I33.P0.GatPoly vout.$936.Metal3 3.35484e-06f
Cred_3079 \$I33.P0.GatPoly vout.P0.GatPoly 0.00385928f
Cred_3080 \$I33.P0.GatPoly vref 0.0453161f
Cred_3081 \$I33.P0.GatPoly vref.P0.GatPoly 0.00558367f
Cred_3082 \$I33.P0.GatPoly vref.P0.nSD 0.00276307f
Cred_3083 \$I33.P0.GatPoly vref.P0.pSD 0.00216894f
Cred_3084 \$I33.P0.GatPoly vss 8.99634e-05f
Cred_3085 \$I33.P0.GatPoly vss.$1212.Metal5 9.278e-05f
Cred_3086 \$I33.P0.GatPoly vss.$1230.Metal5 9.278e-05f
Cred_3087 \$I33.P0.GatPoly vss.$127.Metal1 0.000193913f
Cred_3088 \$I33.P0.GatPoly vss.$1282.Metal5 0.00565709f
Cred_3089 \$I33.P0.GatPoly vss.$1300.Metal5 0.00180714f
Cred_3090 \$I33.P0.GatPoly vss.$141.Metal1 4.1631e-07f
Cred_3091 \$I33.P0.GatPoly vss.$146.Metal1 2.23196e-07f
Cred_3092 \$I33.P0.GatPoly vss.$406.Metal1 0.0014414f
Cred_3093 \$I33.P0.GatPoly vss.$457.Metal2 2.83208e-06f
Cred_3094 \$I33.P0.GatPoly vss.$483.Metal2 5.89542e-05f
Cred_3095 \$I33.P0.GatPoly vss.$485.Metal2 5.69244e-05f
Cred_3096 \$I33.P0.GatPoly vss.$489.Metal2 0.000256798f
Cred_3097 \$I33.P0.GatPoly vss.$493.Metal2 0.000221541f
Cred_3098 \$I33.P0.GatPoly vss.$495.Metal2 9.03944e-05f
Cred_3099 \$I33.P0.GatPoly vss.$499.Metal2 0.000123399f
Cred_3100 \$I33.P0.GatPoly vss.$821.Metal3 4.1631e-07f
Cred_3101 \$I33.P0.GatPoly vss.$831.Metal3 2.23196e-07f
Cred_3102 \$I33.P0.GatPoly vss.P0.GatPoly 6.93259e-06f
Cred_3103 \$I33.P0.GatPoly vss.P0.pSD 0.00858683f
Cred_3104 \$I33.P0.GatPoly vss.P10.nSD 2.15225e-05f
Cred_3105 \$I33.P0.GatPoly vss.P11.nSD 0.000386213f
Cred_3106 \$I33.P0.GatPoly vss.P13.nSD 0.000386145f
Cred_3107 \$I33.P0.GatPoly vss.P15.nSD 3.81895e-05f
Cred_3108 \$I33.P1.GatPoly \$I50 0.0194399f
Cred_3109 \$I33.P1.GatPoly vss 0.000909913f
Cred_3110 \$I33.P1.GatPoly vdd.$2365.Metal1 8.97145e-06f
Cred_3111 \$I33.P1.GatPoly vdd.$2379.Metal1 0.000499874f
Cred_3112 \$I33.P1.GatPoly vdd.$2382.Metal1 0.00100858f
Cred_3113 \$I33.P1.GatPoly vdd.$2399.Metal1 8.25296e-06f
Cred_3114 \$I33.P1.GatPoly vdd.$2769.Metal2 4.53811e-06f
Cred_3115 \$I33.P1.GatPoly vdd.$2771.Metal2 1.66397e-06f
Cred_3116 \$I33.P1.GatPoly vdd.$2773.Metal2 0.0048113f
Cred_3117 \$I33.P1.GatPoly vdd.$2775.Metal2 0.0175839f
Cred_3118 \$I33.P1.GatPoly vdd.$2779.Metal2 2.39574e-05f
Cred_3119 \$I33.P1.GatPoly vdd.$2781.Metal2 7.72818e-06f
Cred_3120 \$I33.P1.GatPoly vdd.$3007.Metal3 0.0085956f
Cred_3121 \$I33.P1.GatPoly vdd.$3011.Metal3 0.0085956f
Cred_3122 \$I33.P1.GatPoly vdd.$3243.Metal4 0.000101349f
Cred_3123 \$I33.P1.GatPoly vdd.P0.nSD 0.000908518f
Cred_3124 \$I33.P1.GatPoly vdd.P1.GatPoly 3.99037e-07f
Cred_3125 \$I33.P1.GatPoly vdd.P10.pSD 5.03639e-06f
Cred_3126 \$I33.P1.GatPoly vdd.P11.pSD 0.0278914f
Cred_3127 \$I33.P1.GatPoly vdd.P13.pSD 6.45479e-05f
Cred_3128 \$I33.P1.GatPoly vdd.P2.GatPoly 3.67079e-07f
Cred_3129 \$I33.P1.GatPoly vout 0.000157018f
Cred_3130 \$I33.P1.GatPoly vout.$1040.Metal3 3.33548e-07f
Cred_3131 \$I33.P1.GatPoly vout.$1299.Metal4 1.89077e-09f
Cred_3132 \$I33.P1.GatPoly vout.$1313.Metal4 7.51652e-05f
Cred_3133 \$I33.P1.GatPoly vout.$1332.Metal4 3.97256e-08f
Cred_3134 \$I33.P1.GatPoly vout.$1372.Metal4 0.0159061f
Cred_3135 \$I33.P1.GatPoly vout.$160.Metal1 4.12087e-07f
Cred_3136 \$I33.P1.GatPoly vout.$592.Metal2 2.07039e-05f
Cred_3137 \$I33.P1.GatPoly vout.$612.Metal2 6.68577e-09f
Cred_3138 \$I33.P1.GatPoly vout.P0.GatPoly 2.46309e-08f
Cred_3139 \$I33.P1.GatPoly vref 0.0056546f
Cred_3140 \$I33.P1.GatPoly vref.P0.GatPoly 0.000220498f
Cred_3141 \$I33.P1.GatPoly vref.P0.nSD 0.00126404f
Cred_3142 \$I33.P1.GatPoly vref.P0.pSD 0.0426361f
Cred_3143 \$I33.P1.GatPoly vss 3.88862e-06f
Cred_3144 \$I33.P1.GatPoly vss.$1212.Metal5 4.01036e-06f
Cred_3145 \$I33.P1.GatPoly vss.$1230.Metal5 4.01036e-06f
Cred_3146 \$I33.P1.GatPoly vss.$1282.Metal5 0.0020183f
Cred_3147 \$I33.P1.GatPoly vss.$1300.Metal5 5.39951e-05f
Cred_3148 \$I33.P2.GatPoly \$I50 0.0194315f
Cred_3149 \$I33.P2.GatPoly vss 0.000886359f
Cred_3150 \$I33.P2.GatPoly vdd.$2365.Metal1 8.28287e-06f
Cred_3151 \$I33.P2.GatPoly vdd.$2382.Metal1 0.00100858f
Cred_3152 \$I33.P2.GatPoly vdd.$2385.Metal1 0.000499874f
Cred_3153 \$I33.P2.GatPoly vdd.$2399.Metal1 8.29624e-06f
Cred_3154 \$I33.P2.GatPoly vdd.$2769.Metal2 4.32268e-06f
Cred_3155 \$I33.P2.GatPoly vdd.$2771.Metal2 1.58498e-06f
Cred_3156 \$I33.P2.GatPoly vdd.$2773.Metal2 9.16999e-06f
Cred_3157 \$I33.P2.GatPoly vdd.$2775.Metal2 2.8427e-05f
Cred_3158 \$I33.P2.GatPoly vdd.$2779.Metal2 0.0175791f
Cred_3159 \$I33.P2.GatPoly vdd.$2781.Metal2 0.00480978f
Cred_3160 \$I33.P2.GatPoly vdd.$3011.Metal3 0.0085956f
Cred_3161 \$I33.P2.GatPoly vdd.$3015.Metal3 0.0085956f
Cred_3162 \$I33.P2.GatPoly vdd.$3247.Metal4 0.000101349f
Cred_3163 \$I33.P2.GatPoly vdd.P0.nSD 0.000869842f
Cred_3164 \$I33.P2.GatPoly vdd.P1.GatPoly 3.6841e-07f
Cred_3165 \$I33.P2.GatPoly vdd.P10.pSD 4.7973e-06f
Cred_3166 \$I33.P2.GatPoly vdd.P11.pSD 6.93414e-05f
Cred_3167 \$I33.P2.GatPoly vdd.P13.pSD 0.0278863f
Cred_3168 \$I33.P2.GatPoly vdd.P2.GatPoly 3.69004e-07f
Cred_3169 \$I33.P2.GatPoly vout 0.000164844f
Cred_3170 \$I33.P2.GatPoly vout.$1040.Metal3 3.17713e-07f
Cred_3171 \$I33.P2.GatPoly vout.$1299.Metal4 1.985e-09f
Cred_3172 \$I33.P2.GatPoly vout.$1313.Metal4 7.89113e-05f
Cred_3173 \$I33.P2.GatPoly vout.$1332.Metal4 3.78397e-08f
Cred_3174 \$I33.P2.GatPoly vout.$1373.Metal4 0.00152956f
Cred_3175 \$I33.P2.GatPoly vout.$1383.Metal4 0.0133547f
Cred_3176 \$I33.P2.GatPoly vout.$160.Metal1 3.92524e-07f
Cred_3177 \$I33.P2.GatPoly vout.$592.Metal2 1.97211e-05f
Cred_3178 \$I33.P2.GatPoly vout.$612.Metal2 6.36838e-09f
Cred_3179 \$I33.P2.GatPoly vout.P0.GatPoly 2.58585e-08f
Cred_3180 \$I33.P2.GatPoly vref 0.00565234f
Cred_3181 \$I33.P2.GatPoly vref.P0.GatPoly 0.00022041f
Cred_3182 \$I33.P2.GatPoly vref.P0.nSD 0.00126354f
Cred_3183 \$I33.P2.GatPoly vref.P0.pSD 0.0426346f
Cred_3184 \$I33.P2.GatPoly vss 4.08242e-06f
Cred_3185 \$I33.P2.GatPoly vss.$1212.Metal5 4.21023e-06f
Cred_3186 \$I33.P2.GatPoly vss.$1230.Metal5 4.21023e-06f
Cred_3187 \$I33.P2.GatPoly vss.$1282.Metal5 0.000342232f
Cred_3188 \$I33.P2.GatPoly vss.$1300.Metal5 0.00171727f
Cred_3189 \$I33.P3.GatPoly \$I50 1.52003e-05f
Cred_3190 \$I33.P3.GatPoly vss 0.025967f
Cred_3191 \$I33.P3.GatPoly vout 0.000267754f
Cred_3192 \$I33.P3.GatPoly vout.$1237.Metal4 1.63039e-08f
Cred_3193 \$I33.P3.GatPoly vout.$1238.Metal4 0.00855415f
Cred_3194 \$I33.P3.GatPoly vout.$1239.Metal4 1.6509e-05f
Cred_3195 \$I33.P3.GatPoly vout.$124.Metal1 1.78031e-07f
Cred_3196 \$I33.P3.GatPoly vout.$125.Metal1 1.78031e-07f
Cred_3197 \$I33.P3.GatPoly vout.$126.Metal1 1.77922e-07f
Cred_3198 \$I33.P3.GatPoly vout.$127.Metal1 1.67011e-07f
Cred_3199 \$I33.P3.GatPoly vout.$1299.Metal4 0.000393223f
Cred_3200 \$I33.P3.GatPoly vout.$1313.Metal4 3.12516e-06f
Cred_3201 \$I33.P3.GatPoly vout.$502.Metal2 2.90788e-09f
Cred_3202 \$I33.P3.GatPoly vout.$504.Metal2 2.90788e-09f
Cred_3203 \$I33.P3.GatPoly vout.$522.Metal2 8.95496e-06f
Cred_3204 \$I33.P3.GatPoly vout.$524.Metal2 8.95496e-06f
Cred_3205 \$I33.P3.GatPoly vout.$526.Metal2 8.94354e-06f
Cred_3206 \$I33.P3.GatPoly vout.$528.Metal2 8.39509e-06f
Cred_3207 \$I33.P3.GatPoly vout.$890.Metal3 1.45072e-07f
Cred_3208 \$I33.P3.GatPoly vout.$892.Metal3 1.45072e-07f
Cred_3209 \$I33.P3.GatPoly vout.$934.Metal3 1.72359e-07f
Cred_3210 \$I33.P3.GatPoly vout.$936.Metal3 1.61789e-07f
Cred_3211 \$I33.P3.GatPoly vout.P0.GatPoly 4.09063e-05f
Cred_3212 \$I33.P3.GatPoly vref 0.00506538f
Cred_3213 \$I33.P3.GatPoly vref.P0.GatPoly 0.0002574f
Cred_3214 \$I33.P3.GatPoly vref.P0.nSD 0.0217834f
Cred_3215 \$I33.P3.GatPoly vref.P0.pSD 0.00134875f
Cred_3216 \$I33.P3.GatPoly vss 6.48469e-06f
Cred_3217 \$I33.P3.GatPoly vss.$1033.Metal4 1.00288e-05f
Cred_3218 \$I33.P3.GatPoly vss.$1212.Metal5 6.68771e-06f
Cred_3219 \$I33.P3.GatPoly vss.$1230.Metal5 6.68771e-06f
Cred_3220 \$I33.P3.GatPoly vss.$127.Metal1 3.03833e-05f
Cred_3221 \$I33.P3.GatPoly vss.$1282.Metal5 0.000543291f
Cred_3222 \$I33.P3.GatPoly vss.$1300.Metal5 0.000165569f
Cred_3223 \$I33.P3.GatPoly vss.$141.Metal1 0.000542936f
Cred_3224 \$I33.P3.GatPoly vss.$143.Metal1 0.000516265f
Cred_3225 \$I33.P3.GatPoly vss.$146.Metal1 1.07638e-08f
Cred_3226 \$I33.P3.GatPoly vss.$406.Metal1 0.000181353f
Cred_3227 \$I33.P3.GatPoly vss.$457.Metal2 4.43743e-07f
Cred_3228 \$I33.P3.GatPoly vss.$483.Metal2 5.36875e-06f
Cred_3229 \$I33.P3.GatPoly vss.$485.Metal2 0.00226957f
Cred_3230 \$I33.P3.GatPoly vss.$489.Metal2 0.0190041f
Cred_3231 \$I33.P3.GatPoly vss.$493.Metal2 2.80507e-05f
Cred_3232 \$I33.P3.GatPoly vss.$495.Metal2 9.96151e-06f
Cred_3233 \$I33.P3.GatPoly vss.$499.Metal2 5.951e-06f
Cred_3234 \$I33.P3.GatPoly vss.$821.Metal3 0.000877298f
Cred_3235 \$I33.P3.GatPoly vss.$825.Metal3 0.000850561f
Cred_3236 \$I33.P3.GatPoly vss.$831.Metal3 1.07638e-08f
Cred_3237 \$I33.P3.GatPoly vss.P0.GatPoly 1.08623e-06f
Cred_3238 \$I33.P3.GatPoly vss.P0.pSD 0.00124536f
Cred_3239 \$I33.P3.GatPoly vss.P10.nSD 1.95998e-06f
Cred_3240 \$I33.P3.GatPoly vss.P11.nSD 0.0161298f
Cred_3241 \$I33.P3.GatPoly vss.P13.nSD 5.30445e-05f
Cred_3242 \$I33.P3.GatPoly vss.P15.nSD 1.84171e-06f
Cred_3243 \$I33.P4.GatPoly \$I50 1.52003e-05f
Cred_3244 \$I33.P4.GatPoly vss 0.0259436f
Cred_3245 \$I33.P4.GatPoly vout 0.000267754f
Cred_3246 \$I33.P4.GatPoly vout.$1237.Metal4 1.63039e-08f
Cred_3247 \$I33.P4.GatPoly vout.$1238.Metal4 1.65253e-05f
Cred_3248 \$I33.P4.GatPoly vout.$1239.Metal4 0.00786123f
Cred_3249 \$I33.P4.GatPoly vout.$124.Metal1 1.78031e-07f
Cred_3250 \$I33.P4.GatPoly vout.$125.Metal1 1.78031e-07f
Cred_3251 \$I33.P4.GatPoly vout.$126.Metal1 1.77922e-07f
Cred_3252 \$I33.P4.GatPoly vout.$127.Metal1 1.67011e-07f
Cred_3253 \$I33.P4.GatPoly vout.$1299.Metal4 0.000399818f
Cred_3254 \$I33.P4.GatPoly vout.$1313.Metal4 3.12516e-06f
Cred_3255 \$I33.P4.GatPoly vout.$502.Metal2 2.90788e-09f
Cred_3256 \$I33.P4.GatPoly vout.$504.Metal2 2.90788e-09f
Cred_3257 \$I33.P4.GatPoly vout.$522.Metal2 8.95496e-06f
Cred_3258 \$I33.P4.GatPoly vout.$524.Metal2 8.95496e-06f
Cred_3259 \$I33.P4.GatPoly vout.$526.Metal2 8.94354e-06f
Cred_3260 \$I33.P4.GatPoly vout.$528.Metal2 8.39509e-06f
Cred_3261 \$I33.P4.GatPoly vout.$890.Metal3 1.45072e-07f
Cred_3262 \$I33.P4.GatPoly vout.$892.Metal3 1.45072e-07f
Cred_3263 \$I33.P4.GatPoly vout.$934.Metal3 1.72359e-07f
Cred_3264 \$I33.P4.GatPoly vout.$936.Metal3 1.61789e-07f
Cred_3265 \$I33.P4.GatPoly vout.P0.GatPoly 4.09063e-05f
Cred_3266 \$I33.P4.GatPoly vref 0.00506565f
Cred_3267 \$I33.P4.GatPoly vref.P0.GatPoly 0.000257411f
Cred_3268 \$I33.P4.GatPoly vref.P0.nSD 0.0217828f
Cred_3269 \$I33.P4.GatPoly vref.P0.pSD 0.00134886f
Cred_3270 \$I33.P4.GatPoly vss 6.60594e-06f
Cred_3271 \$I33.P4.GatPoly vss.$1037.Metal4 1.00288e-05f
Cred_3272 \$I33.P4.GatPoly vss.$1212.Metal5 6.81276e-06f
Cred_3273 \$I33.P4.GatPoly vss.$1230.Metal5 6.81276e-06f
Cred_3274 \$I33.P4.GatPoly vss.$127.Metal1 2.78726e-05f
Cred_3275 \$I33.P4.GatPoly vss.$1282.Metal5 0.000536989f
Cred_3276 \$I33.P4.GatPoly vss.$1300.Metal5 0.000167307f
Cred_3277 \$I33.P4.GatPoly vss.$141.Metal1 5.27116e-08f
Cred_3278 \$I33.P4.GatPoly vss.$143.Metal1 0.00068437f
Cred_3279 \$I33.P4.GatPoly vss.$146.Metal1 0.000339167f
Cred_3280 \$I33.P4.GatPoly vss.$406.Metal1 0.000183797f
Cred_3281 \$I33.P4.GatPoly vss.$457.Metal2 4.07075e-07f
Cred_3282 \$I33.P4.GatPoly vss.$483.Metal2 5.36875e-06f
Cred_3283 \$I33.P4.GatPoly vss.$485.Metal2 6.4391e-06f
Cred_3284 \$I33.P4.GatPoly vss.$489.Metal2 3.25148e-05f
Cred_3285 \$I33.P4.GatPoly vss.$493.Metal2 0.0167422f
Cred_3286 \$I33.P4.GatPoly vss.$495.Metal2 0.0045956f
Cred_3287 \$I33.P4.GatPoly vss.$499.Metal2 5.951e-06f
Cred_3288 \$I33.P4.GatPoly vss.$821.Metal3 5.27116e-08f
Cred_3289 \$I33.P4.GatPoly vss.$825.Metal3 0.000850561f
Cred_3290 \$I33.P4.GatPoly vss.$829.Metal3 0.000850561f
Cred_3291 \$I33.P4.GatPoly vss.$831.Metal3 1.07638e-08f
Cred_3292 \$I33.P4.GatPoly vss.P0.GatPoly 9.96472e-07f
Cred_3293 \$I33.P4.GatPoly vss.P0.pSD 0.00118953f
Cred_3294 \$I33.P4.GatPoly vss.P10.nSD 1.95998e-06f
Cred_3295 \$I33.P4.GatPoly vss.P11.nSD 5.3053e-05f
Cred_3296 \$I33.P4.GatPoly vss.P13.nSD 0.0161254f
Cred_3297 \$I33.P4.GatPoly vss.P15.nSD 1.84171e-06f
Cred_3298 \$I50 vdd 0.00651666f
Cred_3299 \$I50 vdd.$2365.Metal1 0.226157f
Cred_3300 \$I50 vdd.$2367.Metal1 0.0531722f
Cred_3301 \$I50 vdd.$2370.Metal1 0.0485438f
Cred_3302 \$I50 vdd.$2372.Metal1 0.0485639f
Cred_3303 \$I50 vdd.$2375.Metal1 0.048472f
Cred_3304 \$I50 vdd.$2377.Metal1 0.0392495f
Cred_3305 \$I50 vdd.$2379.Metal1 0.0480502f
Cred_3306 \$I50 vdd.$2382.Metal1 0.059258f
Cred_3307 \$I50 vdd.$2385.Metal1 0.0480502f
Cred_3308 \$I50 vdd.$2387.Metal1 0.0392495f
Cred_3309 \$I50 vdd.$2389.Metal1 0.048472f
Cred_3310 \$I50 vdd.$2392.Metal1 0.0485639f
Cred_3311 \$I50 vdd.$2394.Metal1 0.0485438f
Cred_3312 \$I50 vdd.$2397.Metal1 0.0531722f
Cred_3313 \$I50 vdd.$2399.Metal1 0.224696f
Cred_3314 \$I50 vdd.$2745.Metal2 0.0370236f
Cred_3315 \$I50 vdd.$2747.Metal2 0.170596f
Cred_3316 \$I50 vdd.$2749.Metal2 0.0354883f
Cred_3317 \$I50 vdd.$2751.Metal2 0.019716f
Cred_3318 \$I50 vdd.$2755.Metal2 0.0397833f
Cred_3319 \$I50 vdd.$2759.Metal2 0.0309527f
Cred_3320 \$I50 vdd.$2761.Metal2 0.0152239f
Cred_3321 \$I50 vdd.$2763.Metal2 0.0126807f
Cred_3322 \$I50 vdd.$2765.Metal2 0.0303187f
Cred_3323 \$I50 vdd.$2767.Metal2 0.00571749f
Cred_3324 \$I50 vdd.$2769.Metal2 0.0287598f
Cred_3325 \$I50 vdd.$2771.Metal2 0.0142104f
Cred_3326 \$I50 vdd.$2773.Metal2 0.0138018f
Cred_3327 \$I50 vdd.$2775.Metal2 0.0331033f
Cred_3328 \$I50 vdd.$2779.Metal2 0.0331033f
Cred_3329 \$I50 vdd.$2781.Metal2 0.0138018f
Cred_3330 \$I50 vdd.$2783.Metal2 0.0142104f
Cred_3331 \$I50 vdd.$2785.Metal2 0.0287598f
Cred_3332 \$I50 vdd.$2787.Metal2 0.00571749f
Cred_3333 \$I50 vdd.$2789.Metal2 0.0303187f
Cred_3334 \$I50 vdd.$2791.Metal2 0.0126807f
Cred_3335 \$I50 vdd.$2793.Metal2 0.0152239f
Cred_3336 \$I50 vdd.$2795.Metal2 0.0309527f
Cred_3337 \$I50 vdd.$2799.Metal2 0.0397833f
Cred_3338 \$I50 vdd.$2803.Metal2 0.019716f
Cred_3339 \$I50 vdd.$2805.Metal2 0.0354883f
Cred_3340 \$I50 vdd.$2807.Metal2 0.170596f
Cred_3341 \$I50 vdd.$2809.Metal2 0.0370236f
Cred_3342 \$I50 vdd.$2979.Metal3 0.032783f
Cred_3343 \$I50 vdd.$2983.Metal3 0.0058187f
Cred_3344 \$I50 vdd.$2987.Metal3 0.00664693f
Cred_3345 \$I50 vdd.$2991.Metal3 0.00592911f
Cred_3346 \$I50 vdd.$2995.Metal3 0.00654429f
Cred_3347 \$I50 vdd.$2999.Metal3 0.00568951f
Cred_3348 \$I50 vdd.$3003.Metal3 0.0057741f
Cred_3349 \$I50 vdd.$3007.Metal3 0.00639397f
Cred_3350 \$I50 vdd.$3011.Metal3 0.00606442f
Cred_3351 \$I50 vdd.$3015.Metal3 0.00639397f
Cred_3352 \$I50 vdd.$3019.Metal3 0.0057741f
Cred_3353 \$I50 vdd.$3023.Metal3 0.00568951f
Cred_3354 \$I50 vdd.$3027.Metal3 0.00654429f
Cred_3355 \$I50 vdd.$3031.Metal3 0.00592911f
Cred_3356 \$I50 vdd.$3035.Metal3 0.00664693f
Cred_3357 \$I50 vdd.$3039.Metal3 0.0058187f
Cred_3358 \$I50 vdd.$3043.Metal3 0.032783f
Cred_3359 \$I50 vdd.$3213.Metal4 0.0274656f
Cred_3360 \$I50 vdd.$3215.Metal4 0.00409572f
Cred_3361 \$I50 vdd.$3219.Metal4 0.00543774f
Cred_3362 \$I50 vdd.$3223.Metal4 0.00429919f
Cred_3363 \$I50 vdd.$3227.Metal4 0.00445979f
Cred_3364 \$I50 vdd.$3231.Metal4 0.00508558f
Cred_3365 \$I50 vdd.$3235.Metal4 0.00383229f
Cred_3366 \$I50 vdd.$3237.Metal4 0.00143529f
Cred_3367 \$I50 vdd.$3239.Metal4 0.00430599f
Cred_3368 \$I50 vdd.$3243.Metal4 0.00431754f
Cred_3369 \$I50 vdd.$3247.Metal4 0.00431754f
Cred_3370 \$I50 vdd.$3251.Metal4 0.00430599f
Cred_3371 \$I50 vdd.$3253.Metal4 0.00143529f
Cred_3372 \$I50 vdd.$3255.Metal4 0.00383229f
Cred_3373 \$I50 vdd.$3259.Metal4 0.00508558f
Cred_3374 \$I50 vdd.$3263.Metal4 0.00445979f
Cred_3375 \$I50 vdd.$3267.Metal4 0.00429919f
Cred_3376 \$I50 vdd.$3271.Metal4 0.00543774f
Cred_3377 \$I50 vdd.$3275.Metal4 0.00409572f
Cred_3378 \$I50 vdd.$3277.Metal4 0.0274656f
Cred_3379 \$I50 vdd.$3448.Metal5 0.0027564f
Cred_3380 \$I50 vdd.$3450.Metal5 0.00354145f
Cred_3381 \$I50 vdd.$3452.Metal5 0.00308364f
Cred_3382 \$I50 vdd.$3454.Metal5 0.00401014f
Cred_3383 \$I50 vdd.$3456.Metal5 0.00420167f
Cred_3384 \$I50 vdd.$3459.Metal5 0.00381285f
Cred_3385 \$I50 vdd.$3460.Metal5 0.00227597f
Cred_3386 \$I50 vdd.$3462.Metal5 0.00275862f
Cred_3387 \$I50 vdd.$3464.Metal5 0.0022559f
Cred_3388 \$I50 vdd.$3465.Metal5 0.00381182f
Cred_3389 \$I50 vdd.$3468.Metal5 0.00420167f
Cred_3390 \$I50 vdd.$3470.Metal5 0.00401014f
Cred_3391 \$I50 vdd.$3472.Metal5 0.00308364f
Cred_3392 \$I50 vdd.$3474.Metal5 0.00354145f
Cred_3393 \$I50 vdd.$3476.Metal5 0.0027564f
Cred_3394 \$I50 vdd.$3480.Metal5 0.010366f
Cred_3395 \$I50 vdd.$3496.Metal5 0.010366f
Cred_3396 \$I50 vdd.$3615.TopMetal1 0.00826799f
Cred_3397 \$I50 vdd.$3617.TopMetal1 0.00924218f
Cred_3398 \$I50 vdd.$3619.TopMetal1 0.0117317f
Cred_3399 \$I50 vdd.$3622.TopMetal1 0.0100973f
Cred_3400 \$I50 vdd.$3623.TopMetal1 0.00669361f
Cred_3401 \$I50 vdd.$3625.TopMetal1 0.00924218f
Cred_3402 \$I50 vdd.$3627.TopMetal1 0.00826799f
Cred_3403 \$I50 vdd.$3700.TopMetal1 0.0346734f
Cred_3404 \$I50 vdd.$3707.TopMetal1 0.0346734f
Cred_3405 \$I50 vdd.$4071.TopMetal1 0.00650333f
Cred_3406 \$I50 vdd.$4456.TopMetal1 3.48746e-07f
Cred_3407 \$I50 vdd.$4841.TopMetal1 1.87018e-11f
Cred_3408 \$I50 vdd.$5226.TopMetal1 1.00295e-15f
Cred_3409 \$I50 vdd.P0.GatPoly 1.36841e-05f
Cred_3410 \$I50 vdd.P0.nSD 1.46947f
Cred_3411 \$I50 vdd.P0.pSD 0.140487f
Cred_3412 \$I50 vdd.P1.GatPoly 0.0312535f
Cred_3413 \$I50 vdd.P1.pSD 0.0114923f
Cred_3414 \$I50 vdd.P10.pSD 0.0121631f
Cred_3415 \$I50 vdd.P11.pSD 0.0127094f
Cred_3416 \$I50 vdd.P13.pSD 0.0127094f
Cred_3417 \$I50 vdd.P15.pSD 0.0121631f
Cred_3418 \$I50 vdd.P17.pSD 0.0121529f
Cred_3419 \$I50 vdd.P19.pSD 0.0121674f
Cred_3420 \$I50 vdd.P2.GatPoly 0.0309219f
Cred_3421 \$I50 vdd.P21.pSD 0.0121607f
Cred_3422 \$I50 vdd.P23.pSD 0.0114923f
Cred_3423 \$I50 vdd.P25.pSD 0.140487f
Cred_3424 \$I50 vdd.P3.pSD 0.0121607f
Cred_3425 \$I50 vdd.P5.pSD 0.0121674f
Cred_3426 \$I50 vdd.P7.pSD 0.0121529f
Cred_3427 \$I50 vout 0.0140084f
Cred_3428 \$I50 vout.$1002.Metal3 7.14418e-05f
Cred_3429 \$I50 vout.$1004.Metal3 7.14418e-05f
Cred_3430 \$I50 vout.$1006.Metal3 7.14418e-05f
Cred_3431 \$I50 vout.$1008.Metal3 7.14418e-05f
Cred_3432 \$I50 vout.$1010.Metal3 0.012433f
Cred_3433 \$I50 vout.$1032.Metal3 0.0211103f
Cred_3434 \$I50 vout.$1034.Metal3 0.00011303f
Cred_3435 \$I50 vout.$1036.Metal3 5.97978e-05f
Cred_3436 \$I50 vout.$1038.Metal3 0.00011303f
Cred_3437 \$I50 vout.$1040.Metal3 0.00011303f
Cred_3438 \$I50 vout.$1050.Metal3 0.0076185f
Cred_3439 \$I50 vout.$1070.Metal3 0.0076185f
Cred_3440 \$I50 vout.$1072.Metal3 0.0103398f
Cred_3441 \$I50 vout.$1110.Metal3 0.0101245f
Cred_3442 \$I50 vout.$1112.Metal3 0.0103217f
Cred_3443 \$I50 vout.$1150.Metal3 0.0101245f
Cred_3444 \$I50 vout.$1152.Metal3 0.0217394f
Cred_3445 \$I50 vout.$1154.Metal3 0.0016762f
Cred_3446 \$I50 vout.$1156.Metal3 0.0016762f
Cred_3447 \$I50 vout.$1158.Metal3 0.0016762f
Cred_3448 \$I50 vout.$1162.Metal3 0.00188645f
Cred_3449 \$I50 vout.$1164.Metal3 0.0016762f
Cred_3450 \$I50 vout.$1166.Metal3 0.0016762f
Cred_3451 \$I50 vout.$1180.Metal3 0.00209902f
Cred_3452 \$I50 vout.$1190.Metal3 0.0182111f
Cred_3453 \$I50 vout.$1208.Metal3 0.00213862f
Cred_3454 \$I50 vout.$1299.Metal4 7.04428e-05f
Cred_3455 \$I50 vout.$1313.Metal4 0.0660178f
Cred_3456 \$I50 vout.$1323.Metal4 0.00445595f
Cred_3457 \$I50 vout.$1328.Metal4 0.021109f
Cred_3458 \$I50 vout.$1329.Metal4 0.00109159f
Cred_3459 \$I50 vout.$1330.Metal4 7.12194e-06f
Cred_3460 \$I50 vout.$1331.Metal4 0.00109159f
Cred_3461 \$I50 vout.$1332.Metal4 0.00109159f
Cred_3462 \$I50 vout.$1333.Metal4 0.00450618f
Cred_3463 \$I50 vout.$1343.Metal4 0.00445595f
Cred_3464 \$I50 vout.$1353.Metal4 0.00445595f
Cred_3465 \$I50 vout.$1363.Metal4 0.00450618f
Cred_3466 \$I50 vout.$1368.Metal4 0.0169777f
Cred_3467 \$I50 vout.$1369.Metal4 0.00738447f
Cred_3468 \$I50 vout.$1370.Metal4 0.00714111f
Cred_3469 \$I50 vout.$1371.Metal4 0.0070482f
Cred_3470 \$I50 vout.$1372.Metal4 0.0109907f
Cred_3471 \$I50 vout.$1373.Metal4 0.00528052f
Cred_3472 \$I50 vout.$1383.Metal4 0.00986046f
Cred_3473 \$I50 vout.$1384.Metal4 0.00450618f
Cred_3474 \$I50 vout.$1394.Metal4 0.0065599f
Cred_3475 \$I50 vout.$1395.Metal4 0.00445595f
Cred_3476 \$I50 vout.$1405.Metal4 0.00450618f
Cred_3477 \$I50 vout.$1408.Metal4 0.0255166f
Cred_3478 \$I50 vout.$1415.Metal4 0.0128229f
Cred_3479 \$I50 vout.$1416.Metal4 0.0170582f
Cred_3480 \$I50 vout.$156.Metal1 0.00697422f
Cred_3481 \$I50 vout.$157.Metal1 0.00696427f
Cred_3482 \$I50 vout.$158.Metal1 0.00696422f
Cred_3483 \$I50 vout.$159.Metal1 0.00696427f
Cred_3484 \$I50 vout.$160.Metal1 0.00696427f
Cred_3485 \$I50 vout.$161.Metal1 0.00696417f
Cred_3486 \$I50 vout.$162.Metal1 0.00696417f
Cred_3487 \$I50 vout.$163.Metal1 0.00696417f
Cred_3488 \$I50 vout.$164.Metal1 0.00696417f
Cred_3489 \$I50 vout.$165.Metal1 0.00696599f
Cred_3490 \$I50 vout.$396.Metal1 0.00640439f
Cred_3491 \$I50 vout.$397.Metal1 0.00639538f
Cred_3492 \$I50 vout.$398.Metal1 0.00639538f
Cred_3493 \$I50 vout.$399.Metal1 0.00639538f
Cred_3494 \$I50 vout.$400.Metal1 0.00639499f
Cred_3495 \$I50 vout.$401.Metal1 0.00639563f
Cred_3496 \$I50 vout.$402.Metal1 0.00639538f
Cred_3497 \$I50 vout.$403.Metal1 0.00639538f
Cred_3498 \$I50 vout.$404.Metal1 0.00639414f
Cred_3499 \$I50 vout.$405.Metal1 0.00639968f
Cred_3500 \$I50 vout.$584.Metal2 0.00465185f
Cred_3501 \$I50 vout.$586.Metal2 0.00371677f
Cred_3502 \$I50 vout.$588.Metal2 0.00371177f
Cred_3503 \$I50 vout.$590.Metal2 0.00371677f
Cred_3504 \$I50 vout.$592.Metal2 0.00371677f
Cred_3505 \$I50 vout.$594.Metal2 0.00370706f
Cred_3506 \$I50 vout.$596.Metal2 0.00370706f
Cred_3507 \$I50 vout.$598.Metal2 0.00370706f
Cred_3508 \$I50 vout.$600.Metal2 0.00370706f
Cred_3509 \$I50 vout.$602.Metal2 0.00379847f
Cred_3510 \$I50 vout.$604.Metal2 0.000266121f
Cred_3511 \$I50 vout.$606.Metal2 2.26563e-06f
Cred_3512 \$I50 vout.$608.Metal2 1.19861e-06f
Cred_3513 \$I50 vout.$610.Metal2 2.26563e-06f
Cred_3514 \$I50 vout.$612.Metal2 2.26563e-06f
Cred_3515 \$I50 vout.$622.Metal2 5.02316e-05f
Cred_3516 \$I50 vout.$644.Metal2 5.19372e-05f
Cred_3517 \$I50 vout.$682.Metal2 5.02316e-05f
Cred_3518 \$I50 vout.$684.Metal2 5.02316e-05f
Cred_3519 \$I50 vout.$722.Metal2 5.02316e-05f
Cred_3520 \$I50 vout.$724.Metal2 5.17461e-05f
Cred_3521 \$I50 vout.$762.Metal2 5.02316e-05f
Cred_3522 \$I50 vout.$764.Metal2 0.000280525f
Cred_3523 \$I50 vout.$766.Metal2 3.35984e-05f
Cred_3524 \$I50 vout.$768.Metal2 3.35984e-05f
Cred_3525 \$I50 vout.$770.Metal2 3.35984e-05f
Cred_3526 \$I50 vout.$774.Metal2 3.78128e-05f
Cred_3527 \$I50 vout.$776.Metal2 3.35984e-05f
Cred_3528 \$I50 vout.$778.Metal2 3.35984e-05f
Cred_3529 \$I50 vout.$784.Metal2 0.00381883f
Cred_3530 \$I50 vout.$786.Metal2 0.00296528f
Cred_3531 \$I50 vout.$788.Metal2 0.00296528f
Cred_3532 \$I50 vout.$790.Metal2 0.00296528f
Cred_3533 \$I50 vout.$792.Metal2 0.00291919f
Cred_3534 \$I50 vout.$794.Metal2 0.00298669f
Cred_3535 \$I50 vout.$796.Metal2 0.00296528f
Cred_3536 \$I50 vout.$798.Metal2 0.00296528f
Cred_3537 \$I50 vout.$800.Metal2 0.00283455f
Cred_3538 \$I50 vout.$802.Metal2 0.00332515f
Cred_3539 \$I50 vout.P0.GatPoly 0.00318961f
Cred_3540 \$I50 vref 0.0550582f
Cred_3541 \$I50 vref.P0.GatPoly 0.00109437f
Cred_3542 \$I50 vref.P0.nSD 0.00488444f
Cred_3543 \$I50 vref.P0.pSD 0.0241093f
Cred_3544 \$I50 vss 0.0185415f
Cred_3545 \$I50 vss.$1033.Metal4 7.2996e-06f
Cred_3546 \$I50 vss.$1037.Metal4 7.2996e-06f
Cred_3547 \$I50 vss.$1212.Metal5 0.019122f
Cred_3548 \$I50 vss.$1230.Metal5 0.019122f
Cred_3549 \$I50 vss.$1247.Metal5 0.00191604f
Cred_3550 \$I50 vss.$1282.Metal5 0.315179f
Cred_3551 \$I50 vss.$1300.Metal5 0.0791883f
Cred_3552 \$I50 vss.$825.Metal3 8.60685e-08f
Cred_3553 rfin vss 3.08333f
Cred_3554 vss vdd 0.782489f
Cred_3555 vss vdd.$2365.Metal1 0.170733f
Cred_3556 vss vdd.$2367.Metal1 0.0407542f
Cred_3557 vss vdd.$2370.Metal1 0.0408384f
Cred_3558 vss vdd.$2372.Metal1 0.0408373f
Cred_3559 vss vdd.$2375.Metal1 0.040754f
Cred_3560 vss vdd.$2377.Metal1 0.0327464f
Cred_3561 vss vdd.$2379.Metal1 0.0407564f
Cred_3562 vss vdd.$2382.Metal1 0.0488504f
Cred_3563 vss vdd.$2385.Metal1 0.0407564f
Cred_3564 vss vdd.$2387.Metal1 0.0327464f
Cred_3565 vss vdd.$2389.Metal1 0.040754f
Cred_3566 vss vdd.$2392.Metal1 0.0408373f
Cred_3567 vss vdd.$2394.Metal1 0.0408389f
Cred_3568 vss vdd.$2397.Metal1 0.0407542f
Cred_3569 vss vdd.$2399.Metal1 0.172547f
Cred_3570 vss vdd.$2745.Metal2 0.0451267f
Cred_3571 vss vdd.$2747.Metal2 0.0719182f
Cred_3572 vss vdd.$2749.Metal2 0.0197673f
Cred_3573 vss vdd.$2751.Metal2 0.0220432f
Cred_3574 vss vdd.$2755.Metal2 0.0294806f
Cred_3575 vss vdd.$2759.Metal2 0.022362f
Cred_3576 vss vdd.$2761.Metal2 0.014799f
Cred_3577 vss vdd.$2763.Metal2 0.014559f
Cred_3578 vss vdd.$2765.Metal2 0.0152091f
Cred_3579 vss vdd.$2767.Metal2 0.0143219f
Cred_3580 vss vdd.$2769.Metal2 0.0143661f
Cred_3581 vss vdd.$2771.Metal2 0.0143219f
Cred_3582 vss vdd.$2773.Metal2 0.0144831f
Cred_3583 vss vdd.$2775.Metal2 0.0215985f
Cred_3584 vss vdd.$2779.Metal2 0.0227048f
Cred_3585 vss vdd.$2781.Metal2 0.01484f
Cred_3586 vss vdd.$2783.Metal2 0.0147144f
Cred_3587 vss vdd.$2785.Metal2 0.0154366f
Cred_3588 vss vdd.$2787.Metal2 0.0143219f
Cred_3589 vss vdd.$2789.Metal2 0.0155541f
Cred_3590 vss vdd.$2791.Metal2 0.014656f
Cred_3591 vss vdd.$2793.Metal2 0.0149284f
Cred_3592 vss vdd.$2795.Metal2 0.0226745f
Cred_3593 vss vdd.$2799.Metal2 0.0298791f
Cred_3594 vss vdd.$2803.Metal2 0.0222259f
Cred_3595 vss vdd.$2805.Metal2 0.020069f
Cred_3596 vss vdd.$2807.Metal2 0.0719182f
Cred_3597 vss vdd.$2809.Metal2 0.0451267f
Cred_3598 vss vdd.$2979.Metal3 0.050192f
Cred_3599 vss vdd.$2983.Metal3 0.0256026f
Cred_3600 vss vdd.$2987.Metal3 0.0256868f
Cred_3601 vss vdd.$2991.Metal3 0.0256856f
Cred_3602 vss vdd.$2995.Metal3 0.0256026f
Cred_3603 vss vdd.$2999.Metal3 0.0256026f
Cred_3604 vss vdd.$3003.Metal3 0.0255332f
Cred_3605 vss vdd.$3007.Metal3 0.0256026f
Cred_3606 vss vdd.$3011.Metal3 0.0256856f
Cred_3607 vss vdd.$3015.Metal3 0.0256026f
Cred_3608 vss vdd.$3019.Metal3 0.0255332f
Cred_3609 vss vdd.$3023.Metal3 0.0256026f
Cred_3610 vss vdd.$3027.Metal3 0.0256026f
Cred_3611 vss vdd.$3031.Metal3 0.0256856f
Cred_3612 vss vdd.$3035.Metal3 0.0256873f
Cred_3613 vss vdd.$3039.Metal3 0.0256026f
Cred_3614 vss vdd.$3043.Metal3 0.050192f
Cred_3615 vss vdd.$3213.Metal4 0.0419281f
Cred_3616 vss vdd.$3215.Metal4 0.0178983f
Cred_3617 vss vdd.$3219.Metal4 0.0237791f
Cred_3618 vss vdd.$3223.Metal4 0.0237791f
Cred_3619 vss vdd.$3227.Metal4 0.0237791f
Cred_3620 vss vdd.$3231.Metal4 0.0237791f
Cred_3621 vss vdd.$3235.Metal4 0.0179053f
Cred_3622 vss vdd.$3237.Metal4 0.0119426f
Cred_3623 vss vdd.$3239.Metal4 0.017877f
Cred_3624 vss vdd.$3243.Metal4 0.0238309f
Cred_3625 vss vdd.$3247.Metal4 0.0238309f
Cred_3626 vss vdd.$3251.Metal4 0.017877f
Cred_3627 vss vdd.$3253.Metal4 0.0119426f
Cred_3628 vss vdd.$3255.Metal4 0.0179053f
Cred_3629 vss vdd.$3259.Metal4 0.0237791f
Cred_3630 vss vdd.$3263.Metal4 0.0237791f
Cred_3631 vss vdd.$3267.Metal4 0.0237791f
Cred_3632 vss vdd.$3271.Metal4 0.0237791f
Cred_3633 vss vdd.$3275.Metal4 0.0178983f
Cred_3634 vss vdd.$3277.Metal4 0.0419281f
Cred_3635 vss vdd.$3448.Metal5 0.00552209f
Cred_3636 vss vdd.$3450.Metal5 0.004932f
Cred_3637 vss vdd.$3452.Metal5 0.00494275f
Cred_3638 vss vdd.$3454.Metal5 0.00493316f
Cred_3639 vss vdd.$3456.Metal5 0.00613036f
Cred_3640 vss vdd.$3459.Metal5 0.00483274f
Cred_3641 vss vdd.$3460.Metal5 0.0113299f
Cred_3642 vss vdd.$3462.Metal5 0.022675f
Cred_3643 vss vdd.$3464.Metal5 0.0112415f
Cred_3644 vss vdd.$3465.Metal5 0.0048282f
Cred_3645 vss vdd.$3468.Metal5 0.00613036f
Cred_3646 vss vdd.$3470.Metal5 0.00493316f
Cred_3647 vss vdd.$3472.Metal5 0.00494275f
Cred_3648 vss vdd.$3474.Metal5 0.004932f
Cred_3649 vss vdd.$3476.Metal5 0.00552209f
Cred_3650 vss vdd.$3480.Metal5 0.0173627f
Cred_3651 vss vdd.$3496.Metal5 0.0173627f
Cred_3652 vss vdd.$3615.TopMetal1 0.0400916f
Cred_3653 vss vdd.$3617.TopMetal1 0.012503f
Cred_3654 vss vdd.$3619.TopMetal1 0.031613f
Cred_3655 vss vdd.$3622.TopMetal1 0.0444897f
Cred_3656 vss vdd.$3623.TopMetal1 0.0094146f
Cred_3657 vss vdd.$3625.TopMetal1 0.012503f
Cred_3658 vss vdd.$3627.TopMetal1 0.0400916f
Cred_3659 vss vdd.$3700.TopMetal1 0.331865f
Cred_3660 vss vdd.$3707.TopMetal1 0.331865f
Cred_3661 vss vdd.$4071.TopMetal1 3.14732f
Cred_3662 vss vdd.$4456.TopMetal1 1.59956f
Cred_3663 vss vdd.$4841.TopMetal1 1.59958f
Cred_3664 vss vdd.$5226.TopMetal1 3.50106f
Cred_3665 vss vdd.P0.GatPoly 0.320707f
Cred_3666 vss vdd.P0.nSD 1.16473f
Cred_3667 vss vdd.P0.pSD 0.0259894f
Cred_3668 vss vdd.P1.GatPoly 0.00438898f
Cred_3669 vss vdd.P1.pSD 0.000877011f
Cred_3670 vss vdd.P13.pSD 0.00118783f
Cred_3671 vss vdd.P15.pSD 0.00118804f
Cred_3672 vss vdd.P17.pSD 0.00123519f
Cred_3673 vss vdd.P19.pSD 0.00123584f
Cred_3674 vss vdd.P2.GatPoly 0.0048244f
Cred_3675 vss vdd.P21.pSD 0.00125165f
Cred_3676 vss vdd.P23.pSD 0.00123601f
Cred_3677 vss vdd.P25.pSD 0.0259894f
Cred_3678 vss vdd.P3.pSD 0.000892857f
Cred_3679 vss vdd.P5.pSD 0.000876889f
Cred_3680 vss vdd.P7.pSD 0.00087643f
Cred_3681 vss vout 0.298759f
Cred_3682 vss vout.$1002.Metal3 4.91457e-05f
Cred_3683 vss vout.$1004.Metal3 2.56259e-05f
Cred_3684 vss vout.$1006.Metal3 5.11152e-05f
Cred_3685 vss vout.$1008.Metal3 5.11152e-05f
Cred_3686 vss vout.$1010.Metal3 0.00987627f
Cred_3687 vss vout.$1032.Metal3 0.0173432f
Cred_3688 vss vout.$1034.Metal3 0.000155107f
Cred_3689 vss vout.$1036.Metal3 3.03574e-05f
Cred_3690 vss vout.$1040.Metal3 0.000105451f
Cred_3691 vss vout.$1050.Metal3 0.00633479f
Cred_3692 vss vout.$1070.Metal3 0.00633479f
Cred_3693 vss vout.$1072.Metal3 0.00864165f
Cred_3694 vss vout.$11.Metal1 0.00637181f
Cred_3695 vss vout.$1110.Metal3 0.00841854f
Cred_3696 vss vout.$1112.Metal3 0.00862291f
Cred_3697 vss vout.$1150.Metal3 0.00841854f
Cred_3698 vss vout.$1152.Metal3 0.016738f
Cred_3699 vss vout.$1190.Metal3 0.0135965f
Cred_3700 vss vout.$12.Metal1 0.00636247f
Cred_3701 vss vout.$121.Metal1 0.00704504f
Cred_3702 vss vout.$122.Metal1 0.00703864f
Cred_3703 vss vout.$123.Metal1 0.00703842f
Cred_3704 vss vout.$1235.Metal4 0.0526089f
Cred_3705 vss vout.$1236.Metal4 0.0111949f
Cred_3706 vss vout.$1237.Metal4 0.0130693f
Cred_3707 vss vout.$1238.Metal4 0.022553f
Cred_3708 vss vout.$1239.Metal4 0.0117022f
Cred_3709 vss vout.$124.Metal1 0.00701111f
Cred_3710 vss vout.$1240.Metal4 0.00776577f
Cred_3711 vss vout.$1241.Metal4 0.0151591f
Cred_3712 vss vout.$125.Metal1 0.00701127f
Cred_3713 vss vout.$1252.Metal4 0.0368922f
Cred_3714 vss vout.$126.Metal1 0.00701093f
Cred_3715 vss vout.$1261.Metal4 0.00914658f
Cred_3716 vss vout.$1264.Metal4 0.0407275f
Cred_3717 vss vout.$1269.Metal4 0.0115404f
Cred_3718 vss vout.$127.Metal1 0.00701093f
Cred_3719 vss vout.$1279.Metal4 0.00914658f
Cred_3720 vss vout.$128.Metal1 0.00705535f
Cred_3721 vss vout.$1289.Metal4 0.00905496f
Cred_3722 vss vout.$129.Metal1 0.00705535f
Cred_3723 vss vout.$1299.Metal4 0.172633f
Cred_3724 vss vout.$13.Metal1 0.00636247f
Cred_3725 vss vout.$130.Metal1 0.00705841f
Cred_3726 vss vout.$1313.Metal4 0.0573329f
Cred_3727 vss vout.$1323.Metal4 0.00462294f
Cred_3728 vss vout.$1328.Metal4 0.0230038f
Cred_3729 vss vout.$1329.Metal4 0.00254506f
Cred_3730 vss vout.$1330.Metal4 3.61557e-06f
Cred_3731 vss vout.$1332.Metal4 0.00214828f
Cred_3732 vss vout.$1333.Metal4 0.00466471f
Cred_3733 vss vout.$1343.Metal4 0.00462294f
Cred_3734 vss vout.$1353.Metal4 0.00462294f
Cred_3735 vss vout.$1363.Metal4 0.00466471f
Cred_3736 vss vout.$1368.Metal4 0.0188493f
Cred_3737 vss vout.$1369.Metal4 0.00336584f
Cred_3738 vss vout.$1370.Metal4 0.00168292f
Cred_3739 vss vout.$1372.Metal4 0.00121693f
Cred_3740 vss vout.$1373.Metal4 0.00746726f
Cred_3741 vss vout.$1384.Metal4 0.00466471f
Cred_3742 vss vout.$1395.Metal4 0.00462294f
Cred_3743 vss vout.$14.Metal1 0.00636247f
Cred_3744 vss vout.$1405.Metal4 0.00466471f
Cred_3745 vss vout.$1408.Metal4 0.0219291f
Cred_3746 vss vout.$1416.Metal4 0.013458f
Cred_3747 vss vout.$15.Metal1 0.00636278f
Cred_3748 vss vout.$156.Metal1 4.55111e-05f
Cred_3749 vss vout.$157.Metal1 3.76375e-05f
Cred_3750 vss vout.$158.Metal1 3.75056e-05f
Cred_3751 vss vout.$16.Metal1 0.00636278f
Cred_3752 vss vout.$160.Metal1 1.11484e-07f
Cred_3753 vss vout.$161.Metal1 5.07907e-05f
Cred_3754 vss vout.$162.Metal1 2.64837e-05f
Cred_3755 vss vout.$163.Metal1 5.28262e-05f
Cred_3756 vss vout.$164.Metal1 5.28262e-05f
Cred_3757 vss vout.$165.Metal1 5.41661e-05f
Cred_3758 vss vout.$17.Metal1 0.00636247f
Cred_3759 vss vout.$18.Metal1 0.00636132f
Cred_3760 vss vout.$19.Metal1 0.00636135f
Cred_3761 vss vout.$20.Metal1 0.00636431f
Cred_3762 vss vout.$396.Metal1 7.50837e-06f
Cred_3763 vss vout.$405.Metal1 4.04395e-06f
Cred_3764 vss vout.$436.Metal2 0.00372595f
Cred_3765 vss vout.$438.Metal2 0.00293628f
Cred_3766 vss vout.$440.Metal2 0.00293628f
Cred_3767 vss vout.$442.Metal2 0.00293628f
Cred_3768 vss vout.$444.Metal2 0.00296177f
Cred_3769 vss vout.$446.Metal2 0.00296177f
Cred_3770 vss vout.$448.Metal2 0.00293628f
Cred_3771 vss vout.$450.Metal2 0.00281598f
Cred_3772 vss vout.$452.Metal2 0.00281722f
Cred_3773 vss vout.$454.Metal2 0.00296583f
Cred_3774 vss vout.$458.Metal2 3.06347e-05f
Cred_3775 vss vout.$460.Metal2 3.06347e-05f
Cred_3776 vss vout.$462.Metal2 3.06347e-05f
Cred_3777 vss vout.$464.Metal2 3.56518e-05f
Cred_3778 vss vout.$466.Metal2 3.56518e-05f
Cred_3779 vss vout.$468.Metal2 3.06347e-05f
Cred_3780 vss vout.$474.Metal2 9.16161e-05f
Cred_3781 vss vout.$476.Metal2 8.63086e-05f
Cred_3782 vss vout.$498.Metal2 8.54475e-06f
Cred_3783 vss vout.$500.Metal2 3.75683e-06f
Cred_3784 vss vout.$502.Metal2 4.14424e-06f
Cred_3785 vss vout.$504.Metal2 7.65222e-06f
Cred_3786 vss vout.$514.Metal2 9.16161e-05f
Cred_3787 vss vout.$516.Metal2 0.00627692f
Cred_3788 vss vout.$518.Metal2 0.00573093f
Cred_3789 vss vout.$520.Metal2 0.00571126f
Cred_3790 vss vout.$522.Metal2 0.00433907f
Cred_3791 vss vout.$524.Metal2 0.00435349f
Cred_3792 vss vout.$526.Metal2 0.0043223f
Cred_3793 vss vout.$528.Metal2 0.0043223f
Cred_3794 vss vout.$530.Metal2 0.0065551f
Cred_3795 vss vout.$532.Metal2 0.0065551f
Cred_3796 vss vout.$534.Metal2 0.00670896f
Cred_3797 vss vout.$584.Metal2 0.00264087f
Cred_3798 vss vout.$586.Metal2 0.00189607f
Cred_3799 vss vout.$588.Metal2 0.00188434f
Cred_3800 vss vout.$592.Metal2 9.90959e-06f
Cred_3801 vss vout.$594.Metal2 0.00255013f
Cred_3802 vss vout.$596.Metal2 0.00132971f
Cred_3803 vss vout.$598.Metal2 0.00265232f
Cred_3804 vss vout.$600.Metal2 0.00265232f
Cred_3805 vss vout.$602.Metal2 0.0027196f
Cred_3806 vss vout.$604.Metal2 0.000216185f
Cred_3807 vss vout.$606.Metal2 3.10903e-06f
Cred_3808 vss vout.$608.Metal2 6.08498e-07f
Cred_3809 vss vout.$612.Metal2 2.1137e-06f
Cred_3810 vss vout.$622.Metal2 4.17677e-05f
Cred_3811 vss vout.$644.Metal2 4.35351e-05f
Cred_3812 vss vout.$682.Metal2 4.17677e-05f
Cred_3813 vss vout.$684.Metal2 4.17677e-05f
Cred_3814 vss vout.$722.Metal2 4.17677e-05f
Cred_3815 vss vout.$724.Metal2 4.33367e-05f
Cred_3816 vss vout.$762.Metal2 4.17677e-05f
Cred_3817 vss vout.$764.Metal2 0.000205915f
Cred_3818 vss vout.$784.Metal2 0.000711859f
Cred_3819 vss vout.$802.Metal2 0.000348597f
Cred_3820 vss vout.$858.Metal3 0.00183367f
Cred_3821 vss vout.$860.Metal3 0.0018983f
Cred_3822 vss vout.$862.Metal3 0.0235034f
Cred_3823 vss vout.$864.Metal3 0.0329109f
Cred_3824 vss vout.$886.Metal3 0.00195463f
Cred_3825 vss vout.$888.Metal3 0.00171576f
Cred_3826 vss vout.$890.Metal3 0.00173509f
Cred_3827 vss vout.$892.Metal3 0.0021604f
Cred_3828 vss vout.$894.Metal3 0.00177864f
Cred_3829 vss vout.$896.Metal3 0.00152834f
Cred_3830 vss vout.$902.Metal3 0.0184658f
Cred_3831 vss vout.$904.Metal3 0.0226511f
Cred_3832 vss vout.$934.Metal3 8.32987e-05f
Cred_3833 vss vout.$936.Metal3 8.32987e-05f
Cred_3834 vss vout.$938.Metal3 0.000126329f
Cred_3835 vss vout.$940.Metal3 0.000126329f
Cred_3836 vss vout.$942.Metal3 0.0220042f
Cred_3837 vss vout.P0.GatPoly 0.152137f
Cred_3838 vss vref 0.797478f
Cred_3839 vss vref.P0.GatPoly 0.144978f
Cred_3840 vss vref.P0.nSD 0.0411867f
Cred_3841 vss vref.P0.pSD 0.0550933f
Cred_3843 vss vss.$10.Metal1 0.105437f
Cred_3844 vss vss.$1001.Metal4 0.046715f
Cred_3845 vss vss.$1003.Metal4 0.0221319f
Cred_3846 vss vss.$1005.Metal4 0.015774f
Cred_3847 vss vss.$1007.Metal4 0.0158971f
Cred_3848 vss vss.$1009.Metal4 0.0157627f
Cred_3849 vss vss.$1011.Metal4 0.013519f
Cred_3850 vss vss.$1013.Metal4 0.0125334f
Cred_3851 vss vss.$1015.Metal4 0.0135199f
Cred_3852 vss vss.$1017.Metal4 0.0127001f
Cred_3853 vss vss.$1019.Metal4 0.0132729f
Cred_3854 vss vss.$1021.Metal4 0.0133964f
Cred_3855 vss vss.$1023.Metal4 0.0125748f
Cred_3856 vss vss.$1025.Metal4 0.0134376f
Cred_3857 vss vss.$1027.Metal4 0.0126585f
Cred_3858 vss vss.$1029.Metal4 0.0133141f
Cred_3859 vss vss.$1031.Metal4 0.0132935f
Cred_3860 vss vss.$1033.Metal4 0.019276f
Cred_3861 vss vss.$1037.Metal4 0.019276f
Cred_3862 vss vss.$1039.Metal4 0.0132935f
Cred_3863 vss vss.$1041.Metal4 0.0133141f
Cred_3864 vss vss.$1043.Metal4 0.0126585f
Cred_3865 vss vss.$1045.Metal4 0.0135199f
Cred_3866 vss vss.$1047.Metal4 0.012575f
Cred_3867 vss vss.$1049.Metal4 0.0133964f
Cred_3868 vss vss.$1051.Metal4 0.0132729f
Cred_3869 vss vss.$1053.Metal4 0.0127001f
Cred_3870 vss vss.$1055.Metal4 0.0135199f
Cred_3871 vss vss.$1057.Metal4 0.0125334f
Cred_3872 vss vss.$1059.Metal4 0.013519f
Cred_3873 vss vss.$1061.Metal4 0.0156041f
Cred_3874 vss vss.$1063.Metal4 0.015687f
Cred_3875 vss vss.$1065.Metal4 0.0155919f
Cred_3876 vss vss.$1067.Metal4 0.0218911f
Cred_3877 vss vss.$1069.Metal4 0.0465074f
Cred_3878 vss vss.$1212.Metal5 12.2818f
Cred_3879 vss vss.$1230.Metal5 6.20634f
Cred_3880 vss vss.$1247.Metal5 0.107102f
Cred_3881 vss vss.$127.Metal1 0.448603f
Cred_3882 vss vss.$1282.Metal5 17.9164f
Cred_3883 vss vss.$13.Metal1 0.104922f
Cred_3884 vss vss.$1300.Metal5 8.63013f
Cred_3885 vss vss.$136.Metal1 0.0885972f
Cred_3886 vss vss.$138.Metal1 0.0874876f
Cred_3887 vss vss.$141.Metal1 0.0886035f
Cred_3888 vss vss.$143.Metal1 0.0891179f
Cred_3889 vss vss.$146.Metal1 0.0884696f
Cred_3890 vss vss.$148.Metal1 0.0701881f
Cred_3891 vss vss.$150.Metal1 0.0885981f
Cred_3892 vss vss.$153.Metal1 0.104922f
Cred_3893 vss vss.$156.Metal1 0.105439f
Cred_3894 vss vss.$159.Metal1 0.330723f
Cred_3895 vss vss.$406.Metal1 0.73722f
Cred_3896 vss vss.$457.Metal2 0.0719812f
Cred_3897 vss vss.$461.Metal2 0.207614f
Cred_3898 vss vss.$463.Metal2 0.0669038f
Cred_3899 vss vss.$467.Metal2 0.0410382f
Cred_3900 vss vss.$469.Metal2 0.0576431f
Cred_3901 vss vss.$473.Metal2 0.0542393f
Cred_3902 vss vss.$475.Metal2 0.0437655f
Cred_3903 vss vss.$479.Metal2 0.0698794f
Cred_3904 vss vss.$483.Metal2 0.0541492f
Cred_3905 vss vss.$485.Metal2 0.0428093f
Cred_3906 vss vss.$489.Metal2 0.0692119f
Cred_3907 vss vss.$493.Metal2 0.0557223f
Cred_3908 vss vss.$495.Metal2 0.0424705f
Cred_3909 vss vss.$499.Metal2 0.0679724f
Cred_3910 vss vss.$503.Metal2 0.0705061f
Cred_3911 vss vss.$507.Metal2 0.0440482f
Cred_3912 vss vss.$509.Metal2 0.0547376f
Cred_3913 vss vss.$513.Metal2 0.0582105f
Cred_3914 vss vss.$515.Metal2 0.0412861f
Cred_3915 vss vss.$519.Metal2 0.0674936f
Cred_3916 vss vss.$521.Metal2 0.207614f
Cred_3917 vss vss.$525.Metal2 0.0702576f
Cred_3918 vss vss.$793.Metal3 0.072618f
Cred_3919 vss vss.$795.Metal3 0.0252257f
Cred_3920 vss vss.$799.Metal3 0.0247411f
Cred_3921 vss vss.$801.Metal3 0.0236179f
Cred_3922 vss vss.$805.Metal3 0.0310639f
Cred_3923 vss vss.$809.Metal3 0.0234324f
Cred_3924 vss vss.$811.Metal3 0.0237081f
Cred_3925 vss vss.$815.Metal3 0.031049f
Cred_3926 vss vss.$819.Metal3 0.0234744f
Cred_3927 vss vss.$821.Metal3 0.0235001f
Cred_3928 vss vss.$825.Metal3 0.0312175f
Cred_3929 vss vss.$829.Metal3 0.0233379f
Cred_3930 vss vss.$831.Metal3 0.0236407f
Cred_3931 vss vss.$835.Metal3 0.0310692f
Cred_3932 vss vss.$839.Metal3 0.0237292f
Cred_3933 vss vss.$841.Metal3 0.0234324f
Cred_3934 vss vss.$845.Metal3 0.0310639f
Cred_3935 vss vss.$849.Metal3 0.0236179f
Cred_3936 vss vss.$851.Metal3 0.0245971f
Cred_3937 vss vss.$855.Metal3 0.024941f
Cred_3938 vss vss.$857.Metal3 0.0722498f
Cred_3939 vss vss.P0.GatPoly 0.0437447f
Cred_3940 vss vss.P0.nSD 0.0604355f
Cred_3941 vss vss.P0.pSD 1.38202f
Cred_3942 vss vss.P1.GatPoly 0.040028f
Cred_3943 vss vss.P1.nSD 0.00846184f
Cred_3944 vss vss.P10.nSD 0.00849957f
Cred_3945 vss vss.P11.nSD 0.00900544f
Cred_3946 vss vss.P13.nSD 0.00897906f
Cred_3947 vss vss.P15.nSD 0.00852929f
Cred_3948 vss vss.P17.nSD 0.00900486f
Cred_3949 vss vss.P19.nSD 0.00899204f
Cred_3950 vss vss.P21.nSD 0.00897723f
Cred_3951 vss vss.P23.nSD 0.00865046f
Cred_3952 vss vss.P25.nSD 0.0604355f
Cred_3953 vss vss.P3.nSD 0.00878922f
Cred_3954 vss vss.P5.nSD 0.00880374f
Cred_3955 vss vss.P7.nSD 0.00881663f
Cred_3956 vdd vss 63.2445f
Cred_3957 vdd vss.$1212.Metal5 41.0133f
Cred_3958 vdd vss.$1230.Metal5 41.0133f
Cred_3959 vdd vss.$1282.Metal5 156.991f
Cred_3960 vdd vss.$1300.Metal5 156.991f
Cred_3961 vdd.$2365.Metal1 vout 0.000165263f
Cred_3962 vdd.$2365.Metal1 vout.$1002.Metal3 1.20856e-09f
Cred_3963 vdd.$2365.Metal1 vout.$1004.Metal3 9.34949e-10f
Cred_3964 vdd.$2365.Metal1 vout.$1006.Metal3 7.23347e-10f
Cred_3965 vdd.$2365.Metal1 vout.$1008.Metal3 5.59719e-10f
Cred_3966 vdd.$2365.Metal1 vout.$1010.Metal3 4.33214e-10f
Cred_3967 vdd.$2365.Metal1 vout.$1032.Metal3 6.52219e-09f
Cred_3968 vdd.$2365.Metal1 vout.$1034.Metal3 4.21203e-09f
Cred_3969 vdd.$2365.Metal1 vout.$1036.Metal3 3.3252e-09f
Cred_3970 vdd.$2365.Metal1 vout.$1038.Metal3 2.5356e-09f
Cred_3971 vdd.$2365.Metal1 vout.$1040.Metal3 2.36742e-09f
Cred_3972 vdd.$2365.Metal1 vout.$1299.Metal4 1.93097e-07f
Cred_3973 vdd.$2365.Metal1 vout.$1313.Metal4 0.000129147f
Cred_3974 vdd.$2365.Metal1 vout.$1328.Metal4 7.76795e-10f
Cred_3975 vdd.$2365.Metal1 vout.$1329.Metal4 5.01654e-10f
Cred_3976 vdd.$2365.Metal1 vout.$1330.Metal4 3.96032e-10f
Cred_3977 vdd.$2365.Metal1 vout.$1331.Metal4 3.0199e-10f
Cred_3978 vdd.$2365.Metal1 vout.$1332.Metal4 2.8196e-10f
Cred_3979 vdd.$2365.Metal1 vout.$156.Metal1 6.56633e-05f
Cred_3980 vdd.$2365.Metal1 vout.$157.Metal1 4.24054e-05f
Cred_3981 vdd.$2365.Metal1 vout.$158.Metal1 3.34771e-05f
Cred_3982 vdd.$2365.Metal1 vout.$159.Metal1 2.55276e-05f
Cred_3983 vdd.$2365.Metal1 vout.$160.Metal1 2.38344e-05f
Cred_3984 vdd.$2365.Metal1 vout.$161.Metal1 1.01843e-05f
Cred_3985 vdd.$2365.Metal1 vout.$162.Metal1 7.87862e-06f
Cred_3986 vdd.$2365.Metal1 vout.$163.Metal1 6.09549e-06f
Cred_3987 vdd.$2365.Metal1 vout.$164.Metal1 4.71663e-06f
Cred_3988 vdd.$2365.Metal1 vout.$165.Metal1 3.6506e-06f
Cred_3989 vdd.$2365.Metal1 vout.$584.Metal2 4.04845e-07f
Cred_3990 vdd.$2365.Metal1 vout.$586.Metal2 2.61449e-07f
Cred_3991 vdd.$2365.Metal1 vout.$588.Metal2 2.06402e-07f
Cred_3992 vdd.$2365.Metal1 vout.$590.Metal2 1.57389e-07f
Cred_3993 vdd.$2365.Metal1 vout.$592.Metal2 1.4695e-07f
Cred_3994 vdd.$2365.Metal1 vout.$594.Metal2 6.27111e-08f
Cred_3995 vdd.$2365.Metal1 vout.$596.Metal2 4.85137e-08f
Cred_3996 vdd.$2365.Metal1 vout.$598.Metal2 3.75338e-08f
Cred_3997 vdd.$2365.Metal1 vout.$600.Metal2 2.90433e-08f
Cred_3998 vdd.$2365.Metal1 vout.$602.Metal2 2.24791e-08f
Cred_3999 vdd.$2365.Metal1 vout.$604.Metal2 1.30734e-10f
Cred_4000 vdd.$2365.Metal1 vout.$606.Metal2 8.44279e-11f
Cred_4001 vdd.$2365.Metal1 vout.$608.Metal2 6.66519e-11f
Cred_4002 vdd.$2365.Metal1 vout.$610.Metal2 5.08246e-11f
Cred_4003 vdd.$2365.Metal1 vout.$612.Metal2 4.74535e-11f
Cred_4004 vdd.$2365.Metal1 vout.P0.GatPoly 1.24248e-05f
Cred_4005 vdd.$2365.Metal1 vref 0.000336121f
Cred_4006 vdd.$2365.Metal1 vref.P0.GatPoly 1.20224e-05f
Cred_4007 vdd.$2365.Metal1 vref.P0.nSD 5.71094e-05f
Cred_4008 vdd.$2365.Metal1 vref.P0.pSD 0.000165129f
Cred_4009 vdd.$2365.Metal1 vss 2.10024e-05f
Cred_4010 vdd.$2365.Metal1 vss.$1212.Metal5 2.16599e-05f
Cred_4011 vdd.$2365.Metal1 vss.$1230.Metal5 2.16599e-05f
Cred_4012 vdd.$2365.Metal1 vss.$1282.Metal5 0.0739174f
Cred_4013 vdd.$2365.Metal1 vss.$1300.Metal5 0.000137244f
Cred_4014 vdd.$2367.Metal1 vss.$1282.Metal5 0.0111822f
Cred_4015 vdd.$2370.Metal1 vout.$1032.Metal3 8.32148e-06f
Cred_4016 vdd.$2370.Metal1 vout.$1034.Metal3 9.86007e-06f
Cred_4017 vdd.$2370.Metal1 vout.$1072.Metal3 4.02449e-06f
Cred_4018 vdd.$2370.Metal1 vout.$1074.Metal3 5.42491e-06f
Cred_4019 vdd.$2370.Metal1 vout.$1112.Metal3 1.07192e-05f
Cred_4020 vdd.$2370.Metal1 vout.$1114.Metal3 5.7919e-06f
Cred_4021 vdd.$2370.Metal1 vout.$1152.Metal3 2.5293e-05f
Cred_4022 vdd.$2370.Metal1 vout.$1154.Metal3 1.40184e-05f
Cred_4023 vdd.$2370.Metal1 vout.$1328.Metal4 2.74819e-06f
Cred_4024 vdd.$2370.Metal1 vout.$1329.Metal4 2.75463e-06f
Cred_4025 vdd.$2370.Metal1 vout.$1368.Metal4 9.53435e-05f
Cred_4026 vdd.$2370.Metal1 vout.$1369.Metal4 1.76772e-05f
Cred_4027 vdd.$2370.Metal1 vout.$1408.Metal4 0.00111924f
Cred_4028 vdd.$2370.Metal1 vout.$156.Metal1 2.24703e-05f
Cred_4029 vdd.$2370.Metal1 vout.$157.Metal1 2.24328e-05f
Cred_4030 vdd.$2370.Metal1 vout.$206.Metal1 2.06567e-05f
Cred_4031 vdd.$2370.Metal1 vout.$207.Metal1 2.06168e-05f
Cred_4032 vdd.$2370.Metal1 vout.$226.Metal1 1.57111e-05f
Cred_4033 vdd.$2370.Metal1 vout.$227.Metal1 1.53009e-05f
Cred_4034 vdd.$2370.Metal1 vout.$266.Metal1 1.5935e-05f
Cred_4035 vdd.$2370.Metal1 vout.$267.Metal1 1.58502e-05f
Cred_4036 vdd.$2370.Metal1 vout.$286.Metal1 1.66352e-05f
Cred_4037 vdd.$2370.Metal1 vout.$287.Metal1 1.62535e-05f
Cred_4038 vdd.$2370.Metal1 vout.$326.Metal1 1.7042e-05f
Cred_4039 vdd.$2370.Metal1 vout.$327.Metal1 1.66176e-05f
Cred_4040 vdd.$2370.Metal1 vout.$346.Metal1 2.31762e-05f
Cred_4041 vdd.$2370.Metal1 vout.$347.Metal1 2.29305e-05f
Cred_4042 vdd.$2370.Metal1 vout.$396.Metal1 0.00127744f
Cred_4043 vdd.$2370.Metal1 vout.$397.Metal1 2.59548e-05f
Cred_4044 vdd.$2370.Metal1 vout.$584.Metal2 3.74532e-05f
Cred_4045 vdd.$2370.Metal1 vout.$586.Metal2 3.66208e-05f
Cred_4046 vdd.$2370.Metal1 vout.$604.Metal2 3.03786e-05f
Cred_4047 vdd.$2370.Metal1 vout.$606.Metal2 3.0388e-05f
Cred_4048 vdd.$2370.Metal1 vout.$644.Metal2 3.09725e-05f
Cred_4049 vdd.$2370.Metal1 vout.$646.Metal2 3.09777e-05f
Cred_4050 vdd.$2370.Metal1 vout.$664.Metal2 2.23336e-05f
Cred_4051 vdd.$2370.Metal1 vout.$666.Metal2 2.16181e-05f
Cred_4052 vdd.$2370.Metal1 vout.$684.Metal2 2.43733e-05f
Cred_4053 vdd.$2370.Metal1 vout.$686.Metal2 2.34834e-05f
Cred_4054 vdd.$2370.Metal1 vout.$704.Metal2 2.6194e-05f
Cred_4055 vdd.$2370.Metal1 vout.$706.Metal2 2.55089e-05f
Cred_4056 vdd.$2370.Metal1 vout.$724.Metal2 4.0978e-05f
Cred_4057 vdd.$2370.Metal1 vout.$726.Metal2 3.9871e-05f
Cred_4058 vdd.$2370.Metal1 vout.$764.Metal2 4.36814e-05f
Cred_4059 vdd.$2370.Metal1 vout.$766.Metal2 4.25415e-05f
Cred_4060 vdd.$2370.Metal1 vout.$784.Metal2 7.56538e-05f
Cred_4061 vdd.$2370.Metal1 vout.$786.Metal2 5.6512e-05f
Cred_4062 vdd.$2370.Metal1 vout.P0.pSD 8.59513e-06f
Cred_4063 vdd.$2370.Metal1 vout.P2.pSD 5.94552e-07f
Cred_4064 vdd.$2370.Metal1 vss.$1282.Metal5 0.00960248f
Cred_4065 vdd.$2372.Metal1 vout.$1154.Metal3 4.43994e-07f
Cred_4066 vdd.$2372.Metal1 vout.$1369.Metal4 8.95563e-06f
Cred_4067 vdd.$2372.Metal1 vout.$1370.Metal4 0.000389355f
Cred_4068 vdd.$2372.Metal1 vout.$397.Metal1 0.00202212f
Cred_4069 vdd.$2372.Metal1 vout.$766.Metal2 8.89962e-09f
Cred_4070 vdd.$2372.Metal1 vout.$786.Metal2 2.7676e-05f
Cred_4071 vdd.$2372.Metal1 vout.P2.pSD 0.00168762f
Cred_4072 vdd.$2372.Metal1 vss.$1282.Metal5 0.00822874f
Cred_4073 vdd.$2375.Metal1 vout.$1156.Metal3 1.14273e-07f
Cred_4074 vdd.$2375.Metal1 vout.$1370.Metal4 0.0019815f
Cred_4075 vdd.$2375.Metal1 vout.$398.Metal1 0.00115533f
Cred_4076 vdd.$2375.Metal1 vout.$768.Metal2 2.29053e-09f
Cred_4077 vdd.$2375.Metal1 vout.$788.Metal2 7.12308e-06f
Cred_4078 vdd.$2375.Metal1 vss.$1282.Metal5 0.008376f
Cred_4079 vdd.$2377.Metal1 vout.$1158.Metal3 1.99976e-07f
Cred_4080 vdd.$2377.Metal1 vout.$1371.Metal4 2.48604e-08f
Cred_4081 vdd.$2377.Metal1 vout.$399.Metal1 0.00202182f
Cred_4082 vdd.$2377.Metal1 vout.$770.Metal2 4.00842e-09f
Cred_4083 vdd.$2377.Metal1 vout.$790.Metal2 1.24654e-05f
Cred_4084 vdd.$2377.Metal1 vout.P6.pSD 0.00172605f
Cred_4085 vdd.$2377.Metal1 vss.$1282.Metal5 0.00653818f
Cred_4086 vdd.$2379.Metal1 vout.$1180.Metal3 7.65805e-08f
Cred_4087 vdd.$2379.Metal1 vout.$1372.Metal4 0.00193353f
Cred_4088 vdd.$2379.Metal1 vout.$400.Metal1 0.000695841f
Cred_4089 vdd.$2379.Metal1 vout.$792.Metal2 4.28769e-06f
Cred_4090 vdd.$2379.Metal1 vss 0.000372137f
Cred_4091 vdd.$2379.Metal1 vss.$1212.Metal5 0.000383787f
Cred_4092 vdd.$2379.Metal1 vss.$1230.Metal5 0.000383787f
Cred_4093 vdd.$2379.Metal1 vss.$1282.Metal5 0.00310575f
Cred_4094 vdd.$2379.Metal1 vss.$1300.Metal5 0.00146906f
Cred_4095 vdd.$2382.Metal1 vout.$1162.Metal3 3.41102e-08f
Cred_4096 vdd.$2382.Metal1 vout.$1180.Metal3 3.79538e-08f
Cred_4097 vdd.$2382.Metal1 vout.$1372.Metal4 0.000374717f
Cred_4098 vdd.$2382.Metal1 vout.$1383.Metal4 0.000374719f
Cred_4099 vdd.$2382.Metal1 vout.$400.Metal1 0.000344864f
Cred_4100 vdd.$2382.Metal1 vout.$401.Metal1 0.000344864f
Cred_4101 vdd.$2382.Metal1 vout.$774.Metal2 6.83721e-10f
Cred_4102 vdd.$2382.Metal1 vout.$792.Metal2 2.12501e-06f
Cred_4103 vdd.$2382.Metal1 vout.$794.Metal2 2.12623e-06f
Cred_4104 vdd.$2382.Metal1 vref 0.000110365f
Cred_4105 vdd.$2382.Metal1 vref.P0.GatPoly 4.30363e-06f
Cred_4106 vdd.$2382.Metal1 vref.P0.nSD 2.46713e-05f
Cred_4107 vdd.$2382.Metal1 vref.P0.pSD 0.00341376f
Cred_4108 vdd.$2382.Metal1 vss 0.000114553f
Cred_4109 vdd.$2382.Metal1 vss.$1212.Metal5 0.00011814f
Cred_4110 vdd.$2382.Metal1 vss.$1230.Metal5 0.00011814f
Cred_4111 vdd.$2382.Metal1 vss.$1282.Metal5 0.000452215f
Cred_4112 vdd.$2382.Metal1 vss.$1300.Metal5 0.000452215f
Cred_4113 vdd.$2385.Metal1 vout.$1162.Metal3 6.88252e-08f
Cred_4114 vdd.$2385.Metal1 vout.$1373.Metal4 0.0035354f
Cred_4115 vdd.$2385.Metal1 vout.$1383.Metal4 0.00073765f
Cred_4116 vdd.$2385.Metal1 vout.$401.Metal1 0.000695841f
Cred_4117 vdd.$2385.Metal1 vout.$774.Metal2 1.37956e-09f
Cred_4118 vdd.$2385.Metal1 vout.$794.Metal2 4.29016e-06f
Cred_4119 vdd.$2385.Metal1 vss 0.000522556f
Cred_4120 vdd.$2385.Metal1 vss.$1212.Metal5 0.000538916f
Cred_4121 vdd.$2385.Metal1 vss.$1230.Metal5 0.000538916f
Cred_4122 vdd.$2385.Metal1 vss.$1282.Metal5 0.00206286f
Cred_4123 vdd.$2385.Metal1 vss.$1300.Metal5 0.00206286f
Cred_4124 vdd.$2387.Metal1 vout.$1164.Metal3 1.99976e-07f
Cred_4125 vdd.$2387.Metal1 vout.$1373.Metal4 0.00270482f
Cred_4126 vdd.$2387.Metal1 vout.$1394.Metal4 2.48604e-08f
Cred_4127 vdd.$2387.Metal1 vout.$402.Metal1 0.00202182f
Cred_4128 vdd.$2387.Metal1 vout.$776.Metal2 4.00842e-09f
Cred_4129 vdd.$2387.Metal1 vout.$796.Metal2 1.24654e-05f
Cred_4130 vdd.$2387.Metal1 vout.P12.pSD 0.00172605f
Cred_4131 vdd.$2387.Metal1 vss 0.000541866f
Cred_4132 vdd.$2387.Metal1 vss.$1212.Metal5 0.00055883f
Cred_4133 vdd.$2387.Metal1 vss.$1230.Metal5 0.00055883f
Cred_4134 vdd.$2387.Metal1 vss.$1282.Metal5 0.00213909f
Cred_4135 vdd.$2387.Metal1 vss.$1300.Metal5 0.00213909f
Cred_4136 vdd.$2389.Metal1 vout.$1166.Metal3 1.14273e-07f
Cred_4137 vdd.$2389.Metal1 vout.$1373.Metal4 0.00580778f
Cred_4138 vdd.$2389.Metal1 vout.$1415.Metal4 1.4206e-08f
Cred_4139 vdd.$2389.Metal1 vout.$403.Metal1 0.00115533f
Cred_4140 vdd.$2389.Metal1 vout.$778.Metal2 2.29053e-09f
Cred_4141 vdd.$2389.Metal1 vout.$798.Metal2 7.12308e-06f
Cred_4142 vdd.$2389.Metal1 vss 0.000674372f
Cred_4143 vdd.$2389.Metal1 vss.$1212.Metal5 0.000695485f
Cred_4144 vdd.$2389.Metal1 vss.$1230.Metal5 0.000695485f
Cred_4145 vdd.$2389.Metal1 vss.$1282.Metal5 0.00266217f
Cred_4146 vdd.$2389.Metal1 vss.$1300.Metal5 0.00266217f
Cred_4147 vdd.$2392.Metal1 vout.$1208.Metal3 5.32907e-07f
Cred_4148 vdd.$2392.Metal1 vout.$1373.Metal4 0.00388048f
Cred_4149 vdd.$2392.Metal1 vout.$1415.Metal4 1.04624e-08f
Cred_4150 vdd.$2392.Metal1 vout.$404.Metal1 0.00202212f
Cred_4151 vdd.$2392.Metal1 vout.$800.Metal2 2.7641e-05f
Cred_4152 vdd.$2392.Metal1 vout.P16.pSD 0.00168762f
Cred_4153 vdd.$2392.Metal1 vss 0.000676938f
Cred_4154 vdd.$2392.Metal1 vss.$1212.Metal5 0.000698131f
Cred_4155 vdd.$2392.Metal1 vss.$1230.Metal5 0.000698131f
Cred_4156 vdd.$2392.Metal1 vss.$1282.Metal5 0.0026723f
Cred_4157 vdd.$2392.Metal1 vss.$1300.Metal5 0.0026723f
Cred_4158 vdd.$2394.Metal1 vout 1.20776e-06f
Cred_4159 vdd.$2394.Metal1 vout.$1008.Metal3 5.12173e-06f
Cred_4160 vdd.$2394.Metal1 vout.$1010.Metal3 6.20157e-06f
Cred_4161 vdd.$2394.Metal1 vout.$1048.Metal3 4.20558e-06f
Cred_4162 vdd.$2394.Metal1 vout.$1050.Metal3 5.23352e-06f
Cred_4163 vdd.$2394.Metal1 vout.$1070.Metal3 3.64349e-06f
Cred_4164 vdd.$2394.Metal1 vout.$1088.Metal3 4.67009e-06f
Cred_4165 vdd.$2394.Metal1 vout.$1110.Metal3 5.60133e-06f
Cred_4166 vdd.$2394.Metal1 vout.$1128.Metal3 6.07938e-06f
Cred_4167 vdd.$2394.Metal1 vout.$1150.Metal3 7.01491e-06f
Cred_4168 vdd.$2394.Metal1 vout.$1168.Metal3 6.6561e-06f
Cred_4169 vdd.$2394.Metal1 vout.$1190.Metal3 1.44969e-05f
Cred_4170 vdd.$2394.Metal1 vout.$1208.Metal3 8.68956e-06f
Cred_4171 vdd.$2394.Metal1 vout.$1299.Metal4 1.45434e-11f
Cred_4172 vdd.$2394.Metal1 vout.$1313.Metal4 2.58239e-06f
Cred_4173 vdd.$2394.Metal1 vout.$1323.Metal4 2.45637e-06f
Cred_4174 vdd.$2394.Metal1 vout.$1333.Metal4 6.25352e-06f
Cred_4175 vdd.$2394.Metal1 vout.$1343.Metal4 2.53075e-06f
Cred_4176 vdd.$2394.Metal1 vout.$1353.Metal4 2.61725e-06f
Cred_4177 vdd.$2394.Metal1 vout.$1363.Metal4 2.70475e-06f
Cred_4178 vdd.$2394.Metal1 vout.$1373.Metal4 0.00344061f
Cred_4179 vdd.$2394.Metal1 vout.$1384.Metal4 3.15783e-06f
Cred_4180 vdd.$2394.Metal1 vout.$1395.Metal4 3.27343e-06f
Cred_4181 vdd.$2394.Metal1 vout.$1405.Metal4 3.40783e-06f
Cred_4182 vdd.$2394.Metal1 vout.$1415.Metal4 5.93356e-06f
Cred_4183 vdd.$2394.Metal1 vout.$1416.Metal4 1.28619e-05f
Cred_4184 vdd.$2394.Metal1 vout.$164.Metal1 2.3067e-05f
Cred_4185 vdd.$2394.Metal1 vout.$165.Metal1 2.2182e-05f
Cred_4186 vdd.$2394.Metal1 vout.$214.Metal1 2.12703e-05f
Cred_4187 vdd.$2394.Metal1 vout.$215.Metal1 2.06168e-05f
Cred_4188 vdd.$2394.Metal1 vout.$234.Metal1 1.65784e-05f
Cred_4189 vdd.$2394.Metal1 vout.$235.Metal1 1.53009e-05f
Cred_4190 vdd.$2394.Metal1 vout.$274.Metal1 1.61138e-05f
Cred_4191 vdd.$2394.Metal1 vout.$275.Metal1 1.62775e-05f
Cred_4192 vdd.$2394.Metal1 vout.$294.Metal1 1.63772e-05f
Cred_4193 vdd.$2394.Metal1 vout.$295.Metal1 1.66692e-05f
Cred_4194 vdd.$2394.Metal1 vout.$334.Metal1 1.7042e-05f
Cred_4195 vdd.$2394.Metal1 vout.$335.Metal1 1.65881e-05f
Cred_4196 vdd.$2394.Metal1 vout.$354.Metal1 2.31762e-05f
Cred_4197 vdd.$2394.Metal1 vout.$355.Metal1 2.2691e-05f
Cred_4198 vdd.$2394.Metal1 vout.$404.Metal1 2.56415e-05f
Cred_4199 vdd.$2394.Metal1 vout.$405.Metal1 0.00127813f
Cred_4200 vdd.$2394.Metal1 vout.$600.Metal2 3.6077e-05f
Cred_4201 vdd.$2394.Metal1 vout.$602.Metal2 3.62771e-05f
Cred_4202 vdd.$2394.Metal1 vout.$620.Metal2 3.02963e-05f
Cred_4203 vdd.$2394.Metal1 vout.$622.Metal2 3.03043e-05f
Cred_4204 vdd.$2394.Metal1 vout.$660.Metal2 3.16817e-05f
Cred_4205 vdd.$2394.Metal1 vout.$662.Metal2 3.02527e-05f
Cred_4206 vdd.$2394.Metal1 vout.$680.Metal2 2.16223e-05f
Cred_4207 vdd.$2394.Metal1 vout.$682.Metal2 3.31546e-05f
Cred_4208 vdd.$2394.Metal1 vout.$700.Metal2 2.43905e-05f
Cred_4209 vdd.$2394.Metal1 vout.$720.Metal2 2.6194e-05f
Cred_4210 vdd.$2394.Metal1 vout.$722.Metal2 3.70367e-05f
Cred_4211 vdd.$2394.Metal1 vout.$740.Metal2 4.09353e-05f
Cred_4212 vdd.$2394.Metal1 vout.$742.Metal2 2.63895e-05f
Cred_4213 vdd.$2394.Metal1 vout.$762.Metal2 2.74638e-05f
Cred_4214 vdd.$2394.Metal1 vout.$780.Metal2 4.35175e-05f
Cred_4215 vdd.$2394.Metal1 vout.$782.Metal2 2.89092e-05f
Cred_4216 vdd.$2394.Metal1 vout.$800.Metal2 5.7812e-05f
Cred_4217 vdd.$2394.Metal1 vout.$802.Metal2 7.34906e-05f
Cred_4218 vdd.$2394.Metal1 vout.P0.GatPoly 1.89457e-10f
Cred_4219 vdd.$2394.Metal1 vout.P16.pSD 6.01096e-07f
Cred_4220 vdd.$2394.Metal1 vout.P18.pSD 8.59757e-06f
Cred_4221 vdd.$2394.Metal1 vss 0.000822892f
Cred_4222 vdd.$2394.Metal1 vss.$1212.Metal5 0.000848655f
Cred_4223 vdd.$2394.Metal1 vss.$1230.Metal5 0.000848655f
Cred_4224 vdd.$2394.Metal1 vss.$1282.Metal5 0.00324848f
Cred_4225 vdd.$2394.Metal1 vss.$1300.Metal5 0.00324848f
Cred_4226 vdd.$2397.Metal1 vss 0.00102047f
Cred_4227 vdd.$2397.Metal1 vss.$1212.Metal5 0.00105242f
Cred_4228 vdd.$2397.Metal1 vss.$1230.Metal5 0.00105242f
Cred_4229 vdd.$2397.Metal1 vss.$1282.Metal5 0.00402845f
Cred_4230 vdd.$2397.Metal1 vss.$1300.Metal5 0.00402845f
Cred_4231 vdd.$2399.Metal1 vout 0.00072377f
Cred_4232 vdd.$2399.Metal1 vout.$1002.Metal3 1.93107e-09f
Cred_4233 vdd.$2399.Metal1 vout.$1004.Metal3 2.48066e-09f
Cred_4234 vdd.$2399.Metal1 vout.$1006.Metal3 3.19477e-09f
Cred_4235 vdd.$2399.Metal1 vout.$1008.Metal3 4.12077e-09f
Cred_4236 vdd.$2399.Metal1 vout.$1010.Metal3 5.32007e-09f
Cred_4237 vdd.$2399.Metal1 vout.$1032.Metal3 5.31103e-10f
Cred_4238 vdd.$2399.Metal1 vout.$1034.Metal3 5.72115e-10f
Cred_4239 vdd.$2399.Metal1 vout.$1036.Metal3 7.52879e-10f
Cred_4240 vdd.$2399.Metal1 vout.$1038.Metal3 9.55655e-10f
Cred_4241 vdd.$2399.Metal1 vout.$1040.Metal3 1.48165e-09f
Cred_4242 vdd.$2399.Metal1 vout.$1299.Metal4 5.44828e-07f
Cred_4243 vdd.$2399.Metal1 vout.$1313.Metal4 0.00338709f
Cred_4244 vdd.$2399.Metal1 vout.$1328.Metal4 6.32544e-11f
Cred_4245 vdd.$2399.Metal1 vout.$1329.Metal4 6.8139e-11f
Cred_4246 vdd.$2399.Metal1 vout.$1330.Metal4 8.9668e-11f
Cred_4247 vdd.$2399.Metal1 vout.$1331.Metal4 1.13819e-10f
Cred_4248 vdd.$2399.Metal1 vout.$1332.Metal4 1.76464e-10f
Cred_4249 vdd.$2399.Metal1 vout.$156.Metal1 5.34697e-06f
Cred_4250 vdd.$2399.Metal1 vout.$157.Metal1 5.75987e-06f
Cred_4251 vdd.$2399.Metal1 vout.$158.Metal1 7.57974e-06f
Cred_4252 vdd.$2399.Metal1 vout.$159.Metal1 9.62123e-06f
Cred_4253 vdd.$2399.Metal1 vout.$160.Metal1 1.49167e-05f
Cred_4254 vdd.$2399.Metal1 vout.$161.Metal1 1.62727e-05f
Cred_4255 vdd.$2399.Metal1 vout.$162.Metal1 2.0904e-05f
Cred_4256 vdd.$2399.Metal1 vout.$163.Metal1 2.69217e-05f
Cred_4257 vdd.$2399.Metal1 vout.$164.Metal1 3.47249e-05f
Cred_4258 vdd.$2399.Metal1 vout.$165.Metal1 4.48311e-05f
Cred_4259 vdd.$2399.Metal1 vout.$584.Metal2 3.29666e-08f
Cred_4260 vdd.$2399.Metal1 vout.$586.Metal2 3.55123e-08f
Cred_4261 vdd.$2399.Metal1 vout.$588.Metal2 4.67326e-08f
Cred_4262 vdd.$2399.Metal1 vout.$590.Metal2 5.93193e-08f
Cred_4263 vdd.$2399.Metal1 vout.$592.Metal2 9.19686e-08f
Cred_4264 vdd.$2399.Metal1 vout.$594.Metal2 1.00202e-07f
Cred_4265 vdd.$2399.Metal1 vout.$596.Metal2 1.28719e-07f
Cred_4266 vdd.$2399.Metal1 vout.$598.Metal2 1.65774e-07f
Cred_4267 vdd.$2399.Metal1 vout.$600.Metal2 2.13823e-07f
Cred_4268 vdd.$2399.Metal1 vout.$602.Metal2 2.76054e-07f
Cred_4269 vdd.$2399.Metal1 vout.$604.Metal2 1.06457e-11f
Cred_4270 vdd.$2399.Metal1 vout.$606.Metal2 1.14677e-11f
Cred_4271 vdd.$2399.Metal1 vout.$608.Metal2 1.5091e-11f
Cred_4272 vdd.$2399.Metal1 vout.$610.Metal2 1.91556e-11f
Cred_4273 vdd.$2399.Metal1 vout.$612.Metal2 2.96988e-11f
Cred_4274 vdd.$2399.Metal1 vout.P0.GatPoly 3.48961e-05f
Cred_4275 vdd.$2399.Metal1 vref 0.00194864f
Cred_4276 vdd.$2399.Metal1 vref.P0.GatPoly 8.84245e-06f
Cred_4277 vdd.$2399.Metal1 vref.P0.nSD 1.19673e-05f
Cred_4278 vdd.$2399.Metal1 vref.P0.pSD 2.96129e-05f
Cred_4279 vdd.$2399.Metal1 vss 0.00666377f
Cred_4280 vdd.$2399.Metal1 vss.$1212.Metal5 0.00687239f
Cred_4281 vdd.$2399.Metal1 vss.$1230.Metal5 0.00687239f
Cred_4282 vdd.$2399.Metal1 vss.$1282.Metal5 0.0267398f
Cred_4283 vdd.$2399.Metal1 vss.$1300.Metal5 0.0263803f
Cred_4284 vdd.$2745.Metal2 vss.$1282.Metal5 0.0198206f
Cred_4285 vdd.$2747.Metal2 vout.$1032.Metal3 0.00307846f
Cred_4286 vdd.$2747.Metal2 vout.$1072.Metal3 0.0016912f
Cred_4287 vdd.$2747.Metal2 vout.$1112.Metal3 0.00223549f
Cred_4288 vdd.$2747.Metal2 vout.$1152.Metal3 0.00518899f
Cred_4289 vdd.$2747.Metal2 vout.$1328.Metal4 0.000168898f
Cred_4290 vdd.$2747.Metal2 vout.$1368.Metal4 0.00149326f
Cred_4291 vdd.$2747.Metal2 vout.$1408.Metal4 0.00315241f
Cred_4292 vdd.$2747.Metal2 vout.$156.Metal1 5.35654e-05f
Cred_4293 vdd.$2747.Metal2 vout.$206.Metal1 2.9329e-05f
Cred_4294 vdd.$2747.Metal2 vout.$226.Metal1 3.11065e-06f
Cred_4295 vdd.$2747.Metal2 vout.$326.Metal1 3.85272e-06f
Cred_4296 vdd.$2747.Metal2 vout.$346.Metal1 3.13033e-05f
Cred_4297 vdd.$2747.Metal2 vout.$396.Metal1 7.02896e-05f
Cred_4298 vdd.$2747.Metal2 vout.$584.Metal2 0.00596135f
Cred_4299 vdd.$2747.Metal2 vout.$604.Metal2 0.004908f
Cred_4300 vdd.$2747.Metal2 vout.$644.Metal2 0.00501652f
Cred_4301 vdd.$2747.Metal2 vout.$664.Metal2 0.00348907f
Cred_4302 vdd.$2747.Metal2 vout.$684.Metal2 0.00316751f
Cred_4303 vdd.$2747.Metal2 vout.$704.Metal2 0.00332244f
Cred_4304 vdd.$2747.Metal2 vout.$724.Metal2 0.0052135f
Cred_4305 vdd.$2747.Metal2 vout.$764.Metal2 0.00557234f
Cred_4306 vdd.$2747.Metal2 vout.$784.Metal2 0.00757349f
Cred_4307 vdd.$2747.Metal2 vss.$1282.Metal5 0.0834441f
Cred_4308 vdd.$2749.Metal2 vout.$1032.Metal3 0.0078653f
Cred_4309 vdd.$2749.Metal2 vout.$1072.Metal3 0.00449032f
Cred_4310 vdd.$2749.Metal2 vout.$1112.Metal3 0.00421022f
Cred_4311 vdd.$2749.Metal2 vout.$1152.Metal3 0.0104443f
Cred_4312 vdd.$2749.Metal2 vout.$1328.Metal4 0.00380284f
Cred_4313 vdd.$2749.Metal2 vout.$1368.Metal4 0.00290911f
Cred_4314 vdd.$2749.Metal2 vout.$1408.Metal4 0.0039049f
Cred_4315 vdd.$2749.Metal2 vout.$156.Metal1 0.014003f
Cred_4316 vdd.$2749.Metal2 vout.$206.Metal1 0.0129322f
Cred_4317 vdd.$2749.Metal2 vout.$226.Metal1 0.0098368f
Cred_4318 vdd.$2749.Metal2 vout.$266.Metal1 0.00995522f
Cred_4319 vdd.$2749.Metal2 vout.$286.Metal1 0.010177f
Cred_4320 vdd.$2749.Metal2 vout.$326.Metal1 0.0104048f
Cred_4321 vdd.$2749.Metal2 vout.$346.Metal1 0.0142546f
Cred_4322 vdd.$2749.Metal2 vout.$396.Metal1 0.0161307f
Cred_4323 vdd.$2749.Metal2 vout.$584.Metal2 0.0231417f
Cred_4324 vdd.$2749.Metal2 vout.$604.Metal2 0.0189578f
Cred_4325 vdd.$2749.Metal2 vout.$644.Metal2 0.0193128f
Cred_4326 vdd.$2749.Metal2 vout.$664.Metal2 0.0130414f
Cred_4327 vdd.$2749.Metal2 vout.$684.Metal2 0.0142782f
Cred_4328 vdd.$2749.Metal2 vout.$704.Metal2 0.0159238f
Cred_4329 vdd.$2749.Metal2 vout.$724.Metal2 0.0253815f
Cred_4330 vdd.$2749.Metal2 vout.$764.Metal2 0.026582f
Cred_4331 vdd.$2749.Metal2 vout.$784.Metal2 0.0352141f
Cred_4332 vdd.$2749.Metal2 vout.P0.pSD 0.000369426f
Cred_4333 vdd.$2749.Metal2 vss.$1282.Metal5 0.0296465f
Cred_4334 vdd.$2751.Metal2 vout.$1032.Metal3 0.00424466f
Cred_4335 vdd.$2751.Metal2 vout.$1034.Metal3 0.000836247f
Cred_4336 vdd.$2751.Metal2 vout.$1072.Metal3 0.00236412f
Cred_4337 vdd.$2751.Metal2 vout.$1074.Metal3 0.000460095f
Cred_4338 vdd.$2751.Metal2 vout.$1112.Metal3 0.00244597f
Cred_4339 vdd.$2751.Metal2 vout.$1114.Metal3 0.00049122f
Cred_4340 vdd.$2751.Metal2 vout.$1152.Metal3 0.00601397f
Cred_4341 vdd.$2751.Metal2 vout.$1154.Metal3 0.00118892f
Cred_4342 vdd.$2751.Metal2 vout.$1328.Metal4 0.00199249f
Cred_4343 vdd.$2751.Metal2 vout.$1329.Metal4 0.000233624f
Cred_4344 vdd.$2751.Metal2 vout.$1368.Metal4 0.00204359f
Cred_4345 vdd.$2751.Metal2 vout.$1369.Metal4 0.00149923f
Cred_4346 vdd.$2751.Metal2 vout.$1408.Metal4 0.00367163f
Cred_4347 vdd.$2751.Metal2 vout.$156.Metal1 0.00840519f
Cred_4348 vdd.$2751.Metal2 vout.$157.Metal1 0.00190256f
Cred_4349 vdd.$2751.Metal2 vout.$206.Metal1 0.0077551f
Cred_4350 vdd.$2751.Metal2 vout.$207.Metal1 0.00174854f
Cred_4351 vdd.$2751.Metal2 vout.$226.Metal1 0.00589945f
Cred_4352 vdd.$2751.Metal2 vout.$227.Metal1 0.00129769f
Cred_4353 vdd.$2751.Metal2 vout.$266.Metal1 0.00597354f
Cred_4354 vdd.$2751.Metal2 vout.$267.Metal1 0.00134428f
Cred_4355 vdd.$2751.Metal2 vout.$286.Metal1 0.00613589f
Cred_4356 vdd.$2751.Metal2 vout.$287.Metal1 0.00137848f
Cred_4357 vdd.$2751.Metal2 vout.$326.Metal1 0.00627601f
Cred_4358 vdd.$2751.Metal2 vout.$327.Metal1 0.00140936f
Cred_4359 vdd.$2751.Metal2 vout.$346.Metal1 0.00858268f
Cred_4360 vdd.$2751.Metal2 vout.$347.Metal1 0.00194477f
Cred_4361 vdd.$2751.Metal2 vout.$396.Metal1 0.00969741f
Cred_4362 vdd.$2751.Metal2 vout.$397.Metal1 0.00220127f
Cred_4363 vdd.$2751.Metal2 vout.$584.Metal2 0.0137023f
Cred_4364 vdd.$2751.Metal2 vout.$586.Metal2 0.00310587f
Cred_4365 vdd.$2751.Metal2 vout.$604.Metal2 0.0111984f
Cred_4366 vdd.$2751.Metal2 vout.$606.Metal2 0.00257725f
Cred_4367 vdd.$2751.Metal2 vout.$644.Metal2 0.0114096f
Cred_4368 vdd.$2751.Metal2 vout.$646.Metal2 0.00262727f
Cred_4369 vdd.$2751.Metal2 vout.$664.Metal2 0.0078212f
Cred_4370 vdd.$2751.Metal2 vout.$666.Metal2 0.00183347f
Cred_4371 vdd.$2751.Metal2 vout.$684.Metal2 0.00858017f
Cred_4372 vdd.$2751.Metal2 vout.$686.Metal2 0.00199166f
Cred_4373 vdd.$2751.Metal2 vout.$704.Metal2 0.00949298f
Cred_4374 vdd.$2751.Metal2 vout.$706.Metal2 0.00216345f
Cred_4375 vdd.$2751.Metal2 vout.$724.Metal2 0.0150651f
Cred_4376 vdd.$2751.Metal2 vout.$726.Metal2 0.00338152f
Cred_4377 vdd.$2751.Metal2 vout.$764.Metal2 0.0158422f
Cred_4378 vdd.$2751.Metal2 vout.$766.Metal2 0.00360801f
Cred_4379 vdd.$2751.Metal2 vout.$784.Metal2 0.0228126f
Cred_4380 vdd.$2751.Metal2 vout.$786.Metal2 0.00479287f
Cred_4381 vdd.$2751.Metal2 vout.P0.pSD 0.00229506f
Cred_4382 vdd.$2751.Metal2 vout.P2.pSD 5.04248e-05f
Cred_4383 vdd.$2751.Metal2 vss.$1282.Metal5 0.019346f
Cred_4384 vdd.$2755.Metal2 vout.$1032.Metal3 0.00659691f
Cred_4385 vdd.$2755.Metal2 vout.$1034.Metal3 0.00781663f
Cred_4386 vdd.$2755.Metal2 vout.$1072.Metal3 0.00319044f
Cred_4387 vdd.$2755.Metal2 vout.$1074.Metal3 0.00430063f
Cred_4388 vdd.$2755.Metal2 vout.$1112.Metal3 0.00533341f
Cred_4389 vdd.$2755.Metal2 vout.$1114.Metal3 0.00459157f
Cred_4390 vdd.$2755.Metal2 vout.$1152.Metal3 0.012354f
Cred_4391 vdd.$2755.Metal2 vout.$1154.Metal3 0.0111339f
Cred_4392 vdd.$2755.Metal2 vout.$1328.Metal4 0.00217865f
Cred_4393 vdd.$2755.Metal2 vout.$1329.Metal4 0.00218375f
Cred_4394 vdd.$2755.Metal2 vout.$1368.Metal4 0.00646104f
Cred_4395 vdd.$2755.Metal2 vout.$1369.Metal4 0.0159889f
Cred_4396 vdd.$2755.Metal2 vout.$1408.Metal4 0.0117398f
Cred_4397 vdd.$2755.Metal2 vout.$156.Metal1 0.0178135f
Cred_4398 vdd.$2755.Metal2 vout.$157.Metal1 0.0177838f
Cred_4399 vdd.$2755.Metal2 vout.$206.Metal1 0.0163757f
Cred_4400 vdd.$2755.Metal2 vout.$207.Metal1 0.0163441f
Cred_4401 vdd.$2755.Metal2 vout.$226.Metal1 0.0124551f
Cred_4402 vdd.$2755.Metal2 vout.$227.Metal1 0.0121299f
Cred_4403 vdd.$2755.Metal2 vout.$266.Metal1 0.0126326f
Cred_4404 vdd.$2755.Metal2 vout.$267.Metal1 0.0125654f
Cred_4405 vdd.$2755.Metal2 vout.$286.Metal1 0.0131877f
Cred_4406 vdd.$2755.Metal2 vout.$287.Metal1 0.012885f
Cred_4407 vdd.$2755.Metal2 vout.$326.Metal1 0.0135102f
Cred_4408 vdd.$2755.Metal2 vout.$327.Metal1 0.0131737f
Cred_4409 vdd.$2755.Metal2 vout.$346.Metal1 0.0183731f
Cred_4410 vdd.$2755.Metal2 vout.$347.Metal1 0.0181783f
Cred_4411 vdd.$2755.Metal2 vout.$396.Metal1 0.0203482f
Cred_4412 vdd.$2755.Metal2 vout.$397.Metal1 0.0206015f
Cred_4413 vdd.$2755.Metal2 vout.$584.Metal2 0.0296913f
Cred_4414 vdd.$2755.Metal2 vout.$586.Metal2 0.0290314f
Cred_4415 vdd.$2755.Metal2 vout.$604.Metal2 0.0240828f
Cred_4416 vdd.$2755.Metal2 vout.$606.Metal2 0.0240903f
Cred_4417 vdd.$2755.Metal2 vout.$644.Metal2 0.0245537f
Cred_4418 vdd.$2755.Metal2 vout.$646.Metal2 0.0245578f
Cred_4419 vdd.$2755.Metal2 vout.$664.Metal2 0.0177051f
Cred_4420 vdd.$2755.Metal2 vout.$666.Metal2 0.0171379f
Cred_4421 vdd.$2755.Metal2 vout.$684.Metal2 0.0193221f
Cred_4422 vdd.$2755.Metal2 vout.$686.Metal2 0.0186166f
Cred_4423 vdd.$2755.Metal2 vout.$704.Metal2 0.0207654f
Cred_4424 vdd.$2755.Metal2 vout.$706.Metal2 0.0202224f
Cred_4425 vdd.$2755.Metal2 vout.$724.Metal2 0.0324525f
Cred_4426 vdd.$2755.Metal2 vout.$726.Metal2 0.031608f
Cred_4427 vdd.$2755.Metal2 vout.$764.Metal2 0.0346246f
Cred_4428 vdd.$2755.Metal2 vout.$766.Metal2 0.0337255f
Cred_4429 vdd.$2755.Metal2 vout.$784.Metal2 0.0471274f
Cred_4430 vdd.$2755.Metal2 vout.$786.Metal2 0.0460903f
Cred_4431 vdd.$2755.Metal2 vout.P0.pSD 0.00114688f
Cred_4432 vdd.$2755.Metal2 vout.P2.pSD 0.0017867f
Cred_4433 vdd.$2755.Metal2 vss.$1282.Metal5 0.0230837f
Cred_4434 vdd.$2759.Metal2 vout.$1034.Metal3 0.00475265f
Cred_4435 vdd.$2759.Metal2 vout.$1036.Metal3 0.00613148f
Cred_4436 vdd.$2759.Metal2 vout.$1074.Metal3 0.00250269f
Cred_4437 vdd.$2759.Metal2 vout.$1076.Metal3 0.00248013f
Cred_4438 vdd.$2759.Metal2 vout.$1096.Metal3 0.00371385f
Cred_4439 vdd.$2759.Metal2 vout.$1114.Metal3 0.00357648f
Cred_4440 vdd.$2759.Metal2 vout.$1154.Metal3 0.00860172f
Cred_4441 vdd.$2759.Metal2 vout.$1156.Metal3 0.00957464f
Cred_4442 vdd.$2759.Metal2 vout.$1329.Metal4 0.00165698f
Cred_4443 vdd.$2759.Metal2 vout.$1330.Metal4 0.00171305f
Cred_4444 vdd.$2759.Metal2 vout.$1369.Metal4 0.0130005f
Cred_4445 vdd.$2759.Metal2 vout.$1370.Metal4 0.0109319f
Cred_4446 vdd.$2759.Metal2 vout.$157.Metal1 0.0139738f
Cred_4447 vdd.$2759.Metal2 vout.$158.Metal1 0.0137543f
Cred_4448 vdd.$2759.Metal2 vout.$207.Metal1 0.0128465f
Cred_4449 vdd.$2759.Metal2 vout.$208.Metal1 0.0124458f
Cred_4450 vdd.$2759.Metal2 vout.$227.Metal1 0.0100174f
Cred_4451 vdd.$2759.Metal2 vout.$228.Metal1 0.00942707f
Cred_4452 vdd.$2759.Metal2 vout.$267.Metal1 0.00994046f
Cred_4453 vdd.$2759.Metal2 vout.$268.Metal1 0.00941587f
Cred_4454 vdd.$2759.Metal2 vout.$287.Metal1 0.0103455f
Cred_4455 vdd.$2759.Metal2 vout.$288.Metal1 0.0101784f
Cred_4456 vdd.$2759.Metal2 vout.$327.Metal1 0.0105985f
Cred_4457 vdd.$2759.Metal2 vout.$328.Metal1 0.0103345f
Cred_4458 vdd.$2759.Metal2 vout.$347.Metal1 0.0144134f
Cred_4459 vdd.$2759.Metal2 vout.$348.Metal1 0.0142605f
Cred_4460 vdd.$2759.Metal2 vout.$397.Metal1 0.0159755f
Cred_4461 vdd.$2759.Metal2 vout.$398.Metal1 0.0164132f
Cred_4462 vdd.$2759.Metal2 vout.$586.Metal2 0.0232492f
Cred_4463 vdd.$2759.Metal2 vout.$588.Metal2 0.0227387f
Cred_4464 vdd.$2759.Metal2 vout.$606.Metal2 0.018884f
Cred_4465 vdd.$2759.Metal2 vout.$608.Metal2 0.0188967f
Cred_4466 vdd.$2759.Metal2 vout.$646.Metal2 0.019263f
Cred_4467 vdd.$2759.Metal2 vout.$648.Metal2 0.0192647f
Cred_4468 vdd.$2759.Metal2 vout.$666.Metal2 0.0134452f
Cred_4469 vdd.$2759.Metal2 vout.$668.Metal2 0.0205921f
Cred_4470 vdd.$2759.Metal2 vout.$686.Metal2 0.0148063f
Cred_4471 vdd.$2759.Metal2 vout.$706.Metal2 0.0162901f
Cred_4472 vdd.$2759.Metal2 vout.$708.Metal2 0.0230494f
Cred_4473 vdd.$2759.Metal2 vout.$726.Metal2 0.0254578f
Cred_4474 vdd.$2759.Metal2 vout.$728.Metal2 0.024813f
Cred_4475 vdd.$2759.Metal2 vout.$766.Metal2 0.0271531f
Cred_4476 vdd.$2759.Metal2 vout.$768.Metal2 0.0264567f
Cred_4477 vdd.$2759.Metal2 vout.$786.Metal2 0.0375924f
Cred_4478 vdd.$2759.Metal2 vout.$788.Metal2 0.0351466f
Cred_4479 vdd.$2759.Metal2 vout.P2.pSD 0.00168394f
Cred_4480 vdd.$2759.Metal2 vout.P4.pSD 0.000366295f
Cred_4481 vdd.$2759.Metal2 vss.$1282.Metal5 0.0175609f
Cred_4482 vdd.$2761.Metal2 vout.$1034.Metal3 0.00196661f
Cred_4483 vdd.$2761.Metal2 vout.$1036.Metal3 0.00253716f
Cred_4484 vdd.$2761.Metal2 vout.$1074.Metal3 0.0010356f
Cred_4485 vdd.$2761.Metal2 vout.$1076.Metal3 0.00102626f
Cred_4486 vdd.$2761.Metal2 vout.$1096.Metal3 0.00153677f
Cred_4487 vdd.$2761.Metal2 vout.$1114.Metal3 0.00147992f
Cred_4488 vdd.$2761.Metal2 vout.$1154.Metal3 0.00355077f
Cred_4489 vdd.$2761.Metal2 vout.$1156.Metal3 0.00397972f
Cred_4490 vdd.$2761.Metal2 vout.$1329.Metal4 0.000685646f
Cred_4491 vdd.$2761.Metal2 vout.$1330.Metal4 0.000708848f
Cred_4492 vdd.$2761.Metal2 vout.$1369.Metal4 0.00442844f
Cred_4493 vdd.$2761.Metal2 vout.$1370.Metal4 0.00644634f
Cred_4494 vdd.$2761.Metal2 vout.$157.Metal1 0.00578228f
Cred_4495 vdd.$2761.Metal2 vout.$158.Metal1 0.00569145f
Cred_4496 vdd.$2761.Metal2 vout.$207.Metal1 0.00531578f
Cred_4497 vdd.$2761.Metal2 vout.$208.Metal1 0.00514999f
Cred_4498 vdd.$2761.Metal2 vout.$227.Metal1 0.00414513f
Cred_4499 vdd.$2761.Metal2 vout.$228.Metal1 0.00390085f
Cred_4500 vdd.$2761.Metal2 vout.$267.Metal1 0.00411329f
Cred_4501 vdd.$2761.Metal2 vout.$268.Metal1 0.00389622f
Cred_4502 vdd.$2761.Metal2 vout.$287.Metal1 0.00428088f
Cred_4503 vdd.$2761.Metal2 vout.$288.Metal1 0.00421174f
Cred_4504 vdd.$2761.Metal2 vout.$327.Metal1 0.00438558f
Cred_4505 vdd.$2761.Metal2 vout.$328.Metal1 0.00427636f
Cred_4506 vdd.$2761.Metal2 vout.$347.Metal1 0.00596415f
Cred_4507 vdd.$2761.Metal2 vout.$348.Metal1 0.00590091f
Cred_4508 vdd.$2761.Metal2 vout.$397.Metal1 0.00659994f
Cred_4509 vdd.$2761.Metal2 vout.$398.Metal1 0.00681376f
Cred_4510 vdd.$2761.Metal2 vout.$586.Metal2 0.00962038f
Cred_4511 vdd.$2761.Metal2 vout.$588.Metal2 0.00940911f
Cred_4512 vdd.$2761.Metal2 vout.$606.Metal2 0.00781409f
Cred_4513 vdd.$2761.Metal2 vout.$608.Metal2 0.00781934f
Cred_4514 vdd.$2761.Metal2 vout.$646.Metal2 0.00797092f
Cred_4515 vdd.$2761.Metal2 vout.$648.Metal2 0.0079716f
Cred_4516 vdd.$2761.Metal2 vout.$666.Metal2 0.00556352f
Cred_4517 vdd.$2761.Metal2 vout.$668.Metal2 0.00852087f
Cred_4518 vdd.$2761.Metal2 vout.$686.Metal2 0.00612676f
Cred_4519 vdd.$2761.Metal2 vout.$706.Metal2 0.00674073f
Cred_4520 vdd.$2761.Metal2 vout.$708.Metal2 0.00953767f
Cred_4521 vdd.$2761.Metal2 vout.$726.Metal2 0.0105342f
Cred_4522 vdd.$2761.Metal2 vout.$728.Metal2 0.0102675f
Cred_4523 vdd.$2761.Metal2 vout.$766.Metal2 0.0112356f
Cred_4524 vdd.$2761.Metal2 vout.$768.Metal2 0.010948f
Cred_4525 vdd.$2761.Metal2 vout.$786.Metal2 0.0150217f
Cred_4526 vdd.$2761.Metal2 vout.$788.Metal2 0.0156529f
Cred_4527 vdd.$2761.Metal2 vout.P2.pSD 0.000152514f
Cred_4528 vdd.$2761.Metal2 vout.P4.pSD 0.00152538f
Cred_4529 vdd.$2761.Metal2 vss.$1282.Metal5 0.00955567f
Cred_4530 vdd.$2763.Metal2 vout.$1036.Metal3 0.00147429f
Cred_4531 vdd.$2763.Metal2 vout.$1038.Metal3 0.00177041f
Cred_4532 vdd.$2763.Metal2 vout.$1076.Metal3 0.000560241f
Cred_4533 vdd.$2763.Metal2 vout.$1078.Metal3 0.00104748f
Cred_4534 vdd.$2763.Metal2 vout.$1096.Metal3 0.00106396f
Cred_4535 vdd.$2763.Metal2 vout.$1118.Metal3 0.00111834f
Cred_4536 vdd.$2763.Metal2 vout.$1156.Metal3 0.00297765f
Cred_4537 vdd.$2763.Metal2 vout.$1158.Metal3 0.00270676f
Cred_4538 vdd.$2763.Metal2 vout.$1330.Metal4 0.000514453f
Cred_4539 vdd.$2763.Metal2 vout.$1331.Metal4 0.000531881f
Cred_4540 vdd.$2763.Metal2 vout.$1370.Metal4 0.00522687f
Cred_4541 vdd.$2763.Metal2 vout.$1371.Metal4 0.0033337f
Cred_4542 vdd.$2763.Metal2 vout.$158.Metal1 0.00439942f
Cred_4543 vdd.$2763.Metal2 vout.$159.Metal1 0.00433147f
Cred_4544 vdd.$2763.Metal2 vout.$208.Metal1 0.00410406f
Cred_4545 vdd.$2763.Metal2 vout.$209.Metal1 0.00398199f
Cred_4546 vdd.$2763.Metal2 vout.$228.Metal1 0.00314085f
Cred_4547 vdd.$2763.Metal2 vout.$229.Metal1 0.0030311f
Cred_4548 vdd.$2763.Metal2 vout.$268.Metal1 0.00327394f
Cred_4549 vdd.$2763.Metal2 vout.$269.Metal1 0.00306991f
Cred_4550 vdd.$2763.Metal2 vout.$288.Metal1 0.00323463f
Cred_4551 vdd.$2763.Metal2 vout.$289.Metal1 0.00313832f
Cred_4552 vdd.$2763.Metal2 vout.$328.Metal1 0.00329059f
Cred_4553 vdd.$2763.Metal2 vout.$329.Metal1 0.00320863f
Cred_4554 vdd.$2763.Metal2 vout.$348.Metal1 0.00447501f
Cred_4555 vdd.$2763.Metal2 vout.$349.Metal1 0.00442757f
Cred_4556 vdd.$2763.Metal2 vout.$398.Metal1 0.00498194f
Cred_4557 vdd.$2763.Metal2 vout.$399.Metal1 0.00501152f
Cred_4558 vdd.$2763.Metal2 vout.$588.Metal2 0.00721942f
Cred_4559 vdd.$2763.Metal2 vout.$590.Metal2 0.00707098f
Cred_4560 vdd.$2763.Metal2 vout.$608.Metal2 0.00579894f
Cred_4561 vdd.$2763.Metal2 vout.$610.Metal2 0.00593212f
Cred_4562 vdd.$2763.Metal2 vout.$648.Metal2 0.00591626f
Cred_4563 vdd.$2763.Metal2 vout.$650.Metal2 0.00604634f
Cred_4564 vdd.$2763.Metal2 vout.$668.Metal2 0.00642658f
Cred_4565 vdd.$2763.Metal2 vout.$670.Metal2 0.00417429f
Cred_4566 vdd.$2763.Metal2 vout.$690.Metal2 0.00453432f
Cred_4567 vdd.$2763.Metal2 vout.$708.Metal2 0.00732059f
Cred_4568 vdd.$2763.Metal2 vout.$710.Metal2 0.00492543f
Cred_4569 vdd.$2763.Metal2 vout.$728.Metal2 0.00790971f
Cred_4570 vdd.$2763.Metal2 vout.$730.Metal2 0.00769854f
Cred_4571 vdd.$2763.Metal2 vout.$768.Metal2 0.0084309f
Cred_4572 vdd.$2763.Metal2 vout.$770.Metal2 0.00821419f
Cred_4573 vdd.$2763.Metal2 vout.$788.Metal2 0.0127728f
Cred_4574 vdd.$2763.Metal2 vout.$790.Metal2 0.0109117f
Cred_4575 vdd.$2763.Metal2 vout.P4.pSD 0.00149779f
Cred_4576 vdd.$2763.Metal2 vout.P6.pSD 0.000114905f
Cred_4577 vdd.$2763.Metal2 vss.$1282.Metal5 0.00835377f
Cred_4578 vdd.$2765.Metal2 vout.$1036.Metal3 0.00524193f
Cred_4579 vdd.$2765.Metal2 vout.$1038.Metal3 0.00629478f
Cred_4580 vdd.$2765.Metal2 vout.$1076.Metal3 0.00199197f
Cred_4581 vdd.$2765.Metal2 vout.$1078.Metal3 0.00372436f
Cred_4582 vdd.$2765.Metal2 vout.$1096.Metal3 0.00378296f
Cred_4583 vdd.$2765.Metal2 vout.$1118.Metal3 0.00397631f
Cred_4584 vdd.$2765.Metal2 vout.$1156.Metal3 0.0104776f
Cred_4585 vdd.$2765.Metal2 vout.$1158.Metal3 0.00962403f
Cred_4586 vdd.$2765.Metal2 vout.$1330.Metal4 0.00182917f
Cred_4587 vdd.$2765.Metal2 vout.$1331.Metal4 0.00189113f
Cred_4588 vdd.$2765.Metal2 vout.$1370.Metal4 0.0121144f
Cred_4589 vdd.$2765.Metal2 vout.$1371.Metal4 0.0131395f
Cred_4590 vdd.$2765.Metal2 vout.$158.Metal1 0.0156424f
Cred_4591 vdd.$2765.Metal2 vout.$159.Metal1 0.0154008f
Cred_4592 vdd.$2765.Metal2 vout.$208.Metal1 0.0145922f
Cred_4593 vdd.$2765.Metal2 vout.$209.Metal1 0.0141582f
Cred_4594 vdd.$2765.Metal2 vout.$228.Metal1 0.0111675f
Cred_4595 vdd.$2765.Metal2 vout.$229.Metal1 0.0107772f
Cred_4596 vdd.$2765.Metal2 vout.$268.Metal1 0.0116407f
Cred_4597 vdd.$2765.Metal2 vout.$269.Metal1 0.0109152f
Cred_4598 vdd.$2765.Metal2 vout.$288.Metal1 0.0115009f
Cred_4599 vdd.$2765.Metal2 vout.$289.Metal1 0.0111585f
Cred_4600 vdd.$2765.Metal2 vout.$328.Metal1 0.0116999f
Cred_4601 vdd.$2765.Metal2 vout.$329.Metal1 0.0114085f
Cred_4602 vdd.$2765.Metal2 vout.$348.Metal1 0.0159112f
Cred_4603 vdd.$2765.Metal2 vout.$349.Metal1 0.0157425f
Cred_4604 vdd.$2765.Metal2 vout.$398.Metal1 0.0176073f
Cred_4605 vdd.$2765.Metal2 vout.$399.Metal1 0.0178187f
Cred_4606 vdd.$2765.Metal2 vout.$588.Metal2 0.025669f
Cred_4607 vdd.$2765.Metal2 vout.$590.Metal2 0.0251413f
Cred_4608 vdd.$2765.Metal2 vout.$608.Metal2 0.0206185f
Cred_4609 vdd.$2765.Metal2 vout.$610.Metal2 0.021092f
Cred_4610 vdd.$2765.Metal2 vout.$648.Metal2 0.0210356f
Cred_4611 vdd.$2765.Metal2 vout.$650.Metal2 0.0214981f
Cred_4612 vdd.$2765.Metal2 vout.$668.Metal2 0.0228501f
Cred_4613 vdd.$2765.Metal2 vout.$670.Metal2 0.0148419f
Cred_4614 vdd.$2765.Metal2 vout.$690.Metal2 0.016122f
Cred_4615 vdd.$2765.Metal2 vout.$708.Metal2 0.0260288f
Cred_4616 vdd.$2765.Metal2 vout.$710.Metal2 0.0175126f
Cred_4617 vdd.$2765.Metal2 vout.$728.Metal2 0.0281234f
Cred_4618 vdd.$2765.Metal2 vout.$730.Metal2 0.0273726f
Cred_4619 vdd.$2765.Metal2 vout.$768.Metal2 0.0299743f
Cred_4620 vdd.$2765.Metal2 vout.$770.Metal2 0.029206f
Cred_4621 vdd.$2765.Metal2 vout.$788.Metal2 0.0400748f
Cred_4622 vdd.$2765.Metal2 vout.$790.Metal2 0.0387971f
Cred_4623 vdd.$2765.Metal2 vout.P4.pSD 0.00041077f
Cred_4624 vdd.$2765.Metal2 vout.P6.pSD 0.000408551f
Cred_4625 vdd.$2765.Metal2 vss.$1282.Metal5 0.0149868f
Cred_4626 vdd.$2767.Metal2 vout.$1158.Metal3 5.36124e-05f
Cred_4627 vdd.$2767.Metal2 vout.$1371.Metal4 0.00154232f
Cred_4628 vdd.$2767.Metal2 vout.$399.Metal1 5.19732e-05f
Cred_4629 vdd.$2767.Metal2 vout.$770.Metal2 1.07463e-06f
Cred_4630 vdd.$2767.Metal2 vout.$790.Metal2 0.00261169f
Cred_4631 vdd.$2767.Metal2 vout.P6.pSD 0.00276903f
Cred_4632 vdd.$2767.Metal2 vss.$1282.Metal5 0.00553246f
Cred_4633 vdd.$2769.Metal2 vout.$1038.Metal3 0.00536182f
Cred_4634 vdd.$2769.Metal2 vout.$1040.Metal3 0.00540722f
Cred_4635 vdd.$2769.Metal2 vout.$1078.Metal3 0.00258932f
Cred_4636 vdd.$2769.Metal2 vout.$1080.Metal3 0.00398667f
Cred_4637 vdd.$2769.Metal2 vout.$1118.Metal3 0.00370028f
Cred_4638 vdd.$2769.Metal2 vout.$1140.Metal3 0.00477737f
Cred_4639 vdd.$2769.Metal2 vout.$1158.Metal3 0.00887806f
Cred_4640 vdd.$2769.Metal2 vout.$1180.Metal3 0.00745175f
Cred_4641 vdd.$2769.Metal2 vout.$1331.Metal4 0.00171433f
Cred_4642 vdd.$2769.Metal2 vout.$1332.Metal4 0.00174298f
Cred_4643 vdd.$2769.Metal2 vout.$1371.Metal4 0.0125196f
Cred_4644 vdd.$2769.Metal2 vout.$1372.Metal4 0.011007f
Cred_4645 vdd.$2769.Metal2 vout.$159.Metal1 0.0144575f
Cred_4646 vdd.$2769.Metal2 vout.$160.Metal1 0.0142269f
Cred_4647 vdd.$2769.Metal2 vout.$209.Metal1 0.0132872f
Cred_4648 vdd.$2769.Metal2 vout.$210.Metal1 0.0131652f
Cred_4649 vdd.$2769.Metal2 vout.$229.Metal1 0.0101195f
Cred_4650 vdd.$2769.Metal2 vout.$230.Metal1 0.0101007f
Cred_4651 vdd.$2769.Metal2 vout.$269.Metal1 0.0102711f
Cred_4652 vdd.$2769.Metal2 vout.$270.Metal1 0.01023f
Cred_4653 vdd.$2769.Metal2 vout.$289.Metal1 0.0107051f
Cred_4654 vdd.$2769.Metal2 vout.$290.Metal1 0.010458f
Cred_4655 vdd.$2769.Metal2 vout.$329.Metal1 0.0109654f
Cred_4656 vdd.$2769.Metal2 vout.$330.Metal1 0.0106733f
Cred_4657 vdd.$2769.Metal2 vout.$349.Metal1 0.0149123f
Cred_4658 vdd.$2769.Metal2 vout.$350.Metal1 0.0146f
Cred_4659 vdd.$2769.Metal2 vout.$399.Metal1 0.0165019f
Cred_4660 vdd.$2769.Metal2 vout.$400.Metal1 0.0170105f
Cred_4661 vdd.$2769.Metal2 vout.$590.Metal2 0.024054f
Cred_4662 vdd.$2769.Metal2 vout.$592.Metal2 0.0235993f
Cred_4663 vdd.$2769.Metal2 vout.$610.Metal2 0.0193224f
Cred_4664 vdd.$2769.Metal2 vout.$612.Metal2 0.0193265f
Cred_4665 vdd.$2769.Metal2 vout.$650.Metal2 0.0197134f
Cred_4666 vdd.$2769.Metal2 vout.$652.Metal2 0.0201462f
Cred_4667 vdd.$2769.Metal2 vout.$670.Metal2 0.0139103f
Cred_4668 vdd.$2769.Metal2 vout.$672.Metal2 0.0140497f
Cred_4669 vdd.$2769.Metal2 vout.$690.Metal2 0.0153189f
Cred_4670 vdd.$2769.Metal2 vout.$692.Metal2 0.0151264f
Cred_4671 vdd.$2769.Metal2 vout.$710.Metal2 0.016854f
Cred_4672 vdd.$2769.Metal2 vout.$712.Metal2 0.0164475f
Cred_4673 vdd.$2769.Metal2 vout.$730.Metal2 0.026339f
Cred_4674 vdd.$2769.Metal2 vout.$732.Metal2 0.0169798f
Cred_4675 vdd.$2769.Metal2 vout.$752.Metal2 0.017671f
Cred_4676 vdd.$2769.Metal2 vout.$770.Metal2 0.0280926f
Cred_4677 vdd.$2769.Metal2 vout.$772.Metal2 0.018601f
Cred_4678 vdd.$2769.Metal2 vout.$790.Metal2 0.0375589f
Cred_4679 vdd.$2769.Metal2 vout.$792.Metal2 0.0361512f
Cred_4680 vdd.$2769.Metal2 vout.P6.pSD 0.000381053f
Cred_4681 vdd.$2769.Metal2 vout.P8.pSD 0.000379401f
Cred_4682 vdd.$2769.Metal2 vss.$1282.Metal5 0.0146826f
Cred_4683 vdd.$2771.Metal2 vout.$1038.Metal3 0.001966f
Cred_4684 vdd.$2771.Metal2 vout.$1040.Metal3 0.00198265f
Cred_4685 vdd.$2771.Metal2 vout.$1078.Metal3 0.000949417f
Cred_4686 vdd.$2771.Metal2 vout.$1080.Metal3 0.00146178f
Cred_4687 vdd.$2771.Metal2 vout.$1118.Metal3 0.00135677f
Cred_4688 vdd.$2771.Metal2 vout.$1140.Metal3 0.0017517f
Cred_4689 vdd.$2771.Metal2 vout.$1158.Metal3 0.00325529f
Cred_4690 vdd.$2771.Metal2 vout.$1180.Metal3 0.00276064f
Cred_4691 vdd.$2771.Metal2 vout.$1331.Metal4 0.000628589f
Cred_4692 vdd.$2771.Metal2 vout.$1332.Metal4 0.000639092f
Cred_4693 vdd.$2771.Metal2 vout.$1371.Metal4 0.00405992f
Cred_4694 vdd.$2771.Metal2 vout.$1372.Metal4 0.00592616f
Cred_4695 vdd.$2771.Metal2 vout.$159.Metal1 0.0053011f
Cred_4696 vdd.$2771.Metal2 vout.$160.Metal1 0.00521654f
Cred_4697 vdd.$2771.Metal2 vout.$209.Metal1 0.00487199f
Cred_4698 vdd.$2771.Metal2 vout.$210.Metal1 0.00482725f
Cred_4699 vdd.$2771.Metal2 vout.$229.Metal1 0.00371049f
Cred_4700 vdd.$2771.Metal2 vout.$230.Metal1 0.00370357f
Cred_4701 vdd.$2771.Metal2 vout.$269.Metal1 0.00376608f
Cred_4702 vdd.$2771.Metal2 vout.$270.Metal1 0.00375099f
Cred_4703 vdd.$2771.Metal2 vout.$289.Metal1 0.00392522f
Cred_4704 vdd.$2771.Metal2 vout.$290.Metal1 0.00383458f
Cred_4705 vdd.$2771.Metal2 vout.$329.Metal1 0.00402063f
Cred_4706 vdd.$2771.Metal2 vout.$330.Metal1 0.00391354f
Cred_4707 vdd.$2771.Metal2 vout.$349.Metal1 0.00546783f
Cred_4708 vdd.$2771.Metal2 vout.$350.Metal1 0.00535335f
Cred_4709 vdd.$2771.Metal2 vout.$399.Metal1 0.00605071f
Cred_4710 vdd.$2771.Metal2 vout.$400.Metal1 0.00626188f
Cred_4711 vdd.$2771.Metal2 vout.$590.Metal2 0.00881981f
Cred_4712 vdd.$2771.Metal2 vout.$592.Metal2 0.00865307f
Cred_4713 vdd.$2771.Metal2 vout.$610.Metal2 0.00708487f
Cred_4714 vdd.$2771.Metal2 vout.$612.Metal2 0.00708638f
Cred_4715 vdd.$2771.Metal2 vout.$650.Metal2 0.00722824f
Cred_4716 vdd.$2771.Metal2 vout.$652.Metal2 0.00738695f
Cred_4717 vdd.$2771.Metal2 vout.$670.Metal2 0.00510044f
Cred_4718 vdd.$2771.Metal2 vout.$672.Metal2 0.00515154f
Cred_4719 vdd.$2771.Metal2 vout.$690.Metal2 0.00561692f
Cred_4720 vdd.$2771.Metal2 vout.$692.Metal2 0.00554636f
Cred_4721 vdd.$2771.Metal2 vout.$710.Metal2 0.00617979f
Cred_4722 vdd.$2771.Metal2 vout.$712.Metal2 0.00603074f
Cred_4723 vdd.$2771.Metal2 vout.$730.Metal2 0.00965762f
Cred_4724 vdd.$2771.Metal2 vout.$732.Metal2 0.00622592f
Cred_4725 vdd.$2771.Metal2 vout.$752.Metal2 0.00647938f
Cred_4726 vdd.$2771.Metal2 vout.$770.Metal2 0.0103006f
Cred_4727 vdd.$2771.Metal2 vout.$772.Metal2 0.00682038f
Cred_4728 vdd.$2771.Metal2 vout.$790.Metal2 0.0137716f
Cred_4729 vdd.$2771.Metal2 vout.$792.Metal2 0.0144951f
Cred_4730 vdd.$2771.Metal2 vout.P6.pSD 0.00013972f
Cred_4731 vdd.$2771.Metal2 vout.P8.pSD 0.00153338f
Cred_4732 vdd.$2771.Metal2 vss 0.000407859f
Cred_4733 vdd.$2771.Metal2 vss.$1212.Metal5 0.000420628f
Cred_4734 vdd.$2771.Metal2 vss.$1230.Metal5 0.000420628f
Cred_4735 vdd.$2771.Metal2 vss.$1282.Metal5 0.00621124f
Cred_4736 vdd.$2771.Metal2 vss.$1300.Metal5 0.00161008f
Cred_4737 vdd.$2773.Metal2 vout.$1040.Metal3 0.00171126f
Cred_4738 vdd.$2773.Metal2 vout.$1080.Metal3 0.00115794f
Cred_4739 vdd.$2773.Metal2 vout.$1122.Metal3 0.000243831f
Cred_4740 vdd.$2773.Metal2 vout.$1140.Metal3 0.00156727f
Cred_4741 vdd.$2773.Metal2 vout.$1162.Metal3 0.000594261f
Cred_4742 vdd.$2773.Metal2 vout.$1180.Metal3 0.00244529f
Cred_4743 vdd.$2773.Metal2 vout.$1332.Metal4 0.00057127f
Cred_4744 vdd.$2773.Metal2 vout.$1372.Metal4 0.0102485f
Cred_4745 vdd.$2773.Metal2 vout.$1383.Metal4 2.79794e-05f
Cred_4746 vdd.$2773.Metal2 vout.$160.Metal1 0.00470032f
Cred_4747 vdd.$2773.Metal2 vout.$210.Metal1 0.00426857f
Cred_4748 vdd.$2773.Metal2 vout.$230.Metal1 0.00322296f
Cred_4749 vdd.$2773.Metal2 vout.$270.Metal1 0.00327291f
Cred_4750 vdd.$2773.Metal2 vout.$290.Metal1 0.0034232f
Cred_4751 vdd.$2773.Metal2 vout.$330.Metal1 0.00350069f
Cred_4752 vdd.$2773.Metal2 vout.$331.Metal1 6.04921e-07f
Cred_4753 vdd.$2773.Metal2 vout.$350.Metal1 0.00475212f
Cred_4754 vdd.$2773.Metal2 vout.$351.Metal1 4.91498e-06f
Cred_4755 vdd.$2773.Metal2 vout.$400.Metal1 0.00546222f
Cred_4756 vdd.$2773.Metal2 vout.$401.Metal1 1.08308e-05f
Cred_4757 vdd.$2773.Metal2 vout.$592.Metal2 0.00781454f
Cred_4758 vdd.$2773.Metal2 vout.$612.Metal2 0.00654813f
Cred_4759 vdd.$2773.Metal2 vout.$652.Metal2 0.0065325f
Cred_4760 vdd.$2773.Metal2 vout.$672.Metal2 0.00458226f
Cred_4761 vdd.$2773.Metal2 vout.$692.Metal2 0.00521157f
Cred_4762 vdd.$2773.Metal2 vout.$694.Metal2 0.000499614f
Cred_4763 vdd.$2773.Metal2 vout.$712.Metal2 0.00550717f
Cred_4764 vdd.$2773.Metal2 vout.$714.Metal2 0.000521661f
Cred_4765 vdd.$2773.Metal2 vout.$732.Metal2 0.00568505f
Cred_4766 vdd.$2773.Metal2 vout.$734.Metal2 0.000818359f
Cred_4767 vdd.$2773.Metal2 vout.$752.Metal2 0.00591781f
Cred_4768 vdd.$2773.Metal2 vout.$772.Metal2 0.00622625f
Cred_4769 vdd.$2773.Metal2 vout.$774.Metal2 0.000871133f
Cred_4770 vdd.$2773.Metal2 vout.$792.Metal2 0.013782f
Cred_4771 vdd.$2773.Metal2 vout.$794.Metal2 0.00117148f
Cred_4772 vdd.$2773.Metal2 vout.P8.pSD 0.00141186f
Cred_4773 vdd.$2773.Metal2 vref 0.0120599f
Cred_4774 vdd.$2773.Metal2 vref.P0.GatPoly 0.000470268f
Cred_4775 vdd.$2773.Metal2 vref.P0.nSD 0.00269589f
Cred_4776 vdd.$2773.Metal2 vref.P0.pSD 0.052472f
Cred_4777 vdd.$2773.Metal2 vss 0.000279628f
Cred_4778 vdd.$2773.Metal2 vss.$1212.Metal5 0.000288383f
Cred_4779 vdd.$2773.Metal2 vss.$1230.Metal5 0.000288383f
Cred_4780 vdd.$2773.Metal2 vss.$1282.Metal5 0.00392913f
Cred_4781 vdd.$2773.Metal2 vss.$1300.Metal5 0.00110387f
Cred_4782 vdd.$2775.Metal2 vout.$1040.Metal3 0.00530491f
Cred_4783 vdd.$2775.Metal2 vout.$1080.Metal3 0.00358961f
Cred_4784 vdd.$2775.Metal2 vout.$1122.Metal3 0.000755877f
Cred_4785 vdd.$2775.Metal2 vout.$1140.Metal3 0.00485853f
Cred_4786 vdd.$2775.Metal2 vout.$1162.Metal3 0.00184221f
Cred_4787 vdd.$2775.Metal2 vout.$1180.Metal3 0.00750456f
Cred_4788 vdd.$2775.Metal2 vout.$1332.Metal4 0.00177094f
Cred_4789 vdd.$2775.Metal2 vout.$1372.Metal4 0.0285659f
Cred_4790 vdd.$2775.Metal2 vout.$1383.Metal4 0.000861462f
Cred_4791 vdd.$2775.Metal2 vout.$160.Metal1 0.014571f
Cred_4792 vdd.$2775.Metal2 vout.$210.Metal1 0.0132326f
Cred_4793 vdd.$2775.Metal2 vout.$230.Metal1 0.00999119f
Cred_4794 vdd.$2775.Metal2 vout.$270.Metal1 0.010146f
Cred_4795 vdd.$2775.Metal2 vout.$290.Metal1 0.0106119f
Cred_4796 vdd.$2775.Metal2 vout.$330.Metal1 0.0108521f
Cred_4797 vdd.$2775.Metal2 vout.$331.Metal1 1.87525e-06f
Cred_4798 vdd.$2775.Metal2 vout.$350.Metal1 0.0147316f
Cred_4799 vdd.$2775.Metal2 vout.$351.Metal1 1.52364e-05f
Cred_4800 vdd.$2775.Metal2 vout.$400.Metal1 0.0168219f
Cred_4801 vdd.$2775.Metal2 vout.$401.Metal1 3.35753e-05f
Cred_4802 vdd.$2775.Metal2 vout.$592.Metal2 0.0242251f
Cred_4803 vdd.$2775.Metal2 vout.$612.Metal2 0.0202992f
Cred_4804 vdd.$2775.Metal2 vout.$652.Metal2 0.0202508f
Cred_4805 vdd.$2775.Metal2 vout.$672.Metal2 0.014205f
Cred_4806 vdd.$2775.Metal2 vout.$692.Metal2 0.0161559f
Cred_4807 vdd.$2775.Metal2 vout.$694.Metal2 0.0015488f
Cred_4808 vdd.$2775.Metal2 vout.$712.Metal2 0.0170722f
Cred_4809 vdd.$2775.Metal2 vout.$714.Metal2 0.00161715f
Cred_4810 vdd.$2775.Metal2 vout.$732.Metal2 0.0176236f
Cred_4811 vdd.$2775.Metal2 vout.$734.Metal2 0.00253691f
Cred_4812 vdd.$2775.Metal2 vout.$752.Metal2 0.0183452f
Cred_4813 vdd.$2775.Metal2 vout.$772.Metal2 0.0193014f
Cred_4814 vdd.$2775.Metal2 vout.$774.Metal2 0.00270051f
Cred_4815 vdd.$2775.Metal2 vout.$792.Metal2 0.0384778f
Cred_4816 vdd.$2775.Metal2 vout.$794.Metal2 0.00363159f
Cred_4817 vdd.$2775.Metal2 vout.P8.pSD 0.000384144f
Cred_4818 vdd.$2775.Metal2 vref 0.0374416f
Cred_4819 vdd.$2775.Metal2 vref.P0.GatPoly 0.00146001f
Cred_4820 vdd.$2775.Metal2 vref.P0.nSD 0.00836977f
Cred_4821 vdd.$2775.Metal2 vref.P0.pSD 0.164887f
Cred_4822 vdd.$2775.Metal2 vss 8.36464e-07f
Cred_4823 vdd.$2775.Metal2 vss.$1212.Metal5 8.62652e-07f
Cred_4824 vdd.$2775.Metal2 vss.$1230.Metal5 8.62652e-07f
Cred_4825 vdd.$2775.Metal2 vss.$1282.Metal5 0.00876751f
Cred_4826 vdd.$2775.Metal2 vss.$1300.Metal5 3.30205e-06f
Cred_4827 vdd.$2779.Metal2 vout.$1002.Metal3 0.00331866f
Cred_4828 vdd.$2779.Metal2 vout.$1042.Metal3 0.00311767f
Cred_4829 vdd.$2779.Metal2 vout.$1080.Metal3 0.000158511f
Cred_4830 vdd.$2779.Metal2 vout.$1082.Metal3 0.0026541f
Cred_4831 vdd.$2779.Metal2 vout.$1122.Metal3 0.00364252f
Cred_4832 vdd.$2779.Metal2 vout.$1140.Metal3 0.00110806f
Cred_4833 vdd.$2779.Metal2 vout.$1162.Metal3 0.00933811f
Cred_4834 vdd.$2779.Metal2 vout.$1180.Metal3 0.00141064f
Cred_4835 vdd.$2779.Metal2 vout.$1313.Metal4 2.63798e-05f
Cred_4836 vdd.$2779.Metal2 vout.$1323.Metal4 0.000427017f
Cred_4837 vdd.$2779.Metal2 vout.$1333.Metal4 0.000448446f
Cred_4838 vdd.$2779.Metal2 vout.$1343.Metal4 0.000439947f
Cred_4839 vdd.$2779.Metal2 vout.$1353.Metal4 0.00046287f
Cred_4840 vdd.$2779.Metal2 vout.$1363.Metal4 0.000464075f
Cred_4841 vdd.$2779.Metal2 vout.$1372.Metal4 0.00904045f
Cred_4842 vdd.$2779.Metal2 vout.$1373.Metal4 0.00734325f
Cred_4843 vdd.$2779.Metal2 vout.$1383.Metal4 0.0169705f
Cred_4844 vdd.$2779.Metal2 vout.$161.Metal1 0.0117519f
Cred_4845 vdd.$2779.Metal2 vout.$201.Metal1 0.0139271f
Cred_4846 vdd.$2779.Metal2 vout.$231.Metal1 0.0137342f
Cred_4847 vdd.$2779.Metal2 vout.$271.Metal1 0.0107278f
Cred_4848 vdd.$2779.Metal2 vout.$291.Metal1 0.0113865f
Cred_4849 vdd.$2779.Metal2 vout.$331.Metal1 0.0118181f
Cred_4850 vdd.$2779.Metal2 vout.$351.Metal1 0.016179f
Cred_4851 vdd.$2779.Metal2 vout.$400.Metal1 3.32228e-05f
Cred_4852 vdd.$2779.Metal2 vout.$401.Metal1 0.0183895f
Cred_4853 vdd.$2779.Metal2 vout.$594.Metal2 0.0247314f
Cred_4854 vdd.$2779.Metal2 vout.$614.Metal2 0.0135764f
Cred_4855 vdd.$2779.Metal2 vout.$634.Metal2 0.0138704f
Cred_4856 vdd.$2779.Metal2 vout.$654.Metal2 0.0141727f
Cred_4857 vdd.$2779.Metal2 vout.$674.Metal2 0.0142082f
Cred_4858 vdd.$2779.Metal2 vout.$692.Metal2 0.00155198f
Cred_4859 vdd.$2779.Metal2 vout.$694.Metal2 0.0163442f
Cred_4860 vdd.$2779.Metal2 vout.$712.Metal2 0.00162363f
Cred_4861 vdd.$2779.Metal2 vout.$714.Metal2 0.0173479f
Cred_4862 vdd.$2779.Metal2 vout.$732.Metal2 0.00167635f
Cred_4863 vdd.$2779.Metal2 vout.$734.Metal2 0.0271116f
Cred_4864 vdd.$2779.Metal2 vout.$752.Metal2 0.00175049f
Cred_4865 vdd.$2779.Metal2 vout.$772.Metal2 0.00182442f
Cred_4866 vdd.$2779.Metal2 vout.$774.Metal2 0.0289288f
Cred_4867 vdd.$2779.Metal2 vout.$792.Metal2 0.00359475f
Cred_4868 vdd.$2779.Metal2 vout.$794.Metal2 0.0387466f
Cred_4869 vdd.$2779.Metal2 vout.P10.pSD 0.000332902f
Cred_4870 vdd.$2779.Metal2 vref 0.0339831f
Cred_4871 vdd.$2779.Metal2 vref.P0.GatPoly 0.00132515f
Cred_4872 vdd.$2779.Metal2 vref.P0.nSD 0.00759665f
Cred_4873 vdd.$2779.Metal2 vref.P0.pSD 0.150196f
Cred_4874 vdd.$2779.Metal2 vss 9.21423e-05f
Cred_4875 vdd.$2779.Metal2 vss.$1212.Metal5 9.5027e-05f
Cred_4876 vdd.$2779.Metal2 vss.$1230.Metal5 9.5027e-05f
Cred_4877 vdd.$2779.Metal2 vss.$1282.Metal5 0.000363744f
Cred_4878 vdd.$2779.Metal2 vss.$1300.Metal5 0.00792026f
Cred_4879 vdd.$2781.Metal2 vout.$1002.Metal3 0.00107054f
Cred_4880 vdd.$2781.Metal2 vout.$1042.Metal3 0.0010057f
Cred_4881 vdd.$2781.Metal2 vout.$1080.Metal3 5.11325e-05f
Cred_4882 vdd.$2781.Metal2 vout.$1082.Metal3 0.000856163f
Cred_4883 vdd.$2781.Metal2 vout.$1122.Metal3 0.00117501f
Cred_4884 vdd.$2781.Metal2 vout.$1140.Metal3 0.000357438f
Cred_4885 vdd.$2781.Metal2 vout.$1162.Metal3 0.00303428f
Cred_4886 vdd.$2781.Metal2 vout.$1180.Metal3 0.000455046f
Cred_4887 vdd.$2781.Metal2 vout.$1313.Metal4 8.50961e-06f
Cred_4888 vdd.$2781.Metal2 vout.$1323.Metal4 0.000137747f
Cred_4889 vdd.$2781.Metal2 vout.$1333.Metal4 0.00014466f
Cred_4890 vdd.$2781.Metal2 vout.$1343.Metal4 0.000141918f
Cred_4891 vdd.$2781.Metal2 vout.$1353.Metal4 0.000149313f
Cred_4892 vdd.$2781.Metal2 vout.$1363.Metal4 0.000149701f
Cred_4893 vdd.$2781.Metal2 vout.$1372.Metal4 0.00266636f
Cred_4894 vdd.$2781.Metal2 vout.$1373.Metal4 0.00236879f
Cred_4895 vdd.$2781.Metal2 vout.$1383.Metal4 0.00650933f
Cred_4896 vdd.$2781.Metal2 vout.$161.Metal1 0.00379093f
Cred_4897 vdd.$2781.Metal2 vout.$201.Metal1 0.0044926f
Cred_4898 vdd.$2781.Metal2 vout.$231.Metal1 0.00443037f
Cred_4899 vdd.$2781.Metal2 vout.$271.Metal1 0.00346059f
Cred_4900 vdd.$2781.Metal2 vout.$291.Metal1 0.00367307f
Cred_4901 vdd.$2781.Metal2 vout.$331.Metal1 0.00381229f
Cred_4902 vdd.$2781.Metal2 vout.$351.Metal1 0.00521902f
Cred_4903 vdd.$2781.Metal2 vout.$400.Metal1 1.0717e-05f
Cred_4904 vdd.$2781.Metal2 vout.$401.Metal1 0.0059679f
Cred_4905 vdd.$2781.Metal2 vout.$594.Metal2 0.00797788f
Cred_4906 vdd.$2781.Metal2 vout.$614.Metal2 0.00437949f
Cred_4907 vdd.$2781.Metal2 vout.$634.Metal2 0.00447431f
Cred_4908 vdd.$2781.Metal2 vout.$654.Metal2 0.00457183f
Cred_4909 vdd.$2781.Metal2 vout.$674.Metal2 0.00458327f
Cred_4910 vdd.$2781.Metal2 vout.$692.Metal2 0.000500639f
Cred_4911 vdd.$2781.Metal2 vout.$694.Metal2 0.00527231f
Cred_4912 vdd.$2781.Metal2 vout.$712.Metal2 0.000523752f
Cred_4913 vdd.$2781.Metal2 vout.$714.Metal2 0.0055961f
Cred_4914 vdd.$2781.Metal2 vout.$732.Metal2 0.000540758f
Cred_4915 vdd.$2781.Metal2 vout.$734.Metal2 0.00874567f
Cred_4916 vdd.$2781.Metal2 vout.$752.Metal2 0.000564674f
Cred_4917 vdd.$2781.Metal2 vout.$772.Metal2 0.000588522f
Cred_4918 vdd.$2781.Metal2 vout.$774.Metal2 0.00933231f
Cred_4919 vdd.$2781.Metal2 vout.$792.Metal2 0.0011596f
Cred_4920 vdd.$2781.Metal2 vout.$794.Metal2 0.0138695f
Cred_4921 vdd.$2781.Metal2 vout.P10.pSD 0.00139533f
Cred_4922 vdd.$2781.Metal2 vref 0.0109443f
Cred_4923 vdd.$2781.Metal2 vref.P0.GatPoly 0.000426764f
Cred_4924 vdd.$2781.Metal2 vref.P0.nSD 0.0024465f
Cred_4925 vdd.$2781.Metal2 vref.P0.pSD 0.047733f
Cred_4926 vdd.$2781.Metal2 vss 0.000314188f
Cred_4927 vdd.$2781.Metal2 vss.$1212.Metal5 0.000324024f
Cred_4928 vdd.$2781.Metal2 vss.$1230.Metal5 0.000324024f
Cred_4929 vdd.$2781.Metal2 vss.$1282.Metal5 0.0012403f
Cred_4930 vdd.$2781.Metal2 vss.$1300.Metal5 0.00367788f
Cred_4931 vdd.$2783.Metal2 vout 0.00028494f
Cred_4932 vdd.$2783.Metal2 vout.$1002.Metal3 0.00120834f
Cred_4933 vdd.$2783.Metal2 vout.$1004.Metal3 0.00121996f
Cred_4934 vdd.$2783.Metal2 vout.$1042.Metal3 0.000944864f
Cred_4935 vdd.$2783.Metal2 vout.$1044.Metal3 0.00115345f
Cred_4936 vdd.$2783.Metal2 vout.$1082.Metal3 0.00127544f
Cred_4937 vdd.$2783.Metal2 vout.$1084.Metal3 0.000941646f
Cred_4938 vdd.$2783.Metal2 vout.$1122.Metal3 0.00143427f
Cred_4939 vdd.$2783.Metal2 vout.$1124.Metal3 0.00129232f
Cred_4940 vdd.$2783.Metal2 vout.$1162.Metal3 0.00328075f
Cred_4941 vdd.$2783.Metal2 vout.$1164.Metal3 0.00330728f
Cred_4942 vdd.$2783.Metal2 vout.$1299.Metal4 3.43115e-09f
Cred_4943 vdd.$2783.Metal2 vout.$1313.Metal4 0.000606326f
Cred_4944 vdd.$2783.Metal2 vout.$1323.Metal4 0.000579517f
Cred_4945 vdd.$2783.Metal2 vout.$1333.Metal4 0.000596454f
Cred_4946 vdd.$2783.Metal2 vout.$1343.Metal4 0.000597065f
Cred_4947 vdd.$2783.Metal2 vout.$1353.Metal4 0.00136688f
Cred_4948 vdd.$2783.Metal2 vout.$1363.Metal4 0.00139722f
Cred_4949 vdd.$2783.Metal2 vout.$1373.Metal4 0.00332763f
Cred_4950 vdd.$2783.Metal2 vout.$1383.Metal4 0.00318193f
Cred_4951 vdd.$2783.Metal2 vout.$1384.Metal4 0.000369376f
Cred_4952 vdd.$2783.Metal2 vout.$1394.Metal4 0.0028205f
Cred_4953 vdd.$2783.Metal2 vout.$161.Metal1 0.00430697f
Cred_4954 vdd.$2783.Metal2 vout.$162.Metal1 0.00523323f
Cred_4955 vdd.$2783.Metal2 vout.$201.Metal1 0.00504117f
Cred_4956 vdd.$2783.Metal2 vout.$212.Metal1 0.00502147f
Cred_4957 vdd.$2783.Metal2 vout.$231.Metal1 0.00521416f
Cred_4958 vdd.$2783.Metal2 vout.$232.Metal1 0.00370342f
Cred_4959 vdd.$2783.Metal2 vout.$271.Metal1 0.00391074f
Cred_4960 vdd.$2783.Metal2 vout.$272.Metal1 0.00382501f
Cred_4961 vdd.$2783.Metal2 vout.$291.Metal1 0.00391718f
Cred_4962 vdd.$2783.Metal2 vout.$292.Metal1 0.0039066f
Cred_4963 vdd.$2783.Metal2 vout.$331.Metal1 0.00402063f
Cred_4964 vdd.$2783.Metal2 vout.$332.Metal1 0.00392049f
Cred_4965 vdd.$2783.Metal2 vout.$351.Metal1 0.00546783f
Cred_4966 vdd.$2783.Metal2 vout.$352.Metal1 0.00540986f
Cred_4967 vdd.$2783.Metal2 vout.$401.Metal1 0.0060754f
Cred_4968 vdd.$2783.Metal2 vout.$402.Metal1 0.00612337f
Cred_4969 vdd.$2783.Metal2 vout.$594.Metal2 0.00849161f
Cred_4970 vdd.$2783.Metal2 vout.$596.Metal2 0.00855583f
Cred_4971 vdd.$2783.Metal2 vout.$614.Metal2 0.00473615f
Cred_4972 vdd.$2783.Metal2 vout.$616.Metal2 0.00714756f
Cred_4973 vdd.$2783.Metal2 vout.$634.Metal2 0.00484091f
Cred_4974 vdd.$2783.Metal2 vout.$654.Metal2 0.00494793f
Cred_4975 vdd.$2783.Metal2 vout.$656.Metal2 0.0073071f
Cred_4976 vdd.$2783.Metal2 vout.$674.Metal2 0.00532171f
Cred_4977 vdd.$2783.Metal2 vout.$676.Metal2 0.00510039f
Cred_4978 vdd.$2783.Metal2 vout.$694.Metal2 0.00575488f
Cred_4979 vdd.$2783.Metal2 vout.$696.Metal2 0.00554065f
Cred_4980 vdd.$2783.Metal2 vout.$714.Metal2 0.00617979f
Cred_4981 vdd.$2783.Metal2 vout.$716.Metal2 0.00601817f
Cred_4982 vdd.$2783.Metal2 vout.$734.Metal2 0.00965762f
Cred_4983 vdd.$2783.Metal2 vout.$736.Metal2 0.00940652f
Cred_4984 vdd.$2783.Metal2 vout.$774.Metal2 0.0103011f
Cred_4985 vdd.$2783.Metal2 vout.$776.Metal2 0.0100366f
Cred_4986 vdd.$2783.Metal2 vout.$794.Metal2 0.0150122f
Cred_4987 vdd.$2783.Metal2 vout.$796.Metal2 0.0133325f
Cred_4988 vdd.$2783.Metal2 vout.P0.GatPoly 4.46974e-08f
Cred_4989 vdd.$2783.Metal2 vout.P10.pSD 0.00150317f
Cred_4990 vdd.$2783.Metal2 vout.P12.pSD 0.000140398f
Cred_4991 vdd.$2783.Metal2 vss 0.000533041f
Cred_4992 vdd.$2783.Metal2 vss.$1212.Metal5 0.00054973f
Cred_4993 vdd.$2783.Metal2 vss.$1230.Metal5 0.00054973f
Cred_4994 vdd.$2783.Metal2 vss.$1282.Metal5 0.00210425f
Cred_4995 vdd.$2783.Metal2 vss.$1300.Metal5 0.00210425f
Cred_4996 vdd.$2785.Metal2 vout 0.000777108f
Cred_4997 vdd.$2785.Metal2 vout.$1002.Metal3 0.00329547f
Cred_4998 vdd.$2785.Metal2 vout.$1004.Metal3 0.00332716f
Cred_4999 vdd.$2785.Metal2 vout.$1042.Metal3 0.0025769f
Cred_5000 vdd.$2785.Metal2 vout.$1044.Metal3 0.00314577f
Cred_5001 vdd.$2785.Metal2 vout.$1082.Metal3 0.00347847f
Cred_5002 vdd.$2785.Metal2 vout.$1084.Metal3 0.00256812f
Cred_5003 vdd.$2785.Metal2 vout.$1122.Metal3 0.00391165f
Cred_5004 vdd.$2785.Metal2 vout.$1124.Metal3 0.00352452f
Cred_5005 vdd.$2785.Metal2 vout.$1162.Metal3 0.00887806f
Cred_5006 vdd.$2785.Metal2 vout.$1164.Metal3 0.00901985f
Cred_5007 vdd.$2785.Metal2 vout.$1299.Metal4 9.35768e-09f
Cred_5008 vdd.$2785.Metal2 vout.$1313.Metal4 0.00165362f
Cred_5009 vdd.$2785.Metal2 vout.$1323.Metal4 0.0015805f
Cred_5010 vdd.$2785.Metal2 vout.$1333.Metal4 0.00162669f
Cred_5011 vdd.$2785.Metal2 vout.$1343.Metal4 0.00162836f
Cred_5012 vdd.$2785.Metal2 vout.$1353.Metal4 0.00372785f
Cred_5013 vdd.$2785.Metal2 vout.$1363.Metal4 0.00381059f
Cred_5014 vdd.$2785.Metal2 vout.$1373.Metal4 0.00392231f
Cred_5015 vdd.$2785.Metal2 vout.$1383.Metal4 0.00866935f
Cred_5016 vdd.$2785.Metal2 vout.$1384.Metal4 0.00100739f
Cred_5017 vdd.$2785.Metal2 vout.$1394.Metal4 0.00769227f
Cred_5018 vdd.$2785.Metal2 vout.$161.Metal1 0.0117463f
Cred_5019 vdd.$2785.Metal2 vout.$162.Metal1 0.0142724f
Cred_5020 vdd.$2785.Metal2 vout.$201.Metal1 0.0137486f
Cred_5021 vdd.$2785.Metal2 vout.$212.Metal1 0.0136949f
Cred_5022 vdd.$2785.Metal2 vout.$231.Metal1 0.0142204f
Cred_5023 vdd.$2785.Metal2 vout.$232.Metal1 0.0101002f
Cred_5024 vdd.$2785.Metal2 vout.$271.Metal1 0.0106657f
Cred_5025 vdd.$2785.Metal2 vout.$272.Metal1 0.0104318f
Cred_5026 vdd.$2785.Metal2 vout.$291.Metal1 0.0106832f
Cred_5027 vdd.$2785.Metal2 vout.$292.Metal1 0.0106544f
Cred_5028 vdd.$2785.Metal2 vout.$331.Metal1 0.0109654f
Cred_5029 vdd.$2785.Metal2 vout.$332.Metal1 0.0106923f
Cred_5030 vdd.$2785.Metal2 vout.$351.Metal1 0.0149123f
Cred_5031 vdd.$2785.Metal2 vout.$352.Metal1 0.0147542f
Cred_5032 vdd.$2785.Metal2 vout.$401.Metal1 0.0165019f
Cred_5033 vdd.$2785.Metal2 vout.$402.Metal1 0.0167001f
Cred_5034 vdd.$2785.Metal2 vout.$594.Metal2 0.0231589f
Cred_5035 vdd.$2785.Metal2 vout.$596.Metal2 0.0233341f
Cred_5036 vdd.$2785.Metal2 vout.$614.Metal2 0.0129168f
Cred_5037 vdd.$2785.Metal2 vout.$616.Metal2 0.0194933f
Cred_5038 vdd.$2785.Metal2 vout.$634.Metal2 0.0132025f
Cred_5039 vdd.$2785.Metal2 vout.$654.Metal2 0.0134943f
Cred_5040 vdd.$2785.Metal2 vout.$656.Metal2 0.0199285f
Cred_5041 vdd.$2785.Metal2 vout.$674.Metal2 0.0145138f
Cred_5042 vdd.$2785.Metal2 vout.$676.Metal2 0.0139102f
Cred_5043 vdd.$2785.Metal2 vout.$694.Metal2 0.0156951f
Cred_5044 vdd.$2785.Metal2 vout.$696.Metal2 0.0151109f
Cred_5045 vdd.$2785.Metal2 vout.$714.Metal2 0.016854f
Cred_5046 vdd.$2785.Metal2 vout.$716.Metal2 0.0164132f
Cred_5047 vdd.$2785.Metal2 vout.$734.Metal2 0.026339f
Cred_5048 vdd.$2785.Metal2 vout.$736.Metal2 0.0256542f
Cred_5049 vdd.$2785.Metal2 vout.$774.Metal2 0.0280926f
Cred_5050 vdd.$2785.Metal2 vout.$776.Metal2 0.0273725f
Cred_5051 vdd.$2785.Metal2 vout.$794.Metal2 0.0375589f
Cred_5052 vdd.$2785.Metal2 vout.$796.Metal2 0.0363615f
Cred_5053 vdd.$2785.Metal2 vout.P0.GatPoly 1.21902e-07f
Cred_5054 vdd.$2785.Metal2 vout.P10.pSD 0.000316898f
Cred_5055 vdd.$2785.Metal2 vout.P12.pSD 0.000382903f
Cred_5056 vdd.$2785.Metal2 vss 0.000691451f
Cred_5057 vdd.$2785.Metal2 vss.$1212.Metal5 0.000713099f
Cred_5058 vdd.$2785.Metal2 vss.$1230.Metal5 0.000713099f
Cred_5059 vdd.$2785.Metal2 vss.$1282.Metal5 0.0027296f
Cred_5060 vdd.$2785.Metal2 vss.$1300.Metal5 0.0027296f
Cred_5061 vdd.$2787.Metal2 vout.$1164.Metal3 5.36124e-05f
Cred_5062 vdd.$2787.Metal2 vout.$1373.Metal4 0.00214159f
Cred_5063 vdd.$2787.Metal2 vout.$1394.Metal4 6.66492e-06f
Cred_5064 vdd.$2787.Metal2 vout.$402.Metal1 5.19732e-05f
Cred_5065 vdd.$2787.Metal2 vout.$776.Metal2 1.07463e-06f
Cred_5066 vdd.$2787.Metal2 vout.$796.Metal2 0.00261169f
Cred_5067 vdd.$2787.Metal2 vout.P12.pSD 0.00276903f
Cred_5068 vdd.$2787.Metal2 vss 0.000443012f
Cred_5069 vdd.$2787.Metal2 vss.$1212.Metal5 0.000456882f
Cred_5070 vdd.$2787.Metal2 vss.$1230.Metal5 0.000456882f
Cred_5071 vdd.$2787.Metal2 vss.$1282.Metal5 0.00174885f
Cred_5072 vdd.$2787.Metal2 vss.$1300.Metal5 0.00174885f
Cred_5073 vdd.$2789.Metal2 vout 0.000829162f
Cred_5074 vdd.$2789.Metal2 vout.$1004.Metal3 0.00351622f
Cred_5075 vdd.$2789.Metal2 vout.$1006.Metal3 0.00355002f
Cred_5076 vdd.$2789.Metal2 vout.$1044.Metal3 0.00288726f
Cred_5077 vdd.$2789.Metal2 vout.$1046.Metal3 0.00335648f
Cred_5078 vdd.$2789.Metal2 vout.$1084.Metal3 0.00371148f
Cred_5079 vdd.$2789.Metal2 vout.$1086.Metal3 0.00324547f
Cred_5080 vdd.$2789.Metal2 vout.$1124.Metal3 0.00417367f
Cred_5081 vdd.$2789.Metal2 vout.$1126.Metal3 0.00376061f
Cred_5082 vdd.$2789.Metal2 vout.$1164.Metal3 0.00947274f
Cred_5083 vdd.$2789.Metal2 vout.$1166.Metal3 0.00962406f
Cred_5084 vdd.$2789.Metal2 vout.$1299.Metal4 9.9845e-09f
Cred_5085 vdd.$2789.Metal2 vout.$1313.Metal4 0.00176438f
Cred_5086 vdd.$2789.Metal2 vout.$1323.Metal4 0.00374117f
Cred_5087 vdd.$2789.Metal2 vout.$1333.Metal4 0.00173565f
Cred_5088 vdd.$2789.Metal2 vout.$1343.Metal4 0.00385446f
Cred_5089 vdd.$2789.Metal2 vout.$1353.Metal4 0.00180955f
Cred_5090 vdd.$2789.Metal2 vout.$1363.Metal4 0.00183272f
Cred_5091 vdd.$2789.Metal2 vout.$1373.Metal4 0.00382371f
Cred_5092 vdd.$2789.Metal2 vout.$1384.Metal4 0.00367931f
Cred_5093 vdd.$2789.Metal2 vout.$1394.Metal4 0.0081752f
Cred_5094 vdd.$2789.Metal2 vout.$1395.Metal4 0.00113698f
Cred_5095 vdd.$2789.Metal2 vout.$1405.Metal4 0.00115996f
Cred_5096 vdd.$2789.Metal2 vout.$1415.Metal4 0.00591059f
Cred_5097 vdd.$2789.Metal2 vout.$162.Metal1 0.0158362f
Cred_5098 vdd.$2789.Metal2 vout.$163.Metal1 0.0146849f
Cred_5099 vdd.$2789.Metal2 vout.$212.Metal1 0.0141445f
Cred_5100 vdd.$2789.Metal2 vout.$213.Metal1 0.0139352f
Cred_5101 vdd.$2789.Metal2 vout.$232.Metal1 0.011121f
Cred_5102 vdd.$2789.Metal2 vout.$233.Metal1 0.0103771f
Cred_5103 vdd.$2789.Metal2 vout.$272.Metal1 0.0110466f
Cred_5104 vdd.$2789.Metal2 vout.$273.Metal1 0.01053f
Cred_5105 vdd.$2789.Metal2 vout.$292.Metal1 0.0112435f
Cred_5106 vdd.$2789.Metal2 vout.$293.Metal1 0.011368f
Cred_5107 vdd.$2789.Metal2 vout.$332.Metal1 0.0116999f
Cred_5108 vdd.$2789.Metal2 vout.$333.Metal1 0.0114085f
Cred_5109 vdd.$2789.Metal2 vout.$352.Metal1 0.0159112f
Cred_5110 vdd.$2789.Metal2 vout.$353.Metal1 0.0157425f
Cred_5111 vdd.$2789.Metal2 vout.$402.Metal1 0.0176073f
Cred_5112 vdd.$2789.Metal2 vout.$403.Metal1 0.0181188f
Cred_5113 vdd.$2789.Metal2 vout.$596.Metal2 0.0247679f
Cred_5114 vdd.$2789.Metal2 vout.$598.Metal2 0.0244387f
Cred_5115 vdd.$2789.Metal2 vout.$616.Metal2 0.0207993f
Cred_5116 vdd.$2789.Metal2 vout.$618.Metal2 0.0207904f
Cred_5117 vdd.$2789.Metal2 vout.$656.Metal2 0.0212692f
Cred_5118 vdd.$2789.Metal2 vout.$658.Metal2 0.0207814f
Cred_5119 vdd.$2789.Metal2 vout.$676.Metal2 0.014844f
Cred_5120 vdd.$2789.Metal2 vout.$678.Metal2 0.0148387f
Cred_5121 vdd.$2789.Metal2 vout.$696.Metal2 0.0167448f
Cred_5122 vdd.$2789.Metal2 vout.$698.Metal2 0.0157351f
Cred_5123 vdd.$2789.Metal2 vout.$716.Metal2 0.0179829f
Cred_5124 vdd.$2789.Metal2 vout.$718.Metal2 0.0175126f
Cred_5125 vdd.$2789.Metal2 vout.$736.Metal2 0.0281033f
Cred_5126 vdd.$2789.Metal2 vout.$738.Metal2 0.0273726f
Cred_5127 vdd.$2789.Metal2 vout.$776.Metal2 0.0299743f
Cred_5128 vdd.$2789.Metal2 vout.$778.Metal2 0.029206f
Cred_5129 vdd.$2789.Metal2 vout.$796.Metal2 0.0400748f
Cred_5130 vdd.$2789.Metal2 vout.$798.Metal2 0.038799f
Cred_5131 vdd.$2789.Metal2 vout.P0.GatPoly 1.30068e-07f
Cred_5132 vdd.$2789.Metal2 vout.P12.pSD 0.000412372f
Cred_5133 vdd.$2789.Metal2 vout.P14.pSD 0.000400407f
Cred_5134 vdd.$2789.Metal2 vss 0.000708832f
Cred_5135 vdd.$2789.Metal2 vss.$1212.Metal5 0.000731024f
Cred_5136 vdd.$2789.Metal2 vss.$1230.Metal5 0.000731024f
Cred_5137 vdd.$2789.Metal2 vss.$1282.Metal5 0.00279821f
Cred_5138 vdd.$2789.Metal2 vss.$1300.Metal5 0.00279821f
Cred_5139 vdd.$2791.Metal2 vout 0.000233202f
Cred_5140 vdd.$2791.Metal2 vout.$1004.Metal3 0.000988936f
Cred_5141 vdd.$2791.Metal2 vout.$1006.Metal3 0.000998444f
Cred_5142 vdd.$2791.Metal2 vout.$1044.Metal3 0.000812041f
Cred_5143 vdd.$2791.Metal2 vout.$1046.Metal3 0.00094401f
Cred_5144 vdd.$2791.Metal2 vout.$1084.Metal3 0.00104385f
Cred_5145 vdd.$2791.Metal2 vout.$1086.Metal3 0.000912789f
Cred_5146 vdd.$2791.Metal2 vout.$1124.Metal3 0.00117385f
Cred_5147 vdd.$2791.Metal2 vout.$1126.Metal3 0.00105767f
Cred_5148 vdd.$2791.Metal2 vout.$1164.Metal3 0.00266421f
Cred_5149 vdd.$2791.Metal2 vout.$1166.Metal3 0.00273759f
Cred_5150 vdd.$2791.Metal2 vout.$1299.Metal4 2.80814e-09f
Cred_5151 vdd.$2791.Metal2 vout.$1313.Metal4 0.000496232f
Cred_5152 vdd.$2791.Metal2 vout.$1323.Metal4 0.0010522f
Cred_5153 vdd.$2791.Metal2 vout.$1333.Metal4 0.000488153f
Cred_5154 vdd.$2791.Metal2 vout.$1343.Metal4 0.00108407f
Cred_5155 vdd.$2791.Metal2 vout.$1353.Metal4 0.000508936f
Cred_5156 vdd.$2791.Metal2 vout.$1363.Metal4 0.000515452f
Cred_5157 vdd.$2791.Metal2 vout.$1373.Metal4 0.00310027f
Cred_5158 vdd.$2791.Metal2 vout.$1384.Metal4 0.00103481f
Cred_5159 vdd.$2791.Metal2 vout.$1394.Metal4 0.00229927f
Cred_5160 vdd.$2791.Metal2 vout.$1395.Metal4 0.000319776f
Cred_5161 vdd.$2791.Metal2 vout.$1405.Metal4 0.000326239f
Cred_5162 vdd.$2791.Metal2 vout.$1415.Metal4 0.00166619f
Cred_5163 vdd.$2791.Metal2 vout.$162.Metal1 0.00445392f
Cred_5164 vdd.$2791.Metal2 vout.$163.Metal1 0.00413012f
Cred_5165 vdd.$2791.Metal2 vout.$212.Metal1 0.00397814f
Cred_5166 vdd.$2791.Metal2 vout.$213.Metal1 0.00391929f
Cred_5167 vdd.$2791.Metal2 vout.$232.Metal1 0.00312778f
Cred_5168 vdd.$2791.Metal2 vout.$233.Metal1 0.00291857f
Cred_5169 vdd.$2791.Metal2 vout.$272.Metal1 0.00310685f
Cred_5170 vdd.$2791.Metal2 vout.$273.Metal1 0.00296156f
Cred_5171 vdd.$2791.Metal2 vout.$292.Metal1 0.00316222f
Cred_5172 vdd.$2791.Metal2 vout.$293.Metal1 0.00319726f
Cred_5173 vdd.$2791.Metal2 vout.$332.Metal1 0.00329059f
Cred_5174 vdd.$2791.Metal2 vout.$333.Metal1 0.00320863f
Cred_5175 vdd.$2791.Metal2 vout.$352.Metal1 0.00447501f
Cred_5176 vdd.$2791.Metal2 vout.$353.Metal1 0.00442757f
Cred_5177 vdd.$2791.Metal2 vout.$402.Metal1 0.00495206f
Cred_5178 vdd.$2791.Metal2 vout.$403.Metal1 0.00512581f
Cred_5179 vdd.$2791.Metal2 vout.$596.Metal2 0.00696597f
Cred_5180 vdd.$2791.Metal2 vout.$598.Metal2 0.00687338f
Cred_5181 vdd.$2791.Metal2 vout.$616.Metal2 0.0058498f
Cred_5182 vdd.$2791.Metal2 vout.$618.Metal2 0.0058473f
Cred_5183 vdd.$2791.Metal2 vout.$656.Metal2 0.00598197f
Cred_5184 vdd.$2791.Metal2 vout.$658.Metal2 0.00584476f
Cred_5185 vdd.$2791.Metal2 vout.$676.Metal2 0.00417488f
Cred_5186 vdd.$2791.Metal2 vout.$678.Metal2 0.00417337f
Cred_5187 vdd.$2791.Metal2 vout.$696.Metal2 0.00470947f
Cred_5188 vdd.$2791.Metal2 vout.$698.Metal2 0.0044255f
Cred_5189 vdd.$2791.Metal2 vout.$716.Metal2 0.0050577f
Cred_5190 vdd.$2791.Metal2 vout.$718.Metal2 0.00492543f
Cred_5191 vdd.$2791.Metal2 vout.$736.Metal2 0.00790404f
Cred_5192 vdd.$2791.Metal2 vout.$738.Metal2 0.00769854f
Cred_5193 vdd.$2791.Metal2 vout.$776.Metal2 0.00843028f
Cred_5194 vdd.$2791.Metal2 vout.$778.Metal2 0.00821481f
Cred_5195 vdd.$2791.Metal2 vout.$796.Metal2 0.011271f
Cred_5196 vdd.$2791.Metal2 vout.$798.Metal2 0.0124139f
Cred_5197 vdd.$2791.Metal2 vout.P0.GatPoly 3.65815e-08f
Cred_5198 vdd.$2791.Metal2 vout.P12.pSD 0.00011598f
Cred_5199 vdd.$2791.Metal2 vout.P14.pSD 0.00149487f
Cred_5200 vdd.$2791.Metal2 vss 0.000516748f
Cred_5201 vdd.$2791.Metal2 vss.$1212.Metal5 0.000532926f
Cred_5202 vdd.$2791.Metal2 vss.$1230.Metal5 0.000532926f
Cred_5203 vdd.$2791.Metal2 vss.$1282.Metal5 0.00203993f
Cred_5204 vdd.$2791.Metal2 vss.$1300.Metal5 0.00203993f
Cred_5205 vdd.$2793.Metal2 vout 0.000310804f
Cred_5206 vdd.$2793.Metal2 vout.$1006.Metal3 0.00131802f
Cred_5207 vdd.$2793.Metal2 vout.$1008.Metal3 0.00133069f
Cred_5208 vdd.$2793.Metal2 vout.$1046.Metal3 0.00108226f
Cred_5209 vdd.$2793.Metal2 vout.$1048.Metal3 0.00125815f
Cred_5210 vdd.$2793.Metal2 vout.$1086.Metal3 0.0012018f
Cred_5211 vdd.$2793.Metal2 vout.$1088.Metal3 0.00121653f
Cred_5212 vdd.$2793.Metal2 vout.$1126.Metal3 0.00156446f
Cred_5213 vdd.$2793.Metal2 vout.$1128.Metal3 0.00140963f
Cred_5214 vdd.$2793.Metal2 vout.$1166.Metal3 0.00356857f
Cred_5215 vdd.$2793.Metal2 vout.$1168.Metal3 0.00170843f
Cred_5216 vdd.$2793.Metal2 vout.$1208.Metal3 0.00230959f
Cred_5217 vdd.$2793.Metal2 vout.$1299.Metal4 3.7426e-09f
Cred_5218 vdd.$2793.Metal2 vout.$1313.Metal4 0.000661362f
Cred_5219 vdd.$2793.Metal2 vout.$1323.Metal4 0.00063212f
Cred_5220 vdd.$2793.Metal2 vout.$1333.Metal4 0.000650594f
Cred_5221 vdd.$2793.Metal2 vout.$1343.Metal4 0.000651261f
Cred_5222 vdd.$2793.Metal2 vout.$1353.Metal4 0.000678293f
Cred_5223 vdd.$2793.Metal2 vout.$1363.Metal4 0.000686977f
Cred_5224 vdd.$2793.Metal2 vout.$1373.Metal4 0.0034585f
Cred_5225 vdd.$2793.Metal2 vout.$1384.Metal4 0.000805806f
Cred_5226 vdd.$2793.Metal2 vout.$1395.Metal4 0.00134934f
Cred_5227 vdd.$2793.Metal2 vout.$1405.Metal4 0.00138849f
Cred_5228 vdd.$2793.Metal2 vout.$1415.Metal4 0.0037369f
Cred_5229 vdd.$2793.Metal2 vout.$1416.Metal4 0.000463831f
Cred_5230 vdd.$2793.Metal2 vout.$163.Metal1 0.00613979f
Cred_5231 vdd.$2793.Metal2 vout.$164.Metal1 0.00570825f
Cred_5232 vdd.$2793.Metal2 vout.$213.Metal1 0.00572745f
Cred_5233 vdd.$2793.Metal2 vout.$214.Metal1 0.00530551f
Cred_5234 vdd.$2793.Metal2 vout.$233.Metal1 0.00431403f
Cred_5235 vdd.$2793.Metal2 vout.$234.Metal1 0.00393752f
Cred_5236 vdd.$2793.Metal2 vout.$273.Metal1 0.00435928f
Cred_5237 vdd.$2793.Metal2 vout.$274.Metal1 0.00415894f
Cred_5238 vdd.$2793.Metal2 vout.$293.Metal1 0.0042145f
Cred_5239 vdd.$2793.Metal2 vout.$294.Metal1 0.00426054f
Cred_5240 vdd.$2793.Metal2 vout.$333.Metal1 0.00438558f
Cred_5241 vdd.$2793.Metal2 vout.$334.Metal1 0.00427636f
Cred_5242 vdd.$2793.Metal2 vout.$353.Metal1 0.00596415f
Cred_5243 vdd.$2793.Metal2 vout.$354.Metal1 0.00590091f
Cred_5244 vdd.$2793.Metal2 vout.$403.Metal1 0.00662202f
Cred_5245 vdd.$2793.Metal2 vout.$404.Metal1 0.00667776f
Cred_5246 vdd.$2793.Metal2 vout.$598.Metal2 0.00945585f
Cred_5247 vdd.$2793.Metal2 vout.$600.Metal2 0.00933245f
Cred_5248 vdd.$2793.Metal2 vout.$618.Metal2 0.00779968f
Cred_5249 vdd.$2793.Metal2 vout.$620.Metal2 0.00779634f
Cred_5250 vdd.$2793.Metal2 vout.$658.Metal2 0.00815322f
Cred_5251 vdd.$2793.Metal2 vout.$660.Metal2 0.00778998f
Cred_5252 vdd.$2793.Metal2 vout.$678.Metal2 0.00556531f
Cred_5253 vdd.$2793.Metal2 vout.$680.Metal2 0.00556319f
Cred_5254 vdd.$2793.Metal2 vout.$698.Metal2 0.00642205f
Cred_5255 vdd.$2793.Metal2 vout.$700.Metal2 0.00604357f
Cred_5256 vdd.$2793.Metal2 vout.$718.Metal2 0.00674073f
Cred_5257 vdd.$2793.Metal2 vout.$720.Metal2 0.00656444f
Cred_5258 vdd.$2793.Metal2 vout.$738.Metal2 0.0105342f
Cred_5259 vdd.$2793.Metal2 vout.$740.Metal2 0.0102604f
Cred_5260 vdd.$2793.Metal2 vout.$778.Metal2 0.011236f
Cred_5261 vdd.$2793.Metal2 vout.$780.Metal2 0.0109095f
Cred_5262 vdd.$2793.Metal2 vout.$798.Metal2 0.0161311f
Cred_5263 vdd.$2793.Metal2 vout.$800.Metal2 0.0143936f
Cred_5264 vdd.$2793.Metal2 vout.P0.GatPoly 4.87546e-08f
Cred_5265 vdd.$2793.Metal2 vout.P14.pSD 0.00153141f
Cred_5266 vdd.$2793.Metal2 vout.P16.pSD 0.000153001f
Cred_5267 vdd.$2793.Metal2 vss 0.00054183f
Cred_5268 vdd.$2793.Metal2 vss.$1212.Metal5 0.000558794f
Cred_5269 vdd.$2793.Metal2 vss.$1230.Metal5 0.000558794f
Cred_5270 vdd.$2793.Metal2 vss.$1282.Metal5 0.00213895f
Cred_5271 vdd.$2793.Metal2 vss.$1300.Metal5 0.00213895f
Cred_5272 vdd.$2795.Metal2 vout 0.000751109f
Cred_5273 vdd.$2795.Metal2 vout.$1006.Metal3 0.00318522f
Cred_5274 vdd.$2795.Metal2 vout.$1008.Metal3 0.00321584f
Cred_5275 vdd.$2795.Metal2 vout.$1046.Metal3 0.00261547f
Cred_5276 vdd.$2795.Metal2 vout.$1048.Metal3 0.00304052f
Cred_5277 vdd.$2795.Metal2 vout.$1086.Metal3 0.00290434f
Cred_5278 vdd.$2795.Metal2 vout.$1088.Metal3 0.00293996f
Cred_5279 vdd.$2795.Metal2 vout.$1126.Metal3 0.00378078f
Cred_5280 vdd.$2795.Metal2 vout.$1128.Metal3 0.0034066f
Cred_5281 vdd.$2795.Metal2 vout.$1166.Metal3 0.00858103f
Cred_5282 vdd.$2795.Metal2 vout.$1168.Metal3 0.00412871f
Cred_5283 vdd.$2795.Metal2 vout.$1208.Metal3 0.00560635f
Cred_5284 vdd.$2795.Metal2 vout.$1299.Metal4 9.04461e-09f
Cred_5285 vdd.$2795.Metal2 vout.$1313.Metal4 0.00159829f
Cred_5286 vdd.$2795.Metal2 vout.$1323.Metal4 0.00152762f
Cred_5287 vdd.$2795.Metal2 vout.$1333.Metal4 0.00157227f
Cred_5288 vdd.$2795.Metal2 vout.$1343.Metal4 0.00157388f
Cred_5289 vdd.$2795.Metal2 vout.$1353.Metal4 0.00163921f
Cred_5290 vdd.$2795.Metal2 vout.$1363.Metal4 0.00166019f
Cred_5291 vdd.$2795.Metal2 vout.$1373.Metal4 0.00506417f
Cred_5292 vdd.$2795.Metal2 vout.$1384.Metal4 0.00194736f
Cred_5293 vdd.$2795.Metal2 vout.$1395.Metal4 0.00326092f
Cred_5294 vdd.$2795.Metal2 vout.$1405.Metal4 0.00335552f
Cred_5295 vdd.$2795.Metal2 vout.$1415.Metal4 0.00902599f
Cred_5296 vdd.$2795.Metal2 vout.$1416.Metal4 0.00112093f
Cred_5297 vdd.$2795.Metal2 vout.$163.Metal1 0.0148378f
Cred_5298 vdd.$2795.Metal2 vout.$164.Metal1 0.0137949f
Cred_5299 vdd.$2795.Metal2 vout.$213.Metal1 0.0138413f
Cred_5300 vdd.$2795.Metal2 vout.$214.Metal1 0.0128216f
Cred_5301 vdd.$2795.Metal2 vout.$233.Metal1 0.0104256f
Cred_5302 vdd.$2795.Metal2 vout.$234.Metal1 0.00951568f
Cred_5303 vdd.$2795.Metal2 vout.$273.Metal1 0.0105349f
Cred_5304 vdd.$2795.Metal2 vout.$274.Metal1 0.0100508f
Cred_5305 vdd.$2795.Metal2 vout.$293.Metal1 0.010185f
Cred_5306 vdd.$2795.Metal2 vout.$294.Metal1 0.0102963f
Cred_5307 vdd.$2795.Metal2 vout.$333.Metal1 0.0105985f
Cred_5308 vdd.$2795.Metal2 vout.$334.Metal1 0.0103345f
Cred_5309 vdd.$2795.Metal2 vout.$353.Metal1 0.0144134f
Cred_5310 vdd.$2795.Metal2 vout.$354.Metal1 0.0142605f
Cred_5311 vdd.$2795.Metal2 vout.$403.Metal1 0.0159498f
Cred_5312 vdd.$2795.Metal2 vout.$404.Metal1 0.0161636f
Cred_5313 vdd.$2795.Metal2 vout.$598.Metal2 0.0228516f
Cred_5314 vdd.$2795.Metal2 vout.$600.Metal2 0.0225534f
Cred_5315 vdd.$2795.Metal2 vout.$618.Metal2 0.0188492f
Cred_5316 vdd.$2795.Metal2 vout.$620.Metal2 0.0188412f
Cred_5317 vdd.$2795.Metal2 vout.$658.Metal2 0.0197036f
Cred_5318 vdd.$2795.Metal2 vout.$660.Metal2 0.0188258f
Cred_5319 vdd.$2795.Metal2 vout.$678.Metal2 0.0134495f
Cred_5320 vdd.$2795.Metal2 vout.$680.Metal2 0.0134444f
Cred_5321 vdd.$2795.Metal2 vout.$698.Metal2 0.01552f
Cred_5322 vdd.$2795.Metal2 vout.$700.Metal2 0.0146053f
Cred_5323 vdd.$2795.Metal2 vout.$718.Metal2 0.0162901f
Cred_5324 vdd.$2795.Metal2 vout.$720.Metal2 0.0158641f
Cred_5325 vdd.$2795.Metal2 vout.$738.Metal2 0.0254578f
Cred_5326 vdd.$2795.Metal2 vout.$740.Metal2 0.0247959f
Cred_5327 vdd.$2795.Metal2 vout.$778.Metal2 0.0271527f
Cred_5328 vdd.$2795.Metal2 vout.$780.Metal2 0.0263647f
Cred_5329 vdd.$2795.Metal2 vout.$798.Metal2 0.0363023f
Cred_5330 vdd.$2795.Metal2 vout.$800.Metal2 0.0360728f
Cred_5331 vdd.$2795.Metal2 vout.P0.GatPoly 1.17824e-07f
Cred_5332 vdd.$2795.Metal2 vout.P14.pSD 0.000380862f
Cred_5333 vdd.$2795.Metal2 vout.P16.pSD 0.00168512f
Cred_5334 vdd.$2795.Metal2 vss 0.000905324f
Cred_5335 vdd.$2795.Metal2 vss.$1212.Metal5 0.000933668f
Cred_5336 vdd.$2795.Metal2 vss.$1230.Metal5 0.000933668f
Cred_5337 vdd.$2795.Metal2 vss.$1282.Metal5 0.00357389f
Cred_5338 vdd.$2795.Metal2 vss.$1300.Metal5 0.00357389f
Cred_5339 vdd.$2799.Metal2 vout 0.000957459f
Cred_5340 vdd.$2799.Metal2 vout.$1008.Metal3 0.00406029f
Cred_5341 vdd.$2799.Metal2 vout.$1010.Metal3 0.00491633f
Cred_5342 vdd.$2799.Metal2 vout.$1048.Metal3 0.003334f
Cred_5343 vdd.$2799.Metal2 vout.$1050.Metal3 0.00414891f
Cred_5344 vdd.$2799.Metal2 vout.$1070.Metal3 0.0028884f
Cred_5345 vdd.$2799.Metal2 vout.$1088.Metal3 0.00370225f
Cred_5346 vdd.$2799.Metal2 vout.$1110.Metal3 0.00444049f
Cred_5347 vdd.$2799.Metal2 vout.$1128.Metal3 0.00481947f
Cred_5348 vdd.$2799.Metal2 vout.$1150.Metal3 0.00556111f
Cred_5349 vdd.$2799.Metal2 vout.$1168.Metal3 0.00527667f
Cred_5350 vdd.$2799.Metal2 vout.$1190.Metal3 0.011263f
Cred_5351 vdd.$2799.Metal2 vout.$1208.Metal3 0.00691355f
Cred_5352 vdd.$2799.Metal2 vout.$1299.Metal4 1.15294e-08f
Cred_5353 vdd.$2799.Metal2 vout.$1313.Metal4 0.00204721f
Cred_5354 vdd.$2799.Metal2 vout.$1323.Metal4 0.0019473f
Cred_5355 vdd.$2799.Metal2 vout.$1333.Metal4 0.00495752f
Cred_5356 vdd.$2799.Metal2 vout.$1343.Metal4 0.00200627f
Cred_5357 vdd.$2799.Metal2 vout.$1353.Metal4 0.00207485f
Cred_5358 vdd.$2799.Metal2 vout.$1363.Metal4 0.00214421f
Cred_5359 vdd.$2799.Metal2 vout.$1373.Metal4 0.00629655f
Cred_5360 vdd.$2799.Metal2 vout.$1384.Metal4 0.00250339f
Cred_5361 vdd.$2799.Metal2 vout.$1395.Metal4 0.00259504f
Cred_5362 vdd.$2799.Metal2 vout.$1405.Metal4 0.00270158f
Cred_5363 vdd.$2799.Metal2 vout.$1415.Metal4 0.00470436f
Cred_5364 vdd.$2799.Metal2 vout.$1416.Metal4 0.0101825f
Cred_5365 vdd.$2799.Metal2 vout.$164.Metal1 0.0182865f
Cred_5366 vdd.$2799.Metal2 vout.$165.Metal1 0.017585f
Cred_5367 vdd.$2799.Metal2 vout.$214.Metal1 0.0168622f
Cred_5368 vdd.$2799.Metal2 vout.$215.Metal1 0.0163441f
Cred_5369 vdd.$2799.Metal2 vout.$234.Metal1 0.0131427f
Cred_5370 vdd.$2799.Metal2 vout.$235.Metal1 0.0121299f
Cred_5371 vdd.$2799.Metal2 vout.$274.Metal1 0.0127744f
Cred_5372 vdd.$2799.Metal2 vout.$275.Metal1 0.0129041f
Cred_5373 vdd.$2799.Metal2 vout.$294.Metal1 0.0129832f
Cred_5374 vdd.$2799.Metal2 vout.$295.Metal1 0.0132146f
Cred_5375 vdd.$2799.Metal2 vout.$334.Metal1 0.0135102f
Cred_5376 vdd.$2799.Metal2 vout.$335.Metal1 0.0131503f
Cred_5377 vdd.$2799.Metal2 vout.$354.Metal1 0.0183731f
Cred_5378 vdd.$2799.Metal2 vout.$355.Metal1 0.0179884f
Cred_5379 vdd.$2799.Metal2 vout.$404.Metal1 0.0203531f
Cred_5380 vdd.$2799.Metal2 vout.$405.Metal1 0.0208984f
Cred_5381 vdd.$2799.Metal2 vout.$600.Metal2 0.0286002f
Cred_5382 vdd.$2799.Metal2 vout.$602.Metal2 0.0287589f
Cred_5383 vdd.$2799.Metal2 vout.$620.Metal2 0.0240176f
Cred_5384 vdd.$2799.Metal2 vout.$622.Metal2 0.0240239f
Cred_5385 vdd.$2799.Metal2 vout.$660.Metal2 0.0251159f
Cred_5386 vdd.$2799.Metal2 vout.$662.Metal2 0.023983f
Cred_5387 vdd.$2799.Metal2 vout.$680.Metal2 0.0171412f
Cred_5388 vdd.$2799.Metal2 vout.$682.Metal2 0.0262835f
Cred_5389 vdd.$2799.Metal2 vout.$700.Metal2 0.0193357f
Cred_5390 vdd.$2799.Metal2 vout.$720.Metal2 0.0207654f
Cred_5391 vdd.$2799.Metal2 vout.$722.Metal2 0.0293611f
Cred_5392 vdd.$2799.Metal2 vout.$740.Metal2 0.0324517f
Cred_5393 vdd.$2799.Metal2 vout.$742.Metal2 0.0209204f
Cred_5394 vdd.$2799.Metal2 vout.$762.Metal2 0.0217721f
Cred_5395 vdd.$2799.Metal2 vout.$780.Metal2 0.0344988f
Cred_5396 vdd.$2799.Metal2 vout.$782.Metal2 0.022918f
Cred_5397 vdd.$2799.Metal2 vout.$800.Metal2 0.0471192f
Cred_5398 vdd.$2799.Metal2 vout.$802.Metal2 0.0454199f
Cred_5399 vdd.$2799.Metal2 vout.P0.GatPoly 1.50193e-07f
Cred_5400 vdd.$2799.Metal2 vout.P16.pSD 0.00179189f
Cred_5401 vdd.$2799.Metal2 vout.P18.pSD 0.00114881f
Cred_5402 vdd.$2799.Metal2 vss 0.00121456f
Cred_5403 vdd.$2799.Metal2 vss.$1212.Metal5 0.00125259f
Cred_5404 vdd.$2799.Metal2 vss.$1230.Metal5 0.00125259f
Cred_5405 vdd.$2799.Metal2 vss.$1282.Metal5 0.00479465f
Cred_5406 vdd.$2799.Metal2 vss.$1300.Metal5 0.00479465f
Cred_5407 vdd.$2803.Metal2 vout 0.000102432f
Cred_5408 vdd.$2803.Metal2 vout.$1008.Metal3 0.000434382f
Cred_5409 vdd.$2803.Metal2 vout.$1010.Metal3 0.00218728f
Cred_5410 vdd.$2803.Metal2 vout.$1048.Metal3 0.000356682f
Cred_5411 vdd.$2803.Metal2 vout.$1050.Metal3 0.00125977f
Cred_5412 vdd.$2803.Metal2 vout.$1070.Metal3 0.00154437f
Cred_5413 vdd.$2803.Metal2 vout.$1088.Metal3 0.000396078f
Cred_5414 vdd.$2803.Metal2 vout.$1110.Metal3 0.00243779f
Cred_5415 vdd.$2803.Metal2 vout.$1128.Metal3 0.000515601f
Cred_5416 vdd.$2803.Metal2 vout.$1150.Metal3 0.0025435f
Cred_5417 vdd.$2803.Metal2 vout.$1168.Metal3 0.000564514f
Cred_5418 vdd.$2803.Metal2 vout.$1190.Metal3 0.00475956f
Cred_5419 vdd.$2803.Metal2 vout.$1208.Metal3 0.000736975f
Cred_5420 vdd.$2803.Metal2 vout.$1299.Metal4 1.23345e-09f
Cred_5421 vdd.$2803.Metal2 vout.$1313.Metal4 0.000228936f
Cred_5422 vdd.$2803.Metal2 vout.$1323.Metal4 0.000387331f
Cred_5423 vdd.$2803.Metal2 vout.$1333.Metal4 0.00071648f
Cred_5424 vdd.$2803.Metal2 vout.$1343.Metal4 0.00039906f
Cred_5425 vdd.$2803.Metal2 vout.$1353.Metal4 0.000410838f
Cred_5426 vdd.$2803.Metal2 vout.$1363.Metal4 0.000429255f
Cred_5427 vdd.$2803.Metal2 vout.$1373.Metal4 0.00169775f
Cred_5428 vdd.$2803.Metal2 vout.$1384.Metal4 0.00054935f
Cred_5429 vdd.$2803.Metal2 vout.$1395.Metal4 0.000557785f
Cred_5430 vdd.$2803.Metal2 vout.$1405.Metal4 0.000592839f
Cred_5431 vdd.$2803.Metal2 vout.$1415.Metal4 0.000503234f
Cred_5432 vdd.$2803.Metal2 vout.$1416.Metal4 0.00209648f
Cred_5433 vdd.$2803.Metal2 vout.$164.Metal1 0.00195634f
Cred_5434 vdd.$2803.Metal2 vout.$165.Metal1 0.00797768f
Cred_5435 vdd.$2803.Metal2 vout.$214.Metal1 0.00180397f
Cred_5436 vdd.$2803.Metal2 vout.$215.Metal1 0.00726157f
Cred_5437 vdd.$2803.Metal2 vout.$234.Metal1 0.00140604f
Cred_5438 vdd.$2803.Metal2 vout.$235.Metal1 0.00560028f
Cred_5439 vdd.$2803.Metal2 vout.$274.Metal1 0.00136664f
Cred_5440 vdd.$2803.Metal2 vout.$275.Metal1 0.00566914f
Cred_5441 vdd.$2803.Metal2 vout.$294.Metal1 0.00138898f
Cred_5442 vdd.$2803.Metal2 vout.$295.Metal1 0.00578232f
Cred_5443 vdd.$2803.Metal2 vout.$334.Metal1 0.00144536f
Cred_5444 vdd.$2803.Metal2 vout.$335.Metal1 0.00583259f
Cred_5445 vdd.$2803.Metal2 vout.$354.Metal1 0.00196561f
Cred_5446 vdd.$2803.Metal2 vout.$355.Metal1 0.00793477f
Cred_5447 vdd.$2803.Metal2 vout.$404.Metal1 0.00217469f
Cred_5448 vdd.$2803.Metal2 vout.$405.Metal1 0.00912576f
Cred_5449 vdd.$2803.Metal2 vout.$600.Metal2 0.00305974f
Cred_5450 vdd.$2803.Metal2 vout.$602.Metal2 0.0131302f
Cred_5451 vdd.$2803.Metal2 vout.$620.Metal2 0.00256947f
Cred_5452 vdd.$2803.Metal2 vout.$622.Metal2 0.0108708f
Cred_5453 vdd.$2803.Metal2 vout.$660.Metal2 0.00268697f
Cred_5454 vdd.$2803.Metal2 vout.$662.Metal2 0.0112449f
Cred_5455 vdd.$2803.Metal2 vout.$680.Metal2 0.00183382f
Cred_5456 vdd.$2803.Metal2 vout.$682.Metal2 0.0119294f
Cred_5457 vdd.$2803.Metal2 vout.$700.Metal2 0.0020686f
Cred_5458 vdd.$2803.Metal2 vout.$720.Metal2 0.00222155f
Cred_5459 vdd.$2803.Metal2 vout.$722.Metal2 0.0134798f
Cred_5460 vdd.$2803.Metal2 vout.$740.Metal2 0.00347178f
Cred_5461 vdd.$2803.Metal2 vout.$742.Metal2 0.00962551f
Cred_5462 vdd.$2803.Metal2 vout.$762.Metal2 0.010022f
Cred_5463 vdd.$2803.Metal2 vout.$780.Metal2 0.00369079f
Cred_5464 vdd.$2803.Metal2 vout.$782.Metal2 0.0105412f
Cred_5465 vdd.$2803.Metal2 vout.$800.Metal2 0.00490312f
Cred_5466 vdd.$2803.Metal2 vout.$802.Metal2 0.0224793f
Cred_5467 vdd.$2803.Metal2 vout.P0.GatPoly 1.60681e-08f
Cred_5468 vdd.$2803.Metal2 vout.P16.pSD 5.09799e-05f
Cred_5469 vdd.$2803.Metal2 vout.P18.pSD 0.00226901f
Cred_5470 vdd.$2803.Metal2 vss 0.00164697f
Cred_5471 vdd.$2803.Metal2 vss.$1212.Metal5 0.00169854f
Cred_5472 vdd.$2803.Metal2 vss.$1230.Metal5 0.00169854f
Cred_5473 vdd.$2803.Metal2 vss.$1282.Metal5 0.00650165f
Cred_5474 vdd.$2803.Metal2 vss.$1300.Metal5 0.00650165f
Cred_5475 vdd.$2805.Metal2 vout.$1010.Metal3 0.00371948f
Cred_5476 vdd.$2805.Metal2 vout.$1050.Metal3 0.00185091f
Cred_5477 vdd.$2805.Metal2 vout.$1070.Metal3 0.00275542f
Cred_5478 vdd.$2805.Metal2 vout.$1110.Metal3 0.00438317f
Cred_5479 vdd.$2805.Metal2 vout.$1150.Metal3 0.00438243f
Cred_5480 vdd.$2805.Metal2 vout.$1190.Metal3 0.00793046f
Cred_5481 vdd.$2805.Metal2 vout.$1313.Metal4 0.000251023f
Cred_5482 vdd.$2805.Metal2 vout.$1323.Metal4 0.000385545f
Cred_5483 vdd.$2805.Metal2 vout.$1333.Metal4 0.000401443f
Cred_5484 vdd.$2805.Metal2 vout.$1343.Metal4 0.00039722f
Cred_5485 vdd.$2805.Metal2 vout.$1353.Metal4 0.000406785f
Cred_5486 vdd.$2805.Metal2 vout.$1363.Metal4 0.000431106f
Cred_5487 vdd.$2805.Metal2 vout.$1373.Metal4 0.000546051f
Cred_5488 vdd.$2805.Metal2 vout.$1384.Metal4 0.000662096f
Cred_5489 vdd.$2805.Metal2 vout.$1395.Metal4 0.000660269f
Cred_5490 vdd.$2805.Metal2 vout.$1405.Metal4 0.000714511f
Cred_5491 vdd.$2805.Metal2 vout.$1416.Metal4 0.00230099f
Cred_5492 vdd.$2805.Metal2 vout.$165.Metal1 0.0131342f
Cred_5493 vdd.$2805.Metal2 vout.$215.Metal1 0.0118765f
Cred_5494 vdd.$2805.Metal2 vout.$235.Metal1 0.00926735f
Cred_5495 vdd.$2805.Metal2 vout.$275.Metal1 0.00923825f
Cred_5496 vdd.$2805.Metal2 vout.$295.Metal1 0.00941046f
Cred_5497 vdd.$2805.Metal2 vout.$335.Metal1 0.00953233f
Cred_5498 vdd.$2805.Metal2 vout.$355.Metal1 0.0129453f
Cred_5499 vdd.$2805.Metal2 vout.$405.Metal1 0.0147726f
Cred_5500 vdd.$2805.Metal2 vout.$602.Metal2 0.0220853f
Cred_5501 vdd.$2805.Metal2 vout.$622.Metal2 0.0182633f
Cred_5502 vdd.$2805.Metal2 vout.$662.Metal2 0.019089f
Cred_5503 vdd.$2805.Metal2 vout.$682.Metal2 0.020036f
Cred_5504 vdd.$2805.Metal2 vout.$722.Metal2 0.0226533f
Cred_5505 vdd.$2805.Metal2 vout.$742.Metal2 0.0161832f
Cred_5506 vdd.$2805.Metal2 vout.$762.Metal2 0.016853f
Cred_5507 vdd.$2805.Metal2 vout.$782.Metal2 0.0177191f
Cred_5508 vdd.$2805.Metal2 vout.$802.Metal2 0.0348824f
Cred_5509 vdd.$2805.Metal2 vout.P18.pSD 0.000339399f
Cred_5510 vdd.$2805.Metal2 vss 0.00270654f
Cred_5511 vdd.$2805.Metal2 vss.$1212.Metal5 0.00279128f
Cred_5512 vdd.$2805.Metal2 vss.$1230.Metal5 0.00279128f
Cred_5513 vdd.$2805.Metal2 vss.$1282.Metal5 0.0106844f
Cred_5514 vdd.$2805.Metal2 vss.$1300.Metal5 0.0106844f
Cred_5515 vdd.$2807.Metal2 vout.$1010.Metal3 0.00178932f
Cred_5516 vdd.$2807.Metal2 vout.$1050.Metal3 0.00118509f
Cred_5517 vdd.$2807.Metal2 vout.$1070.Metal3 0.001199f
Cred_5518 vdd.$2807.Metal2 vout.$1110.Metal3 0.00197261f
Cred_5519 vdd.$2807.Metal2 vout.$1150.Metal3 0.00235023f
Cred_5520 vdd.$2807.Metal2 vout.$1190.Metal3 0.00430348f
Cred_5521 vdd.$2807.Metal2 vout.$1313.Metal4 0.002909f
Cred_5522 vdd.$2807.Metal2 vout.$1333.Metal4 7.50845e-06f
Cred_5523 vdd.$2807.Metal2 vout.$1363.Metal4 8.06326e-06f
Cred_5524 vdd.$2807.Metal2 vout.$1373.Metal4 0.000595436f
Cred_5525 vdd.$2807.Metal2 vout.$1384.Metal4 0.000705862f
Cred_5526 vdd.$2807.Metal2 vout.$1395.Metal4 0.000720058f
Cred_5527 vdd.$2807.Metal2 vout.$1405.Metal4 0.000761743f
Cred_5528 vdd.$2807.Metal2 vout.$1416.Metal4 0.00171914f
Cred_5529 vdd.$2807.Metal2 vout.$165.Metal1 4.49542e-05f
Cred_5530 vdd.$2807.Metal2 vout.$215.Metal1 2.9329e-05f
Cred_5531 vdd.$2807.Metal2 vout.$235.Metal1 3.11065e-06f
Cred_5532 vdd.$2807.Metal2 vout.$275.Metal1 1.56439e-05f
Cred_5533 vdd.$2807.Metal2 vout.$295.Metal1 1.52211e-05f
Cred_5534 vdd.$2807.Metal2 vout.$405.Metal1 6.91568e-05f
Cred_5535 vdd.$2807.Metal2 vout.$602.Metal2 0.00546754f
Cred_5536 vdd.$2807.Metal2 vout.$622.Metal2 0.00487788f
Cred_5537 vdd.$2807.Metal2 vout.$662.Metal2 0.0050087f
Cred_5538 vdd.$2807.Metal2 vout.$682.Metal2 0.00504514f
Cred_5539 vdd.$2807.Metal2 vout.$722.Metal2 0.00488167f
Cred_5540 vdd.$2807.Metal2 vout.$742.Metal2 0.00344407f
Cred_5541 vdd.$2807.Metal2 vout.$762.Metal2 0.00359759f
Cred_5542 vdd.$2807.Metal2 vout.$782.Metal2 0.00374828f
Cred_5543 vdd.$2807.Metal2 vout.$802.Metal2 0.00745504f
Cred_5544 vdd.$2807.Metal2 vss 0.00761498f
Cred_5545 vdd.$2807.Metal2 vss.$1212.Metal5 0.00785339f
Cred_5546 vdd.$2807.Metal2 vss.$1230.Metal5 0.00785339f
Cred_5547 vdd.$2807.Metal2 vss.$1282.Metal5 0.0300612f
Cred_5548 vdd.$2807.Metal2 vss.$1300.Metal5 0.0300612f
Cred_5549 vdd.$2809.Metal2 vss 0.0018088f
Cred_5550 vdd.$2809.Metal2 vss.$1212.Metal5 0.00186543f
Cred_5551 vdd.$2809.Metal2 vss.$1230.Metal5 0.00186543f
Cred_5552 vdd.$2809.Metal2 vss.$1282.Metal5 0.00714046f
Cred_5553 vdd.$2809.Metal2 vss.$1300.Metal5 0.00714046f
Cred_5554 vdd.$2979.Metal3 vss.$1282.Metal5 0.0301728f
Cred_5555 vdd.$2983.Metal3 vout.P0.pSD 0.00176145f
Cred_5556 vdd.$2983.Metal3 vss.$1282.Metal5 0.0223153f
Cred_5557 vdd.$2987.Metal3 vout.$1032.Metal3 8.32148e-06f
Cred_5558 vdd.$2987.Metal3 vout.$1034.Metal3 9.86007e-06f
Cred_5559 vdd.$2987.Metal3 vout.$1072.Metal3 4.02449e-06f
Cred_5560 vdd.$2987.Metal3 vout.$1074.Metal3 5.42491e-06f
Cred_5561 vdd.$2987.Metal3 vout.$1112.Metal3 1.33327e-05f
Cred_5562 vdd.$2987.Metal3 vout.$1114.Metal3 5.7919e-06f
Cred_5563 vdd.$2987.Metal3 vout.$1152.Metal3 0.00128993f
Cred_5564 vdd.$2987.Metal3 vout.$1154.Metal3 1.40184e-05f
Cred_5565 vdd.$2987.Metal3 vout.$1328.Metal4 2.74819e-06f
Cred_5566 vdd.$2987.Metal3 vout.$1329.Metal4 2.75463e-06f
Cred_5567 vdd.$2987.Metal3 vout.$1368.Metal4 0.000152436f
Cred_5568 vdd.$2987.Metal3 vout.$1369.Metal4 0.00101675f
Cred_5569 vdd.$2987.Metal3 vout.$1408.Metal4 0.00207226f
Cred_5570 vdd.$2987.Metal3 vout.$156.Metal1 2.24703e-05f
Cred_5571 vdd.$2987.Metal3 vout.$157.Metal1 2.24328e-05f
Cred_5572 vdd.$2987.Metal3 vout.$206.Metal1 2.06567e-05f
Cred_5573 vdd.$2987.Metal3 vout.$207.Metal1 2.06168e-05f
Cred_5574 vdd.$2987.Metal3 vout.$226.Metal1 1.57111e-05f
Cred_5575 vdd.$2987.Metal3 vout.$227.Metal1 1.53009e-05f
Cred_5576 vdd.$2987.Metal3 vout.$266.Metal1 1.5935e-05f
Cred_5577 vdd.$2987.Metal3 vout.$267.Metal1 1.58502e-05f
Cred_5578 vdd.$2987.Metal3 vout.$286.Metal1 1.66352e-05f
Cred_5579 vdd.$2987.Metal3 vout.$287.Metal1 1.62535e-05f
Cred_5580 vdd.$2987.Metal3 vout.$326.Metal1 1.7042e-05f
Cred_5581 vdd.$2987.Metal3 vout.$327.Metal1 1.66176e-05f
Cred_5582 vdd.$2987.Metal3 vout.$346.Metal1 2.31762e-05f
Cred_5583 vdd.$2987.Metal3 vout.$347.Metal1 2.29305e-05f
Cred_5584 vdd.$2987.Metal3 vout.$396.Metal1 2.73643e-05f
Cred_5585 vdd.$2987.Metal3 vout.$397.Metal1 2.59548e-05f
Cred_5586 vdd.$2987.Metal3 vout.$584.Metal2 3.74532e-05f
Cred_5587 vdd.$2987.Metal3 vout.$586.Metal2 3.66208e-05f
Cred_5588 vdd.$2987.Metal3 vout.$604.Metal2 3.03786e-05f
Cred_5589 vdd.$2987.Metal3 vout.$606.Metal2 3.0388e-05f
Cred_5590 vdd.$2987.Metal3 vout.$644.Metal2 3.09725e-05f
Cred_5591 vdd.$2987.Metal3 vout.$646.Metal2 3.09777e-05f
Cred_5592 vdd.$2987.Metal3 vout.$664.Metal2 2.23336e-05f
Cred_5593 vdd.$2987.Metal3 vout.$666.Metal2 2.16181e-05f
Cred_5594 vdd.$2987.Metal3 vout.$684.Metal2 2.43733e-05f
Cred_5595 vdd.$2987.Metal3 vout.$686.Metal2 2.34834e-05f
Cred_5596 vdd.$2987.Metal3 vout.$704.Metal2 2.6194e-05f
Cred_5597 vdd.$2987.Metal3 vout.$706.Metal2 2.55089e-05f
Cred_5598 vdd.$2987.Metal3 vout.$724.Metal2 4.10054e-05f
Cred_5599 vdd.$2987.Metal3 vout.$726.Metal2 3.9871e-05f
Cred_5600 vdd.$2987.Metal3 vout.$764.Metal2 6.89063e-05f
Cred_5601 vdd.$2987.Metal3 vout.$766.Metal2 4.25415e-05f
Cred_5602 vdd.$2987.Metal3 vout.$784.Metal2 0.000196106f
Cred_5603 vdd.$2987.Metal3 vout.$786.Metal2 5.6512e-05f
Cred_5604 vdd.$2987.Metal3 vout.P0.pSD 0.00322035f
Cred_5605 vdd.$2987.Metal3 vout.P2.pSD 5.94552e-07f
Cred_5606 vdd.$2987.Metal3 vss.$1282.Metal5 0.0158132f
Cred_5607 vdd.$2991.Metal3 vout.$1154.Metal3 0.00201396f
Cred_5608 vdd.$2991.Metal3 vout.$1369.Metal4 0.00385556f
Cred_5609 vdd.$2991.Metal3 vout.$397.Metal1 2.74705e-06f
Cred_5610 vdd.$2991.Metal3 vout.$766.Metal2 4.03687e-05f
Cred_5611 vdd.$2991.Metal3 vout.$786.Metal2 0.000220281f
Cred_5612 vdd.$2991.Metal3 vout.P2.pSD 0.0038321f
Cred_5613 vdd.$2991.Metal3 vss.$1282.Metal5 0.0142107f
Cred_5614 vdd.$2995.Metal3 vout.$1156.Metal3 0.00142802f
Cred_5615 vdd.$2995.Metal3 vout.$1369.Metal4 0.00114439f
Cred_5616 vdd.$2995.Metal3 vout.$1370.Metal4 0.00348884f
Cred_5617 vdd.$2995.Metal3 vout.$398.Metal1 1.73337e-06f
Cred_5618 vdd.$2995.Metal3 vout.$768.Metal2 2.8624e-05f
Cred_5619 vdd.$2995.Metal3 vout.$788.Metal2 0.000145425f
Cred_5620 vdd.$2995.Metal3 vout.P4.pSD 0.00428114f
Cred_5621 vdd.$2995.Metal3 vss.$1282.Metal5 0.0142498f
Cred_5622 vdd.$2999.Metal3 vout.$1156.Metal3 0.000572196f
Cred_5623 vdd.$2999.Metal3 vout.$1158.Metal3 0.000995123f
Cred_5624 vdd.$2999.Metal3 vout.$1370.Metal4 0.00109908f
Cred_5625 vdd.$2999.Metal3 vout.$1371.Metal4 0.00293668f
Cred_5626 vdd.$2999.Metal3 vout.$398.Metal1 6.94546e-07f
Cred_5627 vdd.$2999.Metal3 vout.$399.Metal1 1.20791e-06f
Cred_5628 vdd.$2999.Metal3 vout.$768.Metal2 1.14694e-05f
Cred_5629 vdd.$2999.Metal3 vout.$770.Metal2 1.99467e-05f
Cred_5630 vdd.$2999.Metal3 vout.$788.Metal2 5.82706e-05f
Cred_5631 vdd.$2999.Metal3 vout.$790.Metal2 0.00010134f
Cred_5632 vdd.$2999.Metal3 vout.P4.pSD 0.0007167f
Cred_5633 vdd.$2999.Metal3 vout.P6.pSD 0.00181697f
Cred_5634 vdd.$2999.Metal3 vss.$1282.Metal5 0.0142756f
Cred_5635 vdd.$3003.Metal3 vout.$1158.Metal3 0.000995123f
Cred_5636 vdd.$3003.Metal3 vout.$1180.Metal3 0.000525948f
Cred_5637 vdd.$3003.Metal3 vout.$1371.Metal4 0.00305623f
Cred_5638 vdd.$3003.Metal3 vout.$1372.Metal4 0.00110378f
Cred_5639 vdd.$3003.Metal3 vout.$399.Metal1 1.20791e-06f
Cred_5640 vdd.$3003.Metal3 vout.$400.Metal1 4.11899e-07f
Cred_5641 vdd.$3003.Metal3 vout.$770.Metal2 1.99467e-05f
Cred_5642 vdd.$3003.Metal3 vout.$790.Metal2 0.00010134f
Cred_5643 vdd.$3003.Metal3 vout.$792.Metal2 3.12232e-05f
Cred_5644 vdd.$3003.Metal3 vout.P6.pSD 0.00181697f
Cred_5645 vdd.$3003.Metal3 vout.P8.pSD 0.0017348f
Cred_5646 vdd.$3003.Metal3 vss 0.000251669f
Cred_5647 vdd.$3003.Metal3 vss.$1212.Metal5 0.000259548f
Cred_5648 vdd.$3003.Metal3 vss.$1230.Metal5 0.000259548f
Cred_5649 vdd.$3003.Metal3 vss.$1282.Metal5 0.0125491f
Cred_5650 vdd.$3003.Metal3 vss.$1300.Metal5 0.000993495f
Cred_5651 vdd.$3007.Metal3 vout.$1180.Metal3 0.00170228f
Cred_5652 vdd.$3007.Metal3 vout.$1372.Metal4 0.00467039f
Cred_5653 vdd.$3007.Metal3 vout.$400.Metal1 1.33315e-06f
Cred_5654 vdd.$3007.Metal3 vout.$792.Metal2 0.000101057f
Cred_5655 vdd.$3007.Metal3 vout.P8.pSD 0.00309446f
Cred_5656 vdd.$3007.Metal3 vss 0.000602957f
Cred_5657 vdd.$3007.Metal3 vss.$1212.Metal5 0.000621834f
Cred_5658 vdd.$3007.Metal3 vss.$1230.Metal5 0.000621834f
Cred_5659 vdd.$3007.Metal3 vss.$1282.Metal5 0.00461537f
Cred_5660 vdd.$3007.Metal3 vss.$1300.Metal5 0.00238025f
Cred_5661 vdd.$3011.Metal3 vout.$1372.Metal4 0.00289683f
Cred_5662 vdd.$3011.Metal3 vout.$1383.Metal4 0.00289683f
Cred_5663 vdd.$3011.Metal3 vref 0.000173248f
Cred_5664 vdd.$3011.Metal3 vref.P0.GatPoly 6.7557e-06f
Cred_5665 vdd.$3011.Metal3 vref.P0.nSD 3.87282e-05f
Cred_5666 vdd.$3011.Metal3 vref.P0.pSD 0.00918614f
Cred_5667 vdd.$3011.Metal3 vss.$1282.Metal5 0.000501635f
Cred_5668 vdd.$3015.Metal3 vout.$1162.Metal3 0.00152989f
Cred_5669 vdd.$3015.Metal3 vout.$1373.Metal4 0.00136147f
Cred_5670 vdd.$3015.Metal3 vout.$1383.Metal4 0.00368511f
Cred_5671 vdd.$3015.Metal3 vout.$401.Metal1 1.85702e-06f
Cred_5672 vdd.$3015.Metal3 vout.$774.Metal2 3.06658e-05f
Cred_5673 vdd.$3015.Metal3 vout.$794.Metal2 0.000155799f
Cred_5674 vdd.$3015.Metal3 vout.P10.pSD 0.00247619f
Cred_5675 vdd.$3015.Metal3 vss 0.000647491f
Cred_5676 vdd.$3015.Metal3 vss.$1212.Metal5 0.000667762f
Cred_5677 vdd.$3015.Metal3 vss.$1230.Metal5 0.000667762f
Cred_5678 vdd.$3015.Metal3 vss.$1282.Metal5 0.00255606f
Cred_5679 vdd.$3015.Metal3 vss.$1300.Metal5 0.00255606f
Cred_5680 vdd.$3019.Metal3 vout.$1162.Metal3 0.000472685f
Cred_5681 vdd.$3019.Metal3 vout.$1164.Metal3 0.000995123f
Cred_5682 vdd.$3019.Metal3 vout.$1373.Metal4 0.00597399f
Cred_5683 vdd.$3019.Metal3 vout.$1383.Metal4 5.87626e-05f
Cred_5684 vdd.$3019.Metal3 vout.$1394.Metal4 0.00012371f
Cred_5685 vdd.$3019.Metal3 vout.$401.Metal1 5.73757e-07f
Cred_5686 vdd.$3019.Metal3 vout.$402.Metal1 1.20791e-06f
Cred_5687 vdd.$3019.Metal3 vout.$774.Metal2 9.47471e-06f
Cred_5688 vdd.$3019.Metal3 vout.$776.Metal2 1.99467e-05f
Cred_5689 vdd.$3019.Metal3 vout.$794.Metal2 4.81367e-05f
Cred_5690 vdd.$3019.Metal3 vout.$796.Metal2 0.00010134f
Cred_5691 vdd.$3019.Metal3 vout.P10.pSD 0.00111653f
Cred_5692 vdd.$3019.Metal3 vout.P12.pSD 0.00181697f
Cred_5693 vdd.$3019.Metal3 vss 0.00112195f
Cred_5694 vdd.$3019.Metal3 vss.$1212.Metal5 0.00115708f
Cred_5695 vdd.$3019.Metal3 vss.$1230.Metal5 0.00115708f
Cred_5696 vdd.$3019.Metal3 vss.$1282.Metal5 0.00442906f
Cred_5697 vdd.$3019.Metal3 vss.$1300.Metal5 0.00442906f
Cred_5698 vdd.$3023.Metal3 vout.$1164.Metal3 0.000995123f
Cred_5699 vdd.$3023.Metal3 vout.$1166.Metal3 0.000572196f
Cred_5700 vdd.$3023.Metal3 vout.$1373.Metal4 0.00585807f
Cred_5701 vdd.$3023.Metal3 vout.$1394.Metal4 0.000151189f
Cred_5702 vdd.$3023.Metal3 vout.$1415.Metal4 8.18456e-05f
Cred_5703 vdd.$3023.Metal3 vout.$402.Metal1 1.20791e-06f
Cred_5704 vdd.$3023.Metal3 vout.$403.Metal1 6.94546e-07f
Cred_5705 vdd.$3023.Metal3 vout.$776.Metal2 1.99467e-05f
Cred_5706 vdd.$3023.Metal3 vout.$778.Metal2 1.14694e-05f
Cred_5707 vdd.$3023.Metal3 vout.$796.Metal2 0.00010134f
Cred_5708 vdd.$3023.Metal3 vout.$798.Metal2 5.82706e-05f
Cred_5709 vdd.$3023.Metal3 vout.P12.pSD 0.00181697f
Cred_5710 vdd.$3023.Metal3 vout.P14.pSD 0.0007167f
Cred_5711 vdd.$3023.Metal3 vss 0.00112413f
Cred_5712 vdd.$3023.Metal3 vss.$1212.Metal5 0.00115932f
Cred_5713 vdd.$3023.Metal3 vss.$1230.Metal5 0.00115932f
Cred_5714 vdd.$3023.Metal3 vss.$1282.Metal5 0.00443764f
Cred_5715 vdd.$3023.Metal3 vss.$1300.Metal5 0.00443764f
Cred_5716 vdd.$3027.Metal3 vout.$1166.Metal3 0.00142802f
Cred_5717 vdd.$3027.Metal3 vout.$1373.Metal4 0.00603152f
Cred_5718 vdd.$3027.Metal3 vout.$1415.Metal4 0.000227254f
Cred_5719 vdd.$3027.Metal3 vout.$403.Metal1 1.73337e-06f
Cred_5720 vdd.$3027.Metal3 vout.$778.Metal2 2.8624e-05f
Cred_5721 vdd.$3027.Metal3 vout.$798.Metal2 0.000145425f
Cred_5722 vdd.$3027.Metal3 vout.P14.pSD 0.002167f
Cred_5723 vdd.$3027.Metal3 vss 0.00112128f
Cred_5724 vdd.$3027.Metal3 vss.$1212.Metal5 0.00115638f
Cred_5725 vdd.$3027.Metal3 vss.$1230.Metal5 0.00115638f
Cred_5726 vdd.$3027.Metal3 vss.$1282.Metal5 0.00442639f
Cred_5727 vdd.$3027.Metal3 vss.$1300.Metal5 0.00442639f
Cred_5728 vdd.$3031.Metal3 vout.$1208.Metal3 0.00241817f
Cred_5729 vdd.$3031.Metal3 vout.$1373.Metal4 0.00550068f
Cred_5730 vdd.$3031.Metal3 vout.$1415.Metal4 9.1522e-05f
Cred_5731 vdd.$3031.Metal3 vout.$404.Metal1 1.23038e-06f
Cred_5732 vdd.$3031.Metal3 vout.$800.Metal2 6.17757e-05f
Cred_5733 vdd.$3031.Metal3 vout.P16.pSD 0.00374145f
Cred_5734 vdd.$3031.Metal3 vss 0.00112636f
Cred_5735 vdd.$3031.Metal3 vss.$1212.Metal5 0.00116163f
Cred_5736 vdd.$3031.Metal3 vss.$1230.Metal5 0.00116163f
Cred_5737 vdd.$3031.Metal3 vss.$1282.Metal5 0.00444647f
Cred_5738 vdd.$3031.Metal3 vss.$1300.Metal5 0.00444647f
Cred_5739 vdd.$3035.Metal3 vout 1.20776e-06f
Cred_5740 vdd.$3035.Metal3 vout.$1008.Metal3 5.12173e-06f
Cred_5741 vdd.$3035.Metal3 vout.$1010.Metal3 6.20157e-06f
Cred_5742 vdd.$3035.Metal3 vout.$1048.Metal3 4.20558e-06f
Cred_5743 vdd.$3035.Metal3 vout.$1050.Metal3 5.23352e-06f
Cred_5744 vdd.$3035.Metal3 vout.$1070.Metal3 3.64349e-06f
Cred_5745 vdd.$3035.Metal3 vout.$1088.Metal3 4.67009e-06f
Cred_5746 vdd.$3035.Metal3 vout.$1110.Metal3 5.60133e-06f
Cred_5747 vdd.$3035.Metal3 vout.$1128.Metal3 6.07938e-06f
Cred_5748 vdd.$3035.Metal3 vout.$1150.Metal3 7.01491e-06f
Cred_5749 vdd.$3035.Metal3 vout.$1168.Metal3 6.6561e-06f
Cred_5750 vdd.$3035.Metal3 vout.$1190.Metal3 0.00141639f
Cred_5751 vdd.$3035.Metal3 vout.$1208.Metal3 8.68956e-06f
Cred_5752 vdd.$3035.Metal3 vout.$1299.Metal4 1.45434e-11f
Cred_5753 vdd.$3035.Metal3 vout.$1313.Metal4 2.58239e-06f
Cred_5754 vdd.$3035.Metal3 vout.$1323.Metal4 2.45637e-06f
Cred_5755 vdd.$3035.Metal3 vout.$1333.Metal4 6.25352e-06f
Cred_5756 vdd.$3035.Metal3 vout.$1343.Metal4 2.53075e-06f
Cred_5757 vdd.$3035.Metal3 vout.$1353.Metal4 2.61725e-06f
Cred_5758 vdd.$3035.Metal3 vout.$1363.Metal4 2.70475e-06f
Cred_5759 vdd.$3035.Metal3 vout.$1373.Metal4 0.00436183f
Cred_5760 vdd.$3035.Metal3 vout.$1384.Metal4 3.15783e-06f
Cred_5761 vdd.$3035.Metal3 vout.$1395.Metal4 3.27343e-06f
Cred_5762 vdd.$3035.Metal3 vout.$1405.Metal4 3.40783e-06f
Cred_5763 vdd.$3035.Metal3 vout.$1415.Metal4 5.93356e-06f
Cred_5764 vdd.$3035.Metal3 vout.$1416.Metal4 0.000152423f
Cred_5765 vdd.$3035.Metal3 vout.$164.Metal1 2.3067e-05f
Cred_5766 vdd.$3035.Metal3 vout.$165.Metal1 2.2182e-05f
Cred_5767 vdd.$3035.Metal3 vout.$214.Metal1 2.12703e-05f
Cred_5768 vdd.$3035.Metal3 vout.$215.Metal1 2.06168e-05f
Cred_5769 vdd.$3035.Metal3 vout.$234.Metal1 1.65784e-05f
Cred_5770 vdd.$3035.Metal3 vout.$235.Metal1 1.53009e-05f
Cred_5771 vdd.$3035.Metal3 vout.$274.Metal1 1.61138e-05f
Cred_5772 vdd.$3035.Metal3 vout.$275.Metal1 1.62775e-05f
Cred_5773 vdd.$3035.Metal3 vout.$294.Metal1 1.63772e-05f
Cred_5774 vdd.$3035.Metal3 vout.$295.Metal1 1.66692e-05f
Cred_5775 vdd.$3035.Metal3 vout.$334.Metal1 1.7042e-05f
Cred_5776 vdd.$3035.Metal3 vout.$335.Metal1 1.65881e-05f
Cred_5777 vdd.$3035.Metal3 vout.$354.Metal1 2.31762e-05f
Cred_5778 vdd.$3035.Metal3 vout.$355.Metal1 2.2691e-05f
Cred_5779 vdd.$3035.Metal3 vout.$404.Metal1 2.56415e-05f
Cred_5780 vdd.$3035.Metal3 vout.$405.Metal1 2.76284e-05f
Cred_5781 vdd.$3035.Metal3 vout.$600.Metal2 3.6077e-05f
Cred_5782 vdd.$3035.Metal3 vout.$602.Metal2 3.62771e-05f
Cred_5783 vdd.$3035.Metal3 vout.$620.Metal2 3.02963e-05f
Cred_5784 vdd.$3035.Metal3 vout.$622.Metal2 3.03043e-05f
Cred_5785 vdd.$3035.Metal3 vout.$660.Metal2 3.16817e-05f
Cred_5786 vdd.$3035.Metal3 vout.$662.Metal2 3.02527e-05f
Cred_5787 vdd.$3035.Metal3 vout.$680.Metal2 2.16223e-05f
Cred_5788 vdd.$3035.Metal3 vout.$682.Metal2 3.31546e-05f
Cred_5789 vdd.$3035.Metal3 vout.$700.Metal2 2.43905e-05f
Cred_5790 vdd.$3035.Metal3 vout.$720.Metal2 2.6194e-05f
Cred_5791 vdd.$3035.Metal3 vout.$722.Metal2 3.70367e-05f
Cred_5792 vdd.$3035.Metal3 vout.$740.Metal2 4.09353e-05f
Cred_5793 vdd.$3035.Metal3 vout.$742.Metal2 2.63895e-05f
Cred_5794 vdd.$3035.Metal3 vout.$762.Metal2 2.74638e-05f
Cred_5795 vdd.$3035.Metal3 vout.$780.Metal2 4.35175e-05f
Cred_5796 vdd.$3035.Metal3 vout.$782.Metal2 2.89092e-05f
Cred_5797 vdd.$3035.Metal3 vout.$800.Metal2 5.7812e-05f
Cred_5798 vdd.$3035.Metal3 vout.$802.Metal2 0.000149002f
Cred_5799 vdd.$3035.Metal3 vout.P0.GatPoly 1.89457e-10f
Cred_5800 vdd.$3035.Metal3 vout.P16.pSD 6.01096e-07f
Cred_5801 vdd.$3035.Metal3 vout.P18.pSD 0.00342672f
Cred_5802 vdd.$3035.Metal3 vss 0.00131032f
Cred_5803 vdd.$3035.Metal3 vss.$1212.Metal5 0.00135135f
Cred_5804 vdd.$3035.Metal3 vss.$1230.Metal5 0.00135135f
Cred_5805 vdd.$3035.Metal3 vss.$1282.Metal5 0.00517268f
Cred_5806 vdd.$3035.Metal3 vss.$1300.Metal5 0.00517268f
Cred_5807 vdd.$3039.Metal3 vout.P18.pSD 0.0007167f
Cred_5808 vdd.$3039.Metal3 vss 0.00203646f
Cred_5809 vdd.$3039.Metal3 vss.$1212.Metal5 0.00210022f
Cred_5810 vdd.$3039.Metal3 vss.$1230.Metal5 0.00210022f
Cred_5811 vdd.$3039.Metal3 vss.$1282.Metal5 0.00803921f
Cred_5812 vdd.$3039.Metal3 vss.$1300.Metal5 0.00803921f
Cred_5813 vdd.$3043.Metal3 vss 0.00275352f
Cred_5814 vdd.$3043.Metal3 vss.$1212.Metal5 0.00283973f
Cred_5815 vdd.$3043.Metal3 vss.$1230.Metal5 0.00283973f
Cred_5816 vdd.$3043.Metal3 vss.$1282.Metal5 0.0108699f
Cred_5817 vdd.$3043.Metal3 vss.$1300.Metal5 0.0108699f
Cred_5818 vdd.$3213.Metal4 vss.$1282.Metal5 0.0195784f
Cred_5819 vdd.$3215.Metal4 vss.$1282.Metal5 0.0143361f
Cred_5820 vdd.$3219.Metal4 vout.$1408.Metal4 0.00742695f
Cred_5821 vdd.$3219.Metal4 vout.P0.pSD 0.00144985f
Cred_5822 vdd.$3219.Metal4 vss.$1282.Metal5 0.0160019f
Cred_5823 vdd.$3223.Metal4 vout.$1369.Metal4 0.00931906f
Cred_5824 vdd.$3223.Metal4 vout.$1408.Metal4 0.00822628f
Cred_5825 vdd.$3223.Metal4 vss.$1282.Metal5 0.0105911f
Cred_5826 vdd.$3227.Metal4 vout.$1369.Metal4 0.00996022f
Cred_5827 vdd.$3227.Metal4 vout.$1370.Metal4 0.0057546f
Cred_5828 vdd.$3227.Metal4 vss.$1282.Metal5 0.0106009f
Cred_5829 vdd.$3231.Metal4 vout.$1156.Metal3 6.74668e-06f
Cred_5830 vdd.$3231.Metal4 vout.$1370.Metal4 0.0118715f
Cred_5831 vdd.$3231.Metal4 vout.$1371.Metal4 0.00233052f
Cred_5832 vdd.$3231.Metal4 vout.$398.Metal1 8.18929e-09f
Cred_5833 vdd.$3231.Metal4 vout.$768.Metal2 1.35233e-07f
Cred_5834 vdd.$3231.Metal4 vout.$788.Metal2 6.8706e-07f
Cred_5835 vdd.$3231.Metal4 vout.P4.pSD 8.4505e-06f
Cred_5836 vdd.$3231.Metal4 vss.$1282.Metal5 0.0105554f
Cred_5837 vdd.$3235.Metal4 vout.$1158.Metal3 1.17334e-05f
Cred_5838 vdd.$3235.Metal4 vout.$1370.Metal4 0.000908508f
Cred_5839 vdd.$3235.Metal4 vout.$1371.Metal4 0.0121889f
Cred_5840 vdd.$3235.Metal4 vout.$399.Metal1 1.42422e-08f
Cred_5841 vdd.$3235.Metal4 vout.$770.Metal2 2.35188e-07f
Cred_5842 vdd.$3235.Metal4 vout.$790.Metal2 1.19489e-06f
Cred_5843 vdd.$3235.Metal4 vout.P6.pSD 2.14236e-05f
Cred_5844 vdd.$3235.Metal4 vss.$1282.Metal5 0.00805268f
Cred_5845 vdd.$3237.Metal4 vout.$1371.Metal4 0.00503573f
Cred_5846 vdd.$3237.Metal4 vout.$1372.Metal4 0.00151871f
Cred_5847 vdd.$3237.Metal4 vss.$1282.Metal5 0.00550193f
Cred_5848 vdd.$3239.Metal4 vout.$1180.Metal3 6.20137e-06f
Cred_5849 vdd.$3239.Metal4 vout.$1372.Metal4 0.00980648f
Cred_5850 vdd.$3239.Metal4 vout.$400.Metal1 4.85664e-09f
Cred_5851 vdd.$3239.Metal4 vout.$792.Metal2 3.68148e-07f
Cred_5852 vdd.$3239.Metal4 vout.P8.pSD 2.04547e-05f
Cred_5853 vdd.$3239.Metal4 vss 0.000570392f
Cred_5854 vdd.$3239.Metal4 vss.$1212.Metal5 0.00058825f
Cred_5855 vdd.$3239.Metal4 vss.$1230.Metal5 0.00058825f
Cred_5856 vdd.$3239.Metal4 vss.$1282.Metal5 0.0022601f
Cred_5857 vdd.$3239.Metal4 vss.$1300.Metal5 0.0022517f
Cred_5858 vdd.$3243.Metal4 vout.$1372.Metal4 0.0114299f
Cred_5859 vdd.$3243.Metal4 vout.$1383.Metal4 0.00161951f
Cred_5860 vdd.$3243.Metal4 vss 0.00014373f
Cred_5861 vdd.$3243.Metal4 vss.$1212.Metal5 0.00014823f
Cred_5862 vdd.$3243.Metal4 vss.$1230.Metal5 0.00014823f
Cred_5863 vdd.$3243.Metal4 vss.$1282.Metal5 0.000614187f
Cred_5864 vdd.$3243.Metal4 vss.$1300.Metal5 0.000567393f
Cred_5865 vdd.$3247.Metal4 vout.$1372.Metal4 0.00161951f
Cred_5866 vdd.$3247.Metal4 vout.$1383.Metal4 0.0114299f
Cred_5867 vdd.$3247.Metal4 vss 0.000157057f
Cred_5868 vdd.$3247.Metal4 vss.$1212.Metal5 0.000161974f
Cred_5869 vdd.$3247.Metal4 vss.$1230.Metal5 0.000161974f
Cred_5870 vdd.$3247.Metal4 vss.$1282.Metal5 0.000620003f
Cred_5871 vdd.$3247.Metal4 vss.$1300.Metal5 0.00064949f
Cred_5872 vdd.$3251.Metal4 vout.$1162.Metal3 5.57336e-06f
Cred_5873 vdd.$3251.Metal4 vout.$1373.Metal4 1.60529e-05f
Cred_5874 vdd.$3251.Metal4 vout.$1383.Metal4 0.00979416f
Cred_5875 vdd.$3251.Metal4 vout.$401.Metal1 6.76508e-09f
Cred_5876 vdd.$3251.Metal4 vout.$774.Metal2 1.11715e-07f
Cred_5877 vdd.$3251.Metal4 vout.$794.Metal2 5.67573e-07f
Cred_5878 vdd.$3251.Metal4 vout.P10.pSD 1.31648e-05f
Cred_5879 vdd.$3251.Metal4 vss 0.000634692f
Cred_5880 vdd.$3251.Metal4 vss.$1212.Metal5 0.000654563f
Cred_5881 vdd.$3251.Metal4 vss.$1230.Metal5 0.000654563f
Cred_5882 vdd.$3251.Metal4 vss.$1282.Metal5 0.00250553f
Cred_5883 vdd.$3251.Metal4 vss.$1300.Metal5 0.00250553f
Cred_5884 vdd.$3253.Metal4 vout.$1383.Metal4 0.00151871f
Cred_5885 vdd.$3253.Metal4 vout.$1394.Metal4 0.00503573f
Cred_5886 vdd.$3253.Metal4 vss 0.000502098f
Cred_5887 vdd.$3253.Metal4 vss.$1212.Metal5 0.000517818f
Cred_5888 vdd.$3253.Metal4 vss.$1230.Metal5 0.000517818f
Cred_5889 vdd.$3253.Metal4 vss.$1282.Metal5 0.0019821f
Cred_5890 vdd.$3253.Metal4 vss.$1300.Metal5 0.0019821f
Cred_5891 vdd.$3255.Metal4 vout.$1164.Metal3 1.17334e-05f
Cred_5892 vdd.$3255.Metal4 vout.$1373.Metal4 1.03391e-05f
Cred_5893 vdd.$3255.Metal4 vout.$1394.Metal4 0.00970185f
Cred_5894 vdd.$3255.Metal4 vout.$1415.Metal4 0.000908508f
Cred_5895 vdd.$3255.Metal4 vout.$402.Metal1 1.42422e-08f
Cred_5896 vdd.$3255.Metal4 vout.$776.Metal2 2.35188e-07f
Cred_5897 vdd.$3255.Metal4 vout.$796.Metal2 1.19489e-06f
Cred_5898 vdd.$3255.Metal4 vout.P12.pSD 2.14236e-05f
Cred_5899 vdd.$3255.Metal4 vss 0.00073452f
Cred_5900 vdd.$3255.Metal4 vss.$1212.Metal5 0.000757516f
Cred_5901 vdd.$3255.Metal4 vss.$1230.Metal5 0.000757516f
Cred_5902 vdd.$3255.Metal4 vss.$1282.Metal5 0.00289961f
Cred_5903 vdd.$3255.Metal4 vss.$1300.Metal5 0.00289961f
Cred_5904 vdd.$3259.Metal4 vout.$1166.Metal3 6.74668e-06f
Cred_5905 vdd.$3259.Metal4 vout.$1373.Metal4 1.52366e-05f
Cred_5906 vdd.$3259.Metal4 vout.$1394.Metal4 0.00233052f
Cred_5907 vdd.$3259.Metal4 vout.$1415.Metal4 0.0116812f
Cred_5908 vdd.$3259.Metal4 vout.$403.Metal1 8.18929e-09f
Cred_5909 vdd.$3259.Metal4 vout.$778.Metal2 1.35233e-07f
Cred_5910 vdd.$3259.Metal4 vout.$798.Metal2 6.8706e-07f
Cred_5911 vdd.$3259.Metal4 vout.P14.pSD 8.4505e-06f
Cred_5912 vdd.$3259.Metal4 vss 0.000962813f
Cred_5913 vdd.$3259.Metal4 vss.$1212.Metal5 0.000992956f
Cred_5914 vdd.$3259.Metal4 vss.$1230.Metal5 0.000992956f
Cred_5915 vdd.$3259.Metal4 vss.$1282.Metal5 0.00380083f
Cred_5916 vdd.$3259.Metal4 vss.$1300.Metal5 0.00380083f
Cred_5917 vdd.$3263.Metal4 vout.$1208.Metal3 0.000179801f
Cred_5918 vdd.$3263.Metal4 vout.$1373.Metal4 2.22947e-05f
Cred_5919 vdd.$3263.Metal4 vout.$1415.Metal4 0.0144043f
Cred_5920 vdd.$3263.Metal4 vout.$404.Metal1 3.38395e-08f
Cred_5921 vdd.$3263.Metal4 vout.$800.Metal2 1.69903e-06f
Cred_5922 vdd.$3263.Metal4 vss 0.000966755f
Cred_5923 vdd.$3263.Metal4 vss.$1212.Metal5 0.000997022f
Cred_5924 vdd.$3263.Metal4 vss.$1230.Metal5 0.000997022f
Cred_5925 vdd.$3263.Metal4 vss.$1282.Metal5 0.0038164f
Cred_5926 vdd.$3263.Metal4 vss.$1300.Metal5 0.0038164f
Cred_5927 vdd.$3267.Metal4 vout.$1190.Metal3 8.75495e-05f
Cred_5928 vdd.$3267.Metal4 vout.$1208.Metal3 0.00016704f
Cred_5929 vdd.$3267.Metal4 vout.$1373.Metal4 2.14945e-05f
Cred_5930 vdd.$3267.Metal4 vout.$1415.Metal4 0.00820152f
Cred_5931 vdd.$3267.Metal4 vout.$1416.Metal4 0.006652f
Cred_5932 vdd.$3267.Metal4 vout.$404.Metal1 3.14378e-08f
Cred_5933 vdd.$3267.Metal4 vout.$405.Metal1 6.01424e-08f
Cred_5934 vdd.$3267.Metal4 vout.$800.Metal2 1.57845e-06f
Cred_5935 vdd.$3267.Metal4 vout.$802.Metal2 4.77454e-06f
Cred_5936 vdd.$3267.Metal4 vss 0.000965905f
Cred_5937 vdd.$3267.Metal4 vss.$1212.Metal5 0.000996145f
Cred_5938 vdd.$3267.Metal4 vss.$1230.Metal5 0.000996145f
Cred_5939 vdd.$3267.Metal4 vss.$1282.Metal5 0.00381304f
Cred_5940 vdd.$3267.Metal4 vss.$1300.Metal5 0.00381304f
Cred_5941 vdd.$3271.Metal4 vout.$1190.Metal3 7.71733e-05f
Cred_5942 vdd.$3271.Metal4 vout.$1416.Metal4 0.00586362f
Cred_5943 vdd.$3271.Metal4 vout.$405.Metal1 5.30145e-08f
Cred_5944 vdd.$3271.Metal4 vout.$802.Metal2 4.20868e-06f
Cred_5945 vdd.$3271.Metal4 vout.P18.pSD 0.00143753f
Cred_5946 vdd.$3271.Metal4 vss 0.00146031f
Cred_5947 vdd.$3271.Metal4 vss.$1212.Metal5 0.00150603f
Cred_5948 vdd.$3271.Metal4 vss.$1230.Metal5 0.00150603f
Cred_5949 vdd.$3271.Metal4 vss.$1282.Metal5 0.00576476f
Cred_5950 vdd.$3271.Metal4 vss.$1300.Metal5 0.00576476f
Cred_5951 vdd.$3275.Metal4 vss 0.00130829f
Cred_5952 vdd.$3275.Metal4 vss.$1212.Metal5 0.00134925f
Cred_5953 vdd.$3275.Metal4 vss.$1230.Metal5 0.00134925f
Cred_5954 vdd.$3275.Metal4 vss.$1282.Metal5 0.00516466f
Cred_5955 vdd.$3275.Metal4 vss.$1300.Metal5 0.00516466f
Cred_5956 vdd.$3277.Metal4 vss 0.00178669f
Cred_5957 vdd.$3277.Metal4 vss.$1212.Metal5 0.00184263f
Cred_5958 vdd.$3277.Metal4 vss.$1230.Metal5 0.00184263f
Cred_5959 vdd.$3277.Metal4 vss.$1282.Metal5 0.0070532f
Cred_5960 vdd.$3277.Metal4 vss.$1300.Metal5 0.0070532f
Cred_5961 vdd.$3448.Metal5 vss.$1282.Metal5 0.0355568f
Cred_5962 vdd.$3450.Metal5 vout.$1369.Metal4 3.7081e-07f
Cred_5963 vdd.$3450.Metal5 vout.$1408.Metal4 7.3433e-05f
Cred_5964 vdd.$3450.Metal5 vss.$1282.Metal5 0.0317114f
Cred_5965 vdd.$3452.Metal5 vout.$1369.Metal4 5.87033e-05f
Cred_5966 vdd.$3452.Metal5 vss.$1282.Metal5 0.031752f
Cred_5967 vdd.$3454.Metal5 vout.$1370.Metal4 5.18296e-05f
Cred_5968 vdd.$3454.Metal5 vss.$1282.Metal5 0.0317206f
Cred_5969 vdd.$3456.Metal5 vout.$1370.Metal4 1.07121e-05f
Cred_5970 vdd.$3456.Metal5 vout.$1371.Metal4 2.74788e-05f
Cred_5971 vdd.$3456.Metal5 vss.$1282.Metal5 0.039489f
Cred_5972 vdd.$3459.Metal5 vout.$1372.Metal4 8.72761e-07f
Cred_5973 vdd.$3459.Metal5 vout.$1383.Metal4 5.73966e-07f
Cred_5974 vdd.$3459.Metal5 vss 2.05587e-07f
Cred_5975 vdd.$3459.Metal5 vss.$1212.Metal5 2.12023e-07f
Cred_5976 vdd.$3459.Metal5 vss.$1230.Metal5 2.12023e-07f
Cred_5977 vdd.$3459.Metal5 vss.$1282.Metal5 0.0314653f
Cred_5978 vdd.$3459.Metal5 vss.$1300.Metal5 1.13693e-06f
Cred_5979 vdd.$3460.Metal5 vout.$1372.Metal4 5.52097e-05f
Cred_5980 vdd.$3460.Metal5 vout.$1383.Metal4 1.11923e-05f
Cred_5981 vdd.$3460.Metal5 vss 5.70364e-06f
Cred_5982 vdd.$3460.Metal5 vss.$1212.Metal5 5.88221e-06f
Cred_5983 vdd.$3460.Metal5 vss.$1230.Metal5 5.88221e-06f
Cred_5984 vdd.$3460.Metal5 vss.$1282.Metal5 0.0165539f
Cred_5985 vdd.$3460.Metal5 vss.$1300.Metal5 2.88602e-05f
Cred_5986 vdd.$3462.Metal5 vout.$1372.Metal4 0.00182241f
Cred_5987 vdd.$3462.Metal5 vout.$1383.Metal4 0.0018165f
Cred_5988 vdd.$3462.Metal5 vss 9.0281e-05f
Cred_5989 vdd.$3462.Metal5 vss.$1033.Metal4 8.21749e-06f
Cred_5990 vdd.$3462.Metal5 vss.$1037.Metal4 8.21749e-06f
Cred_5991 vdd.$3462.Metal5 vss.$1212.Metal5 9.31075e-05f
Cred_5992 vdd.$3462.Metal5 vss.$1230.Metal5 9.31075e-05f
Cred_5993 vdd.$3462.Metal5 vss.$1247.Metal5 0.00215698f
Cred_5994 vdd.$3462.Metal5 vss.$1282.Metal5 0.00386314f
Cred_5995 vdd.$3462.Metal5 vss.$1300.Metal5 0.00287063f
Cred_5996 vdd.$3462.Metal5 vss.$825.Metal3 9.68912e-08f
Cred_5997 vdd.$3464.Metal5 vout.$1383.Metal4 3.81909e-05f
Cred_5998 vdd.$3464.Metal5 vss 0.0012771f
Cred_5999 vdd.$3464.Metal5 vss.$1212.Metal5 0.00131708f
Cred_6000 vdd.$3464.Metal5 vss.$1230.Metal5 0.00131708f
Cred_6001 vdd.$3464.Metal5 vss.$1282.Metal5 0.00504151f
Cred_6002 vdd.$3464.Metal5 vss.$1300.Metal5 0.00754238f
Cred_6003 vdd.$3465.Metal5 vss 0.00287114f
Cred_6004 vdd.$3465.Metal5 vss.$1212.Metal5 0.00296103f
Cred_6005 vdd.$3465.Metal5 vss.$1230.Metal5 0.00296103f
Cred_6006 vdd.$3465.Metal5 vss.$1282.Metal5 0.0113342f
Cred_6007 vdd.$3465.Metal5 vss.$1300.Metal5 0.0113342f
Cred_6008 vdd.$3468.Metal5 vout.$1394.Metal4 2.74788e-05f
Cred_6009 vdd.$3468.Metal5 vout.$1415.Metal4 1.07121e-05f
Cred_6010 vdd.$3468.Metal5 vss 0.00360371f
Cred_6011 vdd.$3468.Metal5 vss.$1212.Metal5 0.00371653f
Cred_6012 vdd.$3468.Metal5 vss.$1230.Metal5 0.00371653f
Cred_6013 vdd.$3468.Metal5 vss.$1282.Metal5 0.0142261f
Cred_6014 vdd.$3468.Metal5 vss.$1300.Metal5 0.0142261f
Cred_6015 vdd.$3470.Metal5 vout.$1415.Metal4 4.97269e-05f
Cred_6016 vdd.$3470.Metal5 vss 0.00289478f
Cred_6017 vdd.$3470.Metal5 vss.$1212.Metal5 0.00298541f
Cred_6018 vdd.$3470.Metal5 vss.$1230.Metal5 0.00298541f
Cred_6019 vdd.$3470.Metal5 vss.$1282.Metal5 0.0114275f
Cred_6020 vdd.$3470.Metal5 vss.$1300.Metal5 0.0114275f
Cred_6021 vdd.$3472.Metal5 vout.$1208.Metal3 9.51009e-07f
Cred_6022 vdd.$3472.Metal5 vout.$1415.Metal4 4.66938e-05f
Cred_6023 vdd.$3472.Metal5 vout.$404.Metal1 1.78985e-10f
Cred_6024 vdd.$3472.Metal5 vout.$800.Metal2 8.98659e-09f
Cred_6025 vdd.$3472.Metal5 vss 0.00289764f
Cred_6026 vdd.$3472.Metal5 vss.$1212.Metal5 0.00298836f
Cred_6027 vdd.$3472.Metal5 vss.$1230.Metal5 0.00298836f
Cred_6028 vdd.$3472.Metal5 vss.$1282.Metal5 0.0114388f
Cred_6029 vdd.$3472.Metal5 vss.$1300.Metal5 0.0114388f
Cred_6030 vdd.$3474.Metal5 vout.$1190.Metal3 7.26425e-07f
Cred_6031 vdd.$3474.Metal5 vout.$1208.Metal3 7.4001e-09f
Cred_6032 vdd.$3474.Metal5 vout.$1415.Metal4 3.63339e-07f
Cred_6033 vdd.$3474.Metal5 vout.$1416.Metal4 5.51937e-05f
Cred_6034 vdd.$3474.Metal5 vout.$404.Metal1 1.39274e-12f
Cred_6035 vdd.$3474.Metal5 vout.$405.Metal1 4.99021e-10f
Cred_6036 vdd.$3474.Metal5 vout.$800.Metal2 6.99274e-11f
Cred_6037 vdd.$3474.Metal5 vout.$802.Metal2 3.96159e-08f
Cred_6038 vdd.$3474.Metal5 vss 0.00289393f
Cred_6039 vdd.$3474.Metal5 vss.$1212.Metal5 0.00298454f
Cred_6040 vdd.$3474.Metal5 vss.$1230.Metal5 0.00298454f
Cred_6041 vdd.$3474.Metal5 vss.$1282.Metal5 0.0114242f
Cred_6042 vdd.$3474.Metal5 vss.$1300.Metal5 0.0114242f
Cred_6043 vdd.$3476.Metal5 vss 0.00324486f
Cred_6044 vdd.$3476.Metal5 vss.$1212.Metal5 0.00334645f
Cred_6045 vdd.$3476.Metal5 vss.$1230.Metal5 0.00334645f
Cred_6046 vdd.$3476.Metal5 vss.$1282.Metal5 0.0128095f
Cred_6047 vdd.$3476.Metal5 vss.$1300.Metal5 0.0128095f
Cred_6048 vdd.$3480.Metal5 vss.$1282.Metal5 0.0390854f
Cred_6049 vdd.$3496.Metal5 vss 0.00356688f
Cred_6050 vdd.$3496.Metal5 vss.$1212.Metal5 0.00367855f
Cred_6051 vdd.$3496.Metal5 vss.$1230.Metal5 0.00367855f
Cred_6052 vdd.$3496.Metal5 vss.$1282.Metal5 0.0140807f
Cred_6053 vdd.$3496.Metal5 vss.$1300.Metal5 0.0140807f
Cred_6054 vdd.$3615.TopMetal1 vout.$1369.Metal4 0.000732361f
Cred_6055 vdd.$3615.TopMetal1 vss.$1282.Metal5 0.0376313f
Cred_6056 vdd.$3617.TopMetal1 vout.$1369.Metal4 0.000732361f
Cred_6057 vdd.$3617.TopMetal1 vout.$1370.Metal4 0.0011416f
Cred_6058 vdd.$3617.TopMetal1 vss.$1282.Metal5 0.0440902f
Cred_6059 vdd.$3619.TopMetal1 vout.$1371.Metal4 0.00103288f
Cred_6060 vdd.$3619.TopMetal1 vout.$1372.Metal4 0.00427256f
Cred_6061 vdd.$3619.TopMetal1 vout.$1383.Metal4 0.00280982f
Cred_6062 vdd.$3619.TopMetal1 vss 0.00130943f
Cred_6063 vdd.$3619.TopMetal1 vss.$1212.Metal5 0.00135042f
Cred_6064 vdd.$3619.TopMetal1 vss.$1230.Metal5 0.00135042f
Cred_6065 vdd.$3619.TopMetal1 vss.$1282.Metal5 0.0515713f
Cred_6066 vdd.$3619.TopMetal1 vss.$1300.Metal5 0.00676187f
Cred_6067 vdd.$3622.TopMetal1 vout.$1372.Metal4 0.00704087f
Cred_6068 vdd.$3622.TopMetal1 vout.$1383.Metal4 0.00715355f
Cred_6069 vdd.$3622.TopMetal1 vss 0.00273786f
Cred_6070 vdd.$3622.TopMetal1 vss.$1212.Metal5 0.00282358f
Cred_6071 vdd.$3622.TopMetal1 vss.$1230.Metal5 0.00282358f
Cred_6072 vdd.$3622.TopMetal1 vss.$1282.Metal5 0.0202723f
Cred_6073 vdd.$3622.TopMetal1 vss.$1300.Metal5 0.0321729f
Cred_6074 vdd.$3623.TopMetal1 vout.$1394.Metal4 0.00103288f
Cred_6075 vdd.$3623.TopMetal1 vss 0.00324506f
Cred_6076 vdd.$3623.TopMetal1 vss.$1212.Metal5 0.00334666f
Cred_6077 vdd.$3623.TopMetal1 vss.$1230.Metal5 0.00334666f
Cred_6078 vdd.$3623.TopMetal1 vss.$1282.Metal5 0.0128103f
Cred_6079 vdd.$3623.TopMetal1 vss.$1300.Metal5 0.0128103f
Cred_6080 vdd.$3625.TopMetal1 vout.$1208.Metal3 1.46154e-05f
Cred_6081 vdd.$3625.TopMetal1 vout.$1415.Metal4 0.0018592f
Cred_6082 vdd.$3625.TopMetal1 vout.$404.Metal1 2.7507e-09f
Cred_6083 vdd.$3625.TopMetal1 vout.$800.Metal2 1.38109e-07f
Cred_6084 vdd.$3625.TopMetal1 vss 0.0040236f
Cred_6085 vdd.$3625.TopMetal1 vss.$1212.Metal5 0.00414957f
Cred_6086 vdd.$3625.TopMetal1 vss.$1230.Metal5 0.00414957f
Cred_6087 vdd.$3625.TopMetal1 vss.$1282.Metal5 0.0158837f
Cred_6088 vdd.$3625.TopMetal1 vss.$1300.Metal5 0.0158837f
Cred_6089 vdd.$3627.TopMetal1 vout.$1208.Metal3 1.46154e-05f
Cred_6090 vdd.$3627.TopMetal1 vout.$1415.Metal4 0.000717604f
Cred_6091 vdd.$3627.TopMetal1 vout.$404.Metal1 2.7507e-09f
Cred_6092 vdd.$3627.TopMetal1 vout.$800.Metal2 1.38109e-07f
Cred_6093 vdd.$3627.TopMetal1 vss 0.00343417f
Cred_6094 vdd.$3627.TopMetal1 vss.$1212.Metal5 0.00354169f
Cred_6095 vdd.$3627.TopMetal1 vss.$1230.Metal5 0.00354169f
Cred_6096 vdd.$3627.TopMetal1 vss.$1282.Metal5 0.0135569f
Cred_6097 vdd.$3627.TopMetal1 vss.$1300.Metal5 0.0135569f
Cred_6098 vdd.$3700.TopMetal1 vss 1.1707f
Cred_6099 vdd.$3700.TopMetal1 vss.$1212.Metal5 1.20735f
Cred_6100 vdd.$3700.TopMetal1 vss.$1230.Metal5 1.20735f
Cred_6101 vdd.$3700.TopMetal1 vss.$1282.Metal5 124.28f
Cred_6102 vdd.$3700.TopMetal1 vss.$1300.Metal5 4.62147f
Cred_6103 vdd.$3707.TopMetal1 vss 12.0904f
Cred_6104 vdd.$3707.TopMetal1 vss.$1212.Metal5 12.4679f
Cred_6105 vdd.$3707.TopMetal1 vss.$1230.Metal5 12.4679f
Cred_6106 vdd.$3707.TopMetal1 vss.$1282.Metal5 47.7314f
Cred_6107 vdd.$3707.TopMetal1 vss.$1300.Metal5 47.7247f
Cred_6108 vdd.$4071.TopMetal1 vss 300.838f
Cred_6109 vdd.$4071.TopMetal1 vss.$1212.Metal5 32.4141f
Cred_6110 vdd.$4071.TopMetal1 vss.$1230.Metal5 32.4141f
Cred_6111 vdd.$4071.TopMetal1 vss.$1282.Metal5 505.206f
Cred_6112 vdd.$4071.TopMetal1 vss.$1300.Metal5 124.075f
Cred_6113 vdd.$4456.TopMetal1 vss 631.71f
Cred_6114 vdd.$4456.TopMetal1 vss.$1212.Metal5 8.48399f
Cred_6115 vdd.$4456.TopMetal1 vss.$1230.Metal5 8.48399f
Cred_6116 vdd.$4456.TopMetal1 vss.$1282.Metal5 237.752f
Cred_6117 vdd.$4456.TopMetal1 vss.$1300.Metal5 32.475f
Cred_6118 vdd.$4841.TopMetal1 vss 867.796f
Cred_6119 vdd.$4841.TopMetal1 vss.$1212.Metal5 0.065407f
Cred_6120 vdd.$4841.TopMetal1 vss.$1230.Metal5 0.065407f
Cred_6121 vdd.$4841.TopMetal1 vss.$1282.Metal5 50.7316f
Cred_6122 vdd.$4841.TopMetal1 vss.$1300.Metal5 0.250364f
Cred_6123 vdd.$5226.TopMetal1 vss 917.626f
Cred_6124 vdd.$5226.TopMetal1 vss.$1212.Metal5 3.50769e-06f
Cred_6125 vdd.$5226.TopMetal1 vss.$1230.Metal5 3.50769e-06f
Cred_6126 vdd.$5226.TopMetal1 vss.$1282.Metal5 0.0945437f
Cred_6127 vdd.$5226.TopMetal1 vss.$1300.Metal5 1.34267e-05f
Cred_6128 vdd.P0.GatPoly vss 3.60185e-11f
Cred_6129 vdd.P0.GatPoly vss.$1282.Metal5 0.280059f
Cred_6130 vdd.P0.nSD vout 0.0398266f
Cred_6131 vdd.P0.nSD vout.$1002.Metal3 1.84676e-07f
Cred_6132 vdd.P0.nSD vout.$1004.Metal3 1.84387e-07f
Cred_6133 vdd.P0.nSD vout.$1006.Metal3 1.83862e-07f
Cred_6134 vdd.P0.nSD vout.$1008.Metal3 1.83066e-07f
Cred_6135 vdd.P0.nSD vout.$1010.Metal3 1.81946e-07f
Cred_6136 vdd.P0.nSD vout.$1032.Metal3 2.23058e-07f
Cred_6137 vdd.P0.nSD vout.$1034.Metal3 1.87121e-07f
Cred_6138 vdd.P0.nSD vout.$1036.Metal3 1.91369e-07f
Cred_6139 vdd.P0.nSD vout.$1038.Metal3 1.88471e-07f
Cred_6140 vdd.P0.nSD vout.$1040.Metal3 2.26405e-07f
Cred_6141 vdd.P0.nSD vout.$1162.Metal3 3.10383e-10f
Cred_6142 vdd.P0.nSD vout.$1180.Metal3 3.45358e-10f
Cred_6143 vdd.P0.nSD vout.$1299.Metal4 3.92022e-05f
Cred_6144 vdd.P0.nSD vout.$1313.Metal4 0.0563038f
Cred_6145 vdd.P0.nSD vout.$1328.Metal4 2.65663e-08f
Cred_6146 vdd.P0.nSD vout.$1329.Metal4 2.22861e-08f
Cred_6147 vdd.P0.nSD vout.$1330.Metal4 2.27921e-08f
Cred_6148 vdd.P0.nSD vout.$1331.Metal4 2.24469e-08f
Cred_6149 vdd.P0.nSD vout.$1332.Metal4 2.69649e-08f
Cred_6150 vdd.P0.nSD vout.$1370.Metal4 3.76477e-06f
Cred_6151 vdd.P0.nSD vout.$1372.Metal4 3.32659e-06f
Cred_6152 vdd.P0.nSD vout.$1373.Metal4 1.93926e-05f
Cred_6153 vdd.P0.nSD vout.$1383.Metal4 3.32661e-06f
Cred_6154 vdd.P0.nSD vout.$156.Metal1 0.00224568f
Cred_6155 vdd.P0.nSD vout.$157.Metal1 0.00188387f
Cred_6156 vdd.P0.nSD vout.$158.Metal1 0.00192664f
Cred_6157 vdd.P0.nSD vout.$159.Metal1 0.00189746f
Cred_6158 vdd.P0.nSD vout.$160.Metal1 0.00227937f
Cred_6159 vdd.P0.nSD vout.$161.Metal1 0.00155622f
Cred_6160 vdd.P0.nSD vout.$162.Metal1 0.00155379f
Cred_6161 vdd.P0.nSD vout.$163.Metal1 0.00154937f
Cred_6162 vdd.P0.nSD vout.$164.Metal1 0.00154266f
Cred_6163 vdd.P0.nSD vout.$165.Metal1 0.00153322f
Cred_6164 vdd.P0.nSD vout.$400.Metal1 3.13806e-06f
Cred_6165 vdd.P0.nSD vout.$401.Metal1 3.13806e-06f
Cred_6166 vdd.P0.nSD vout.$584.Metal2 1.38456e-05f
Cred_6167 vdd.P0.nSD vout.$586.Metal2 1.16149e-05f
Cred_6168 vdd.P0.nSD vout.$588.Metal2 1.18786e-05f
Cred_6169 vdd.P0.nSD vout.$590.Metal2 1.16987e-05f
Cred_6170 vdd.P0.nSD vout.$592.Metal2 1.40534e-05f
Cred_6171 vdd.P0.nSD vout.$594.Metal2 9.58266e-06f
Cred_6172 vdd.P0.nSD vout.$596.Metal2 9.5677e-06f
Cred_6173 vdd.P0.nSD vout.$598.Metal2 9.54046e-06f
Cred_6174 vdd.P0.nSD vout.$600.Metal2 9.49915e-06f
Cred_6175 vdd.P0.nSD vout.$602.Metal2 9.441e-06f
Cred_6176 vdd.P0.nSD vout.$604.Metal2 4.47107e-09f
Cred_6177 vdd.P0.nSD vout.$606.Metal2 3.75073e-09f
Cred_6178 vdd.P0.nSD vout.$608.Metal2 3.83589e-09f
Cred_6179 vdd.P0.nSD vout.$610.Metal2 3.7778e-09f
Cred_6180 vdd.P0.nSD vout.$612.Metal2 4.53816e-09f
Cred_6181 vdd.P0.nSD vout.$774.Metal2 6.22146e-12f
Cred_6182 vdd.P0.nSD vout.$792.Metal2 1.93364e-08f
Cred_6183 vdd.P0.nSD vout.$794.Metal2 1.93475e-08f
Cred_6184 vdd.P0.nSD vout.P0.GatPoly 0.00251854f
Cred_6185 vdd.P0.nSD vref 0.0425413f
Cred_6186 vdd.P0.nSD vref.P0.GatPoly 0.000764702f
Cred_6187 vdd.P0.nSD vref.P0.nSD 0.00197974f
Cred_6188 vdd.P0.nSD vref.P0.pSD 0.00544974f
Cred_6189 vdd.P0.nSD vss 0.0252424f
Cred_6190 vdd.P0.nSD vss.$1212.Metal5 0.0260327f
Cred_6191 vdd.P0.nSD vss.$1230.Metal5 0.0260327f
Cred_6192 vdd.P0.nSD vss.$1282.Metal5 0.424351f
Cred_6193 vdd.P0.nSD vss.$1300.Metal5 0.107301f
Cred_6194 vdd.P0.pSD vout.$1032.Metal3 0.00255715f
Cred_6195 vdd.P0.pSD vout.$1072.Metal3 0.00118629f
Cred_6196 vdd.P0.pSD vout.$1112.Metal3 0.00131187f
Cred_6197 vdd.P0.pSD vout.$1152.Metal3 0.00202129f
Cred_6198 vdd.P0.pSD vout.$1328.Metal4 0.000145039f
Cred_6199 vdd.P0.pSD vout.$1368.Metal4 0.00089037f
Cred_6200 vdd.P0.pSD vout.$1408.Metal4 0.00130987f
Cred_6201 vdd.P0.pSD vout.$156.Metal1 4.67577e-05f
Cred_6202 vdd.P0.pSD vout.$206.Metal1 2.35964e-05f
Cred_6203 vdd.P0.pSD vout.$226.Metal1 2.50265e-06f
Cred_6204 vdd.P0.pSD vout.$326.Metal1 1.80567e-06f
Cred_6205 vdd.P0.pSD vout.$346.Metal1 1.46711e-05f
Cred_6206 vdd.P0.pSD vout.$396.Metal1 1.83419e-05f
Cred_6207 vdd.P0.pSD vout.$584.Metal2 0.0051666f
Cred_6208 vdd.P0.pSD vout.$604.Metal2 0.00406116f
Cred_6209 vdd.P0.pSD vout.$644.Metal2 0.00388563f
Cred_6210 vdd.P0.pSD vout.$664.Metal2 0.00246544f
Cred_6211 vdd.P0.pSD vout.$684.Metal2 0.00204219f
Cred_6212 vdd.P0.pSD vout.$704.Metal2 0.00196421f
Cred_6213 vdd.P0.pSD vout.$724.Metal2 0.00266303f
Cred_6214 vdd.P0.pSD vout.$764.Metal2 0.00235065f
Cred_6215 vdd.P0.pSD vout.$784.Metal2 0.00225963f
Cred_6216 vdd.P0.pSD vss.$1282.Metal5 0.0487728f
Cred_6217 vdd.P1.GatPoly vout 7.35063e-06f
Cred_6218 vdd.P1.GatPoly vout.$1002.Metal3 5.37549e-11f
Cred_6219 vdd.P1.GatPoly vout.$1004.Metal3 4.15851e-11f
Cred_6220 vdd.P1.GatPoly vout.$1006.Metal3 3.21734e-11f
Cred_6221 vdd.P1.GatPoly vout.$1008.Metal3 2.48955e-11f
Cred_6222 vdd.P1.GatPoly vout.$1010.Metal3 1.92687e-11f
Cred_6223 vdd.P1.GatPoly vout.$1032.Metal3 2.90097e-10f
Cred_6224 vdd.P1.GatPoly vout.$1034.Metal3 1.87345e-10f
Cred_6225 vdd.P1.GatPoly vout.$1036.Metal3 1.479e-10f
Cred_6226 vdd.P1.GatPoly vout.$1038.Metal3 1.1278e-10f
Cred_6227 vdd.P1.GatPoly vout.$1040.Metal3 1.05299e-10f
Cred_6228 vdd.P1.GatPoly vout.$1299.Metal4 8.58868e-09f
Cred_6229 vdd.P1.GatPoly vout.$1313.Metal4 5.74427e-06f
Cred_6230 vdd.P1.GatPoly vout.$1328.Metal4 3.45506e-11f
Cred_6231 vdd.P1.GatPoly vout.$1329.Metal4 2.23128e-11f
Cred_6232 vdd.P1.GatPoly vout.$1330.Metal4 1.76149e-11f
Cred_6233 vdd.P1.GatPoly vout.$1331.Metal4 1.34321e-11f
Cred_6234 vdd.P1.GatPoly vout.$1332.Metal4 1.25411e-11f
Cred_6235 vdd.P1.GatPoly vout.$156.Metal1 2.92061e-06f
Cred_6236 vdd.P1.GatPoly vout.$157.Metal1 1.88613e-06f
Cred_6237 vdd.P1.GatPoly vout.$158.Metal1 1.48901e-06f
Cred_6238 vdd.P1.GatPoly vout.$159.Metal1 1.13543e-06f
Cred_6239 vdd.P1.GatPoly vout.$160.Metal1 1.06012e-06f
Cred_6240 vdd.P1.GatPoly vout.$161.Metal1 4.52981e-07f
Cred_6241 vdd.P1.GatPoly vout.$162.Metal1 3.50429e-07f
Cred_6242 vdd.P1.GatPoly vout.$163.Metal1 2.71118e-07f
Cred_6243 vdd.P1.GatPoly vout.$164.Metal1 2.09789e-07f
Cred_6244 vdd.P1.GatPoly vout.$165.Metal1 1.62373e-07f
Cred_6245 vdd.P1.GatPoly vout.$584.Metal2 1.80069e-08f
Cred_6246 vdd.P1.GatPoly vout.$586.Metal2 1.16288e-08f
Cred_6247 vdd.P1.GatPoly vout.$588.Metal2 9.18044e-09f
Cred_6248 vdd.P1.GatPoly vout.$590.Metal2 7.00044e-09f
Cred_6249 vdd.P1.GatPoly vout.$592.Metal2 6.53611e-09f
Cred_6250 vdd.P1.GatPoly vout.$594.Metal2 2.7893e-09f
Cred_6251 vdd.P1.GatPoly vout.$596.Metal2 2.15782e-09f
Cred_6252 vdd.P1.GatPoly vout.$598.Metal2 1.66945e-09f
Cred_6253 vdd.P1.GatPoly vout.$600.Metal2 1.2918e-09f
Cred_6254 vdd.P1.GatPoly vout.$602.Metal2 9.99836e-10f
Cred_6255 vdd.P1.GatPoly vout.$604.Metal2 5.81484e-12f
Cred_6256 vdd.P1.GatPoly vout.$606.Metal2 3.75522e-12f
Cred_6257 vdd.P1.GatPoly vout.$608.Metal2 2.96457e-12f
Cred_6258 vdd.P1.GatPoly vout.$610.Metal2 2.2606e-12f
Cred_6259 vdd.P1.GatPoly vout.$612.Metal2 2.11066e-12f
Cred_6260 vdd.P1.GatPoly vout.P0.GatPoly 5.52637e-07f
Cred_6261 vdd.P1.GatPoly vref 4.07704e-05f
Cred_6262 vdd.P1.GatPoly vref.P0.GatPoly 1.54158e-06f
Cred_6263 vdd.P1.GatPoly vref.P0.nSD 8.31204e-06f
Cred_6264 vdd.P1.GatPoly vref.P0.pSD 2.41982e-05f
Cred_6265 vdd.P1.GatPoly vss 9.34153e-07f
Cred_6266 vdd.P1.GatPoly vss.$1212.Metal5 9.63399e-07f
Cred_6267 vdd.P1.GatPoly vss.$1230.Metal5 9.63399e-07f
Cred_6268 vdd.P1.GatPoly vss.$1282.Metal5 0.023592f
Cred_6269 vdd.P1.GatPoly vss.$1300.Metal5 6.10441e-06f
Cred_6270 vdd.P1.pSD vout.$1032.Metal3 0.00859123f
Cred_6271 vdd.P1.pSD vout.$1072.Metal3 0.00417905f
Cred_6272 vdd.P1.pSD vout.$1112.Metal3 0.00323301f
Cred_6273 vdd.P1.pSD vout.$1152.Metal3 0.00522175f
Cred_6274 vdd.P1.pSD vout.$1328.Metal4 0.00423656f
Cred_6275 vdd.P1.pSD vout.$1368.Metal4 0.00256659f
Cred_6276 vdd.P1.pSD vout.$1408.Metal4 0.00188566f
Cred_6277 vdd.P1.pSD vout.$156.Metal1 0.0322414f
Cred_6278 vdd.P1.pSD vout.$206.Metal1 0.0295952f
Cred_6279 vdd.P1.pSD vout.$226.Metal1 0.0220183f
Cred_6280 vdd.P1.pSD vout.$266.Metal1 0.0217383f
Cred_6281 vdd.P1.pSD vout.$286.Metal1 0.0214135f
Cred_6282 vdd.P1.pSD vout.$326.Metal1 0.0211621f
Cred_6283 vdd.P1.pSD vout.$346.Metal1 0.0274314f
Cred_6284 vdd.P1.pSD vout.$396.Metal1 0.0296431f
Cred_6285 vdd.P1.pSD vout.$584.Metal2 0.0269335f
Cred_6286 vdd.P1.pSD vout.$604.Metal2 0.0210998f
Cred_6287 vdd.P1.pSD vout.$644.Metal2 0.0200051f
Cred_6288 vdd.P1.pSD vout.$664.Metal2 0.0123712f
Cred_6289 vdd.P1.pSD vout.$684.Metal2 0.0123554f
Cred_6290 vdd.P1.pSD vout.$704.Metal2 0.012706f
Cred_6291 vdd.P1.pSD vout.$724.Metal2 0.0174635f
Cred_6292 vdd.P1.pSD vout.$764.Metal2 0.0152834f
Cred_6293 vdd.P1.pSD vout.$784.Metal2 0.0143663f
Cred_6294 vdd.P1.pSD vout.P0.pSD 0.000777848f
Cred_6295 vdd.P1.pSD vss.$1282.Metal5 0.0175825f
Cred_6296 vdd.P10.pSD vout.$1038.Metal3 0.00564938f
Cred_6297 vdd.P10.pSD vout.$1040.Metal3 0.00571056f
Cred_6298 vdd.P10.pSD vout.$1078.Metal3 0.0023114f
Cred_6299 vdd.P10.pSD vout.$1080.Metal3 0.00345661f
Cred_6300 vdd.P10.pSD vout.$1118.Metal3 0.00276594f
Cred_6301 vdd.P10.pSD vout.$1140.Metal3 0.00332934f
Cred_6302 vdd.P10.pSD vout.$1158.Metal3 0.00439679f
Cred_6303 vdd.P10.pSD vout.$1180.Metal3 0.00330781f
Cred_6304 vdd.P10.pSD vout.$1331.Metal4 0.00179423f
Cred_6305 vdd.P10.pSD vout.$1332.Metal4 0.00182513f
Cred_6306 vdd.P10.pSD vout.$1371.Metal4 0.0139837f
Cred_6307 vdd.P10.pSD vout.$1372.Metal4 0.00871065f
Cred_6308 vdd.P10.pSD vout.$159.Metal1 0.0310567f
Cred_6309 vdd.P10.pSD vout.$160.Metal1 0.0305663f
Cred_6310 vdd.P10.pSD vout.$209.Metal1 0.0283754f
Cred_6311 vdd.P10.pSD vout.$210.Metal1 0.0281025f
Cred_6312 vdd.P10.pSD vout.$229.Metal1 0.0211331f
Cred_6313 vdd.P10.pSD vout.$230.Metal1 0.0210928f
Cred_6314 vdd.P10.pSD vout.$269.Metal1 0.0209236f
Cred_6315 vdd.P10.pSD vout.$270.Metal1 0.0208406f
Cred_6316 vdd.P10.pSD vout.$289.Metal1 0.0210138f
Cred_6317 vdd.P10.pSD vout.$290.Metal1 0.0205293f
Cred_6318 vdd.P10.pSD vout.$329.Metal1 0.0208069f
Cred_6319 vdd.P10.pSD vout.$330.Metal1 0.0202774f
Cred_6320 vdd.P10.pSD vout.$349.Metal1 0.0267786f
Cred_6321 vdd.P10.pSD vout.$350.Metal1 0.0263924f
Cred_6322 vdd.P10.pSD vout.$399.Metal1 0.0282717f
Cred_6323 vdd.P10.pSD vout.$400.Metal1 0.0291736f
Cred_6324 vdd.P10.pSD vout.$590.Metal2 0.0266562f
Cred_6325 vdd.P10.pSD vout.$592.Metal2 0.0261469f
Cred_6326 vdd.P10.pSD vout.$610.Metal2 0.0204828f
Cred_6327 vdd.P10.pSD vout.$612.Metal2 0.0204659f
Cred_6328 vdd.P10.pSD vout.$650.Metal2 0.019438f
Cred_6329 vdd.P10.pSD vout.$652.Metal2 0.0198805f
Cred_6330 vdd.P10.pSD vout.$670.Metal2 0.0125697f
Cred_6331 vdd.P10.pSD vout.$672.Metal2 0.0126948f
Cred_6332 vdd.P10.pSD vout.$690.Metal2 0.0125836f
Cred_6333 vdd.P10.pSD vout.$692.Metal2 0.0124248f
Cred_6334 vdd.P10.pSD vout.$710.Metal2 0.0127517f
Cred_6335 vdd.P10.pSD vout.$712.Metal2 0.0124448f
Cred_6336 vdd.P10.pSD vout.$730.Metal2 0.0171659f
Cred_6337 vdd.P10.pSD vout.$732.Metal2 0.0115377f
Cred_6338 vdd.P10.pSD vout.$752.Metal2 0.0105531f
Cred_6339 vdd.P10.pSD vout.$770.Metal2 0.0153138f
Cred_6340 vdd.P10.pSD vout.$772.Metal2 0.00970832f
Cred_6341 vdd.P10.pSD vout.$790.Metal2 0.0144964f
Cred_6342 vdd.P10.pSD vout.$792.Metal2 0.0139807f
Cred_6343 vdd.P10.pSD vout.P6.pSD 0.000748542f
Cred_6344 vdd.P10.pSD vout.P8.pSD 0.00074375f
Cred_6345 vdd.P10.pSD vss.$1282.Metal5 0.0101403f
Cred_6346 vdd.P11.pSD vout.$1040.Metal3 0.00541385f
Cred_6347 vdd.P11.pSD vout.$1080.Metal3 0.0029911f
Cred_6348 vdd.P11.pSD vout.$1122.Metal3 0.000531491f
Cred_6349 vdd.P11.pSD vout.$1140.Metal3 0.00326123f
Cred_6350 vdd.P11.pSD vout.$1162.Metal3 0.000950938f
Cred_6351 vdd.P11.pSD vout.$1180.Metal3 0.00325266f
Cred_6352 vdd.P11.pSD vout.$1332.Metal4 0.00179305f
Cred_6353 vdd.P11.pSD vout.$1372.Metal4 0.0293052f
Cred_6354 vdd.P11.pSD vout.$1383.Metal4 3.88777e-05f
Cred_6355 vdd.P11.pSD vout.$160.Metal1 0.0302868f
Cred_6356 vdd.P11.pSD vout.$210.Metal1 0.0273364f
Cred_6357 vdd.P11.pSD vout.$230.Metal1 0.0201865f
Cred_6358 vdd.P11.pSD vout.$270.Metal1 0.019997f
Cred_6359 vdd.P11.pSD vout.$290.Metal1 0.020154f
Cred_6360 vdd.P11.pSD vout.$330.Metal1 0.0199473f
Cred_6361 vdd.P11.pSD vout.$331.Metal1 1.08229e-06f
Cred_6362 vdd.P11.pSD vout.$350.Metal1 0.0257714f
Cred_6363 vdd.P11.pSD vout.$351.Metal1 8.79363e-06f
Cred_6364 vdd.P11.pSD vout.$400.Metal1 0.0278595f
Cred_6365 vdd.P11.pSD vout.$401.Metal1 1.08108e-05f
Cred_6366 vdd.P11.pSD vout.$592.Metal2 0.0259712f
Cred_6367 vdd.P11.pSD vout.$612.Metal2 0.0208102f
Cred_6368 vdd.P11.pSD vout.$652.Metal2 0.0193241f
Cred_6369 vdd.P11.pSD vout.$672.Metal2 0.0124152f
Cred_6370 vdd.P11.pSD vout.$692.Metal2 0.0128359f
Cred_6371 vdd.P11.pSD vout.$694.Metal2 0.00122859f
Cred_6372 vdd.P11.pSD vout.$712.Metal2 0.0124942f
Cred_6373 vdd.P11.pSD vout.$714.Metal2 0.00117654f
Cred_6374 vdd.P11.pSD vout.$732.Metal2 0.0115832f
Cred_6375 vdd.P11.pSD vout.$734.Metal2 0.00159531f
Cred_6376 vdd.P11.pSD vout.$752.Metal2 0.0105971f
Cred_6377 vdd.P11.pSD vout.$772.Metal2 0.009737f
Cred_6378 vdd.P11.pSD vout.$774.Metal2 0.00140539f
Cred_6379 vdd.P11.pSD vout.$792.Metal2 0.0143258f
Cred_6380 vdd.P11.pSD vout.$794.Metal2 0.00133861f
Cred_6381 vdd.P11.pSD vout.P8.pSD 0.000729942f
Cred_6382 vdd.P11.pSD vref 0.0472656f
Cred_6383 vdd.P11.pSD vref.P0.GatPoly 0.00184309f
Cred_6384 vdd.P11.pSD vref.P0.nSD 0.0105658f
Cred_6385 vdd.P11.pSD vref.P0.pSD 0.240441f
Cred_6386 vdd.P11.pSD vss.$1282.Metal5 0.00939495f
Cred_6387 vdd.P13.pSD vout.$1002.Metal3 0.00351207f
Cred_6388 vdd.P13.pSD vout.$1042.Metal3 0.00308522f
Cred_6389 vdd.P13.pSD vout.$1080.Metal3 0.000115323f
Cred_6390 vdd.P13.pSD vout.$1082.Metal3 0.00229078f
Cred_6391 vdd.P13.pSD vout.$1122.Metal3 0.00261949f
Cred_6392 vdd.P13.pSD vout.$1140.Metal3 0.000728664f
Cred_6393 vdd.P13.pSD vout.$1162.Metal3 0.00444372f
Cred_6394 vdd.P13.pSD vout.$1180.Metal3 0.000667108f
Cred_6395 vdd.P13.pSD vout.$1313.Metal4 2.83314e-05f
Cred_6396 vdd.P13.pSD vout.$1323.Metal4 0.000452396f
Cred_6397 vdd.P13.pSD vout.$1333.Metal4 0.000462427f
Cred_6398 vdd.P13.pSD vout.$1343.Metal4 0.000435295f
Cred_6399 vdd.P13.pSD vout.$1353.Metal4 0.00043281f
Cred_6400 vdd.P13.pSD vout.$1363.Metal4 0.000403384f
Cred_6401 vdd.P13.pSD vout.$1372.Metal4 0.00453815f
Cred_6402 vdd.P13.pSD vout.$1373.Metal4 0.00968345f
Cred_6403 vdd.P13.pSD vout.$1383.Metal4 0.00892878f
Cred_6404 vdd.P13.pSD vout.$161.Metal1 0.0243973f
Cred_6405 vdd.P13.pSD vout.$201.Metal1 0.0289962f
Cred_6406 vdd.P13.pSD vout.$231.Metal1 0.0279023f
Cred_6407 vdd.P13.pSD vout.$271.Metal1 0.0211446f
Cred_6408 vdd.P13.pSD vout.$291.Metal1 0.0216203f
Cred_6409 vdd.P13.pSD vout.$331.Metal1 0.0216975f
Cred_6410 vdd.P13.pSD vout.$351.Metal1 0.0281126f
Cred_6411 vdd.P13.pSD vout.$400.Metal1 1.06526e-05f
Cred_6412 vdd.P13.pSD vout.$401.Metal1 0.0305041f
Cred_6413 vdd.P13.pSD vout.$594.Metal2 0.0264554f
Cred_6414 vdd.P13.pSD vout.$614.Metal2 0.014006f
Cred_6415 vdd.P13.pSD vout.$634.Metal2 0.0138003f
Cred_6416 vdd.P13.pSD vout.$654.Metal2 0.0132835f
Cred_6417 vdd.P13.pSD vout.$674.Metal2 0.0124214f
Cred_6418 vdd.P13.pSD vout.$692.Metal2 0.00123091f
Cred_6419 vdd.P13.pSD vout.$694.Metal2 0.0129862f
Cred_6420 vdd.P13.pSD vout.$712.Metal2 0.00118125f
Cred_6421 vdd.P13.pSD vout.$714.Metal2 0.0127005f
Cred_6422 vdd.P13.pSD vout.$732.Metal2 0.00109824f
Cred_6423 vdd.P13.pSD vout.$734.Metal2 0.0170941f
Cred_6424 vdd.P13.pSD vout.$752.Metal2 0.00101028f
Cred_6425 vdd.P13.pSD vout.$772.Metal2 0.000902409f
Cred_6426 vdd.P13.pSD vout.$774.Metal2 0.0152645f
Cred_6427 vdd.P13.pSD vout.$792.Metal2 0.00132208f
Cred_6428 vdd.P13.pSD vout.$794.Metal2 0.01448f
Cred_6429 vdd.P13.pSD vout.P10.pSD 0.000615731f
Cred_6430 vdd.P13.pSD vref 0.0426039f
Cred_6431 vdd.P13.pSD vref.P0.GatPoly 0.00166131f
Cred_6432 vdd.P13.pSD vref.P0.nSD 0.00952376f
Cred_6433 vdd.P13.pSD vref.P0.pSD 0.216101f
Cred_6434 vdd.P13.pSD vss 2.65918e-07f
Cred_6435 vdd.P13.pSD vss.$1212.Metal5 2.74244e-07f
Cred_6436 vdd.P13.pSD vss.$1230.Metal5 2.74244e-07f
Cred_6437 vdd.P13.pSD vss.$1282.Metal5 1.04975e-06f
Cred_6438 vdd.P13.pSD vss.$1300.Metal5 0.00962066f
Cred_6439 vdd.P15.pSD vout 0.000862434f
Cred_6440 vdd.P15.pSD vout.$1002.Metal3 0.00360938f
Cred_6441 vdd.P15.pSD vout.$1004.Metal3 0.00364142f
Cred_6442 vdd.P15.pSD vout.$1042.Metal3 0.00261404f
Cred_6443 vdd.P15.pSD vout.$1044.Metal3 0.0032179f
Cred_6444 vdd.P15.pSD vout.$1082.Metal3 0.00310798f
Cred_6445 vdd.P15.pSD vout.$1084.Metal3 0.00229128f
Cred_6446 vdd.P15.pSD vout.$1122.Metal3 0.00293927f
Cred_6447 vdd.P15.pSD vout.$1124.Metal3 0.00262017f
Cred_6448 vdd.P15.pSD vout.$1162.Metal3 0.00439679f
Cred_6449 vdd.P15.pSD vout.$1164.Metal3 0.00443914f
Cred_6450 vdd.P15.pSD vout.$1299.Metal4 1.03851e-08f
Cred_6451 vdd.P15.pSD vout.$1313.Metal4 0.0018352f
Cred_6452 vdd.P15.pSD vout.$1323.Metal4 0.0017308f
Cred_6453 vdd.P15.pSD vout.$1333.Metal4 0.00173388f
Cred_6454 vdd.P15.pSD vout.$1343.Metal4 0.0016654f
Cred_6455 vdd.P15.pSD vout.$1353.Metal4 0.00360318f
Cred_6456 vdd.P15.pSD vout.$1363.Metal4 0.00342388f
Cred_6457 vdd.P15.pSD vout.$1373.Metal4 0.0015526f
Cred_6458 vdd.P15.pSD vout.$1383.Metal4 0.00513183f
Cred_6459 vdd.P15.pSD vout.$1384.Metal4 0.000757646f
Cred_6460 vdd.P15.pSD vout.$1394.Metal4 0.00414117f
Cred_6461 vdd.P15.pSD vout.$161.Metal1 0.0252229f
Cred_6462 vdd.P15.pSD vout.$162.Metal1 0.0306696f
Cred_6463 vdd.P15.pSD vout.$201.Metal1 0.0295893f
Cred_6464 vdd.P15.pSD vout.$212.Metal1 0.0292411f
Cred_6465 vdd.P15.pSD vout.$231.Metal1 0.0298579f
Cred_6466 vdd.P15.pSD vout.$232.Metal1 0.0210924f
Cred_6467 vdd.P15.pSD vout.$271.Metal1 0.0217359f
Cred_6468 vdd.P15.pSD vout.$272.Metal1 0.0212436f
Cred_6469 vdd.P15.pSD vout.$291.Metal1 0.0209701f
Cred_6470 vdd.P15.pSD vout.$292.Metal1 0.0209213f
Cred_6471 vdd.P15.pSD vout.$331.Metal1 0.0208069f
Cred_6472 vdd.P15.pSD vout.$332.Metal1 0.0202887f
Cred_6473 vdd.P15.pSD vout.$351.Metal1 0.0267786f
Cred_6474 vdd.P15.pSD vout.$352.Metal1 0.0264844f
Cred_6475 vdd.P15.pSD vout.$401.Metal1 0.0282717f
Cred_6476 vdd.P15.pSD vout.$402.Metal1 0.0286387f
Cred_6477 vdd.P15.pSD vout.$594.Metal2 0.0256138f
Cred_6478 vdd.P15.pSD vout.$596.Metal2 0.0258587f
Cred_6479 vdd.P15.pSD vout.$614.Metal2 0.0137744f
Cred_6480 vdd.P15.pSD vout.$616.Metal2 0.020654f
Cred_6481 vdd.P15.pSD vout.$634.Metal2 0.0135806f
Cred_6482 vdd.P15.pSD vout.$654.Metal2 0.0130756f
Cred_6483 vdd.P15.pSD vout.$656.Metal2 0.019658f
Cred_6484 vdd.P15.pSD vout.$674.Metal2 0.0131166f
Cred_6485 vdd.P15.pSD vout.$676.Metal2 0.0125694f
Cred_6486 vdd.P15.pSD vout.$694.Metal2 0.0128919f
Cred_6487 vdd.P15.pSD vout.$696.Metal2 0.0124152f
Cred_6488 vdd.P15.pSD vout.$714.Metal2 0.0127517f
Cred_6489 vdd.P15.pSD vout.$716.Metal2 0.0124183f
Cred_6490 vdd.P15.pSD vout.$734.Metal2 0.0171659f
Cred_6491 vdd.P15.pSD vout.$736.Metal2 0.0167197f
Cred_6492 vdd.P15.pSD vout.$774.Metal2 0.0153138f
Cred_6493 vdd.P15.pSD vout.$776.Metal2 0.0149259f
Cred_6494 vdd.P15.pSD vout.$794.Metal2 0.0144964f
Cred_6495 vdd.P15.pSD vout.$796.Metal2 0.014067f
Cred_6496 vdd.P15.pSD vout.P0.GatPoly 1.35287e-07f
Cred_6497 vdd.P15.pSD vout.P10.pSD 0.000608823f
Cred_6498 vdd.P15.pSD vout.P12.pSD 0.000751344f
Cred_6499 vdd.P15.pSD vss 2.71713e-05f
Cred_6500 vdd.P15.pSD vss.$1212.Metal5 2.8022e-05f
Cred_6501 vdd.P15.pSD vss.$1230.Metal5 2.8022e-05f
Cred_6502 vdd.P15.pSD vss.$1282.Metal5 0.000107262f
Cred_6503 vdd.P15.pSD vss.$1300.Metal5 0.000107262f
Cred_6504 vdd.P17.pSD vout 0.000862117f
Cred_6505 vdd.P17.pSD vout.$1004.Metal3 0.00360804f
Cred_6506 vdd.P17.pSD vout.$1006.Metal3 0.00364007f
Cred_6507 vdd.P17.pSD vout.$1044.Metal3 0.00274504f
Cred_6508 vdd.P17.pSD vout.$1046.Metal3 0.00321661f
Cred_6509 vdd.P17.pSD vout.$1084.Metal3 0.00310657f
Cred_6510 vdd.P17.pSD vout.$1086.Metal3 0.00271558f
Cred_6511 vdd.P17.pSD vout.$1124.Metal3 0.00293768f
Cred_6512 vdd.P17.pSD vout.$1126.Metal3 0.00261873f
Cred_6513 vdd.P17.pSD vout.$1164.Metal3 0.00439318f
Cred_6514 vdd.P17.pSD vout.$1166.Metal3 0.00443552f
Cred_6515 vdd.P17.pSD vout.$1299.Metal4 1.03813e-08f
Cred_6516 vdd.P17.pSD vout.$1313.Metal4 0.00183452f
Cred_6517 vdd.P17.pSD vout.$1323.Metal4 0.00383832f
Cred_6518 vdd.P17.pSD vout.$1333.Metal4 0.00173322f
Cred_6519 vdd.P17.pSD vout.$1343.Metal4 0.00369317f
Cred_6520 vdd.P17.pSD vout.$1353.Metal4 0.00163854f
Cred_6521 vdd.P17.pSD vout.$1363.Metal4 0.00154265f
Cred_6522 vdd.P17.pSD vout.$1373.Metal4 0.00155183f
Cred_6523 vdd.P17.pSD vout.$1384.Metal4 0.00259205f
Cred_6524 vdd.P17.pSD vout.$1394.Metal4 0.00412599f
Cred_6525 vdd.P17.pSD vout.$1395.Metal4 0.000721263f
Cred_6526 vdd.P17.pSD vout.$1405.Metal4 0.000648211f
Cred_6527 vdd.P17.pSD vout.$1415.Metal4 0.00164188f
Cred_6528 vdd.P17.pSD vout.$162.Metal1 0.0318976f
Cred_6529 vdd.P17.pSD vout.$163.Metal1 0.0295612f
Cred_6530 vdd.P17.pSD vout.$212.Metal1 0.0283042f
Cred_6531 vdd.P17.pSD vout.$213.Metal1 0.0278753f
Cred_6532 vdd.P17.pSD vout.$232.Metal1 0.0217622f
Cred_6533 vdd.P17.pSD vout.$233.Metal1 0.0203079f
Cred_6534 vdd.P17.pSD vout.$272.Metal1 0.0210956f
Cred_6535 vdd.P17.pSD vout.$273.Metal1 0.020092f
Cred_6536 vdd.P17.pSD vout.$292.Metal1 0.0206751f
Cred_6537 vdd.P17.pSD vout.$293.Metal1 0.020917f
Cred_6538 vdd.P17.pSD vout.$332.Metal1 0.0208025f
Cred_6539 vdd.P17.pSD vout.$333.Metal1 0.0202844f
Cred_6540 vdd.P17.pSD vout.$352.Metal1 0.0267726f
Cred_6541 vdd.P17.pSD vout.$353.Metal1 0.0264784f
Cred_6542 vdd.P17.pSD vout.$402.Metal1 0.028265f
Cred_6543 vdd.P17.pSD vout.$403.Metal1 0.029114f
Cred_6544 vdd.P17.pSD vout.$596.Metal2 0.025721f
Cred_6545 vdd.P17.pSD vout.$598.Metal2 0.0253754f
Cred_6546 vdd.P17.pSD vout.$616.Metal2 0.0206512f
Cred_6547 vdd.P17.pSD vout.$618.Metal2 0.0206285f
Cred_6548 vdd.P17.pSD vout.$656.Metal2 0.0196563f
Cred_6549 vdd.P17.pSD vout.$658.Metal2 0.0192113f
Cred_6550 vdd.P17.pSD vout.$676.Metal2 0.0125678f
Cred_6551 vdd.P17.pSD vout.$678.Metal2 0.0125575f
Cred_6552 vdd.P17.pSD vout.$696.Metal2 0.0128824f
Cred_6553 vdd.P17.pSD vout.$698.Metal2 0.0121111f
Cred_6554 vdd.P17.pSD vout.$716.Metal2 0.0127448f
Cred_6555 vdd.P17.pSD vout.$718.Metal2 0.0124116f
Cred_6556 vdd.P17.pSD vout.$736.Metal2 0.0171552f
Cred_6557 vdd.P17.pSD vout.$738.Metal2 0.0167093f
Cred_6558 vdd.P17.pSD vout.$776.Metal2 0.0153024f
Cred_6559 vdd.P17.pSD vout.$778.Metal2 0.0149148f
Cred_6560 vdd.P17.pSD vout.$796.Metal2 0.0144811f
Cred_6561 vdd.P17.pSD vout.$798.Metal2 0.0140552f
Cred_6562 vdd.P17.pSD vout.P0.GatPoly 1.35237e-07f
Cred_6563 vdd.P17.pSD vout.P12.pSD 0.000760012f
Cred_6564 vdd.P17.pSD vout.P14.pSD 0.000734876f
Cred_6565 vdd.P17.pSD vss 2.70657e-05f
Cred_6566 vdd.P17.pSD vss.$1212.Metal5 2.79131e-05f
Cred_6567 vdd.P17.pSD vss.$1230.Metal5 2.79131e-05f
Cred_6568 vdd.P17.pSD vss.$1282.Metal5 0.000106846f
Cred_6569 vdd.P17.pSD vss.$1300.Metal5 0.000106846f
Cred_6570 vdd.P19.pSD vout 0.000862569f
Cred_6571 vdd.P19.pSD vout.$1006.Metal3 0.00360995f
Cred_6572 vdd.P19.pSD vout.$1008.Metal3 0.003642f
Cred_6573 vdd.P19.pSD vout.$1046.Metal3 0.00274662f
Cred_6574 vdd.P19.pSD vout.$1048.Metal3 0.00321845f
Cred_6575 vdd.P19.pSD vout.$1086.Metal3 0.00268297f
Cred_6576 vdd.P19.pSD vout.$1088.Metal3 0.00271735f
Cred_6577 vdd.P19.pSD vout.$1126.Metal3 0.00293995f
Cred_6578 vdd.P19.pSD vout.$1128.Metal3 0.00262078f
Cred_6579 vdd.P19.pSD vout.$1166.Metal3 0.00439834f
Cred_6580 vdd.P19.pSD vout.$1168.Metal3 0.00253656f
Cred_6581 vdd.P19.pSD vout.$1208.Metal3 0.00230174f
Cred_6582 vdd.P19.pSD vout.$1299.Metal4 1.03868e-08f
Cred_6583 vdd.P19.pSD vout.$1313.Metal4 0.00183549f
Cred_6584 vdd.P19.pSD vout.$1323.Metal4 0.00173108f
Cred_6585 vdd.P19.pSD vout.$1333.Metal4 0.00173417f
Cred_6586 vdd.P19.pSD vout.$1343.Metal4 0.00166568f
Cred_6587 vdd.P19.pSD vout.$1353.Metal4 0.00163953f
Cred_6588 vdd.P19.pSD vout.$1363.Metal4 0.00154365f
Cred_6589 vdd.P19.pSD vout.$1373.Metal4 0.00155293f
Cred_6590 vdd.P19.pSD vout.$1384.Metal4 0.00151564f
Cred_6591 vdd.P19.pSD vout.$1395.Metal4 0.00228554f
Cred_6592 vdd.P19.pSD vout.$1405.Metal4 0.00207201f
Cred_6593 vdd.P19.pSD vout.$1415.Metal4 0.00247904f
Cred_6594 vdd.P19.pSD vout.$1416.Metal4 0.000593265f
Cred_6595 vdd.P19.pSD vout.$163.Metal1 0.0330091f
Cred_6596 vdd.P19.pSD vout.$164.Metal1 0.0306721f
Cred_6597 vdd.P19.pSD vout.$213.Metal1 0.0305892f
Cred_6598 vdd.P19.pSD vout.$214.Metal1 0.0283266f
Cred_6599 vdd.P19.pSD vout.$233.Metal1 0.0225261f
Cred_6600 vdd.P19.pSD vout.$234.Metal1 0.0205603f
Cred_6601 vdd.P19.pSD vout.$273.Metal1 0.0222157f
Cred_6602 vdd.P19.pSD vout.$274.Metal1 0.0211762f
Cred_6603 vdd.P19.pSD vout.$293.Metal1 0.0206812f
Cred_6604 vdd.P19.pSD vout.$294.Metal1 0.0209199f
Cred_6605 vdd.P19.pSD vout.$333.Metal1 0.0208089f
Cred_6606 vdd.P19.pSD vout.$334.Metal1 0.0202906f
Cred_6607 vdd.P19.pSD vout.$353.Metal1 0.0267812f
Cred_6608 vdd.P19.pSD vout.$354.Metal1 0.026487f
Cred_6609 vdd.P19.pSD vout.$403.Metal1 0.0282746f
Cred_6610 vdd.P19.pSD vout.$404.Metal1 0.0286402f
Cred_6611 vdd.P19.pSD vout.$598.Metal2 0.0262085f
Cred_6612 vdd.P19.pSD vout.$600.Metal2 0.0258628f
Cred_6613 vdd.P19.pSD vout.$618.Metal2 0.0206801f
Cred_6614 vdd.P19.pSD vout.$620.Metal2 0.0206574f
Cred_6615 vdd.P19.pSD vout.$658.Metal2 0.0201066f
Cred_6616 vdd.P19.pSD vout.$660.Metal2 0.0192241f
Cred_6617 vdd.P19.pSD vout.$678.Metal2 0.0125819f
Cred_6618 vdd.P19.pSD vout.$680.Metal2 0.012571f
Cred_6619 vdd.P19.pSD vout.$698.Metal2 0.0131897f
Cred_6620 vdd.P19.pSD vout.$700.Metal2 0.0124178f
Cred_6621 vdd.P19.pSD vout.$718.Metal2 0.0127546f
Cred_6622 vdd.P19.pSD vout.$720.Metal2 0.0124211f
Cred_6623 vdd.P19.pSD vout.$738.Metal2 0.0171705f
Cred_6624 vdd.P19.pSD vout.$740.Metal2 0.0167242f
Cred_6625 vdd.P19.pSD vout.$778.Metal2 0.0153187f
Cred_6626 vdd.P19.pSD vout.$780.Metal2 0.0148925f
Cred_6627 vdd.P19.pSD vout.$798.Metal2 0.014503f
Cred_6628 vdd.P19.pSD vout.$800.Metal2 0.0139236f
Cred_6629 vdd.P19.pSD vout.P0.GatPoly 1.35308e-07f
Cred_6630 vdd.P19.pSD vout.P14.pSD 0.000776405f
Cred_6631 vdd.P19.pSD vout.P16.pSD 0.000750677f
Cred_6632 vdd.P19.pSD vss 2.72165e-05f
Cred_6633 vdd.P19.pSD vss.$1212.Metal5 2.80686e-05f
Cred_6634 vdd.P19.pSD vss.$1230.Metal5 2.80686e-05f
Cred_6635 vdd.P19.pSD vss.$1282.Metal5 0.000107441f
Cred_6636 vdd.P19.pSD vss.$1300.Metal5 0.000107441f
Cred_6637 vdd.P2.GatPoly vout 3.21922e-05f
Cred_6638 vdd.P2.GatPoly vout.$1002.Metal3 8.58911e-11f
Cred_6639 vdd.P2.GatPoly vout.$1004.Metal3 1.10336e-10f
Cred_6640 vdd.P2.GatPoly vout.$1006.Metal3 1.42099e-10f
Cred_6641 vdd.P2.GatPoly vout.$1008.Metal3 1.83286e-10f
Cred_6642 vdd.P2.GatPoly vout.$1010.Metal3 2.36629e-10f
Cred_6643 vdd.P2.GatPoly vout.$1032.Metal3 2.36226e-11f
Cred_6644 vdd.P2.GatPoly vout.$1034.Metal3 2.54468e-11f
Cred_6645 vdd.P2.GatPoly vout.$1036.Metal3 3.34869e-11f
Cred_6646 vdd.P2.GatPoly vout.$1038.Metal3 4.25061e-11f
Cred_6647 vdd.P2.GatPoly vout.$1040.Metal3 6.59014e-11f
Cred_6648 vdd.P2.GatPoly vout.$1299.Metal4 2.42331e-08f
Cred_6649 vdd.P2.GatPoly vout.$1313.Metal4 0.00058754f
Cred_6650 vdd.P2.GatPoly vout.$1328.Metal4 2.81346e-12f
Cred_6651 vdd.P2.GatPoly vout.$1329.Metal4 3.03072e-12f
Cred_6652 vdd.P2.GatPoly vout.$1330.Metal4 3.9883e-12f
Cred_6653 vdd.P2.GatPoly vout.$1331.Metal4 5.06249e-12f
Cred_6654 vdd.P2.GatPoly vout.$1332.Metal4 7.84887e-12f
Cred_6655 vdd.P2.GatPoly vout.$156.Metal1 2.37825e-07f
Cred_6656 vdd.P2.GatPoly vout.$157.Metal1 2.5619e-07f
Cred_6657 vdd.P2.GatPoly vout.$158.Metal1 3.37135e-07f
Cred_6658 vdd.P2.GatPoly vout.$159.Metal1 4.27938e-07f
Cred_6659 vdd.P2.GatPoly vout.$160.Metal1 6.63474e-07f
Cred_6660 vdd.P2.GatPoly vout.$161.Metal1 7.23786e-07f
Cred_6661 vdd.P2.GatPoly vout.$162.Metal1 9.29777e-07f
Cred_6662 vdd.P2.GatPoly vout.$163.Metal1 1.19743e-06f
Cred_6663 vdd.P2.GatPoly vout.$164.Metal1 1.54451e-06f
Cred_6664 vdd.P2.GatPoly vout.$165.Metal1 1.99402e-06f
Cred_6665 vdd.P2.GatPoly vout.$584.Metal2 1.4663e-09f
Cred_6666 vdd.P2.GatPoly vout.$586.Metal2 1.57953e-09f
Cred_6667 vdd.P2.GatPoly vout.$588.Metal2 2.0786e-09f
Cred_6668 vdd.P2.GatPoly vout.$590.Metal2 2.63843e-09f
Cred_6669 vdd.P2.GatPoly vout.$592.Metal2 4.09062e-09f
Cred_6670 vdd.P2.GatPoly vout.$594.Metal2 4.45682e-09f
Cred_6671 vdd.P2.GatPoly vout.$596.Metal2 5.72524e-09f
Cred_6672 vdd.P2.GatPoly vout.$598.Metal2 7.37337e-09f
Cred_6673 vdd.P2.GatPoly vout.$600.Metal2 9.51053e-09f
Cred_6674 vdd.P2.GatPoly vout.$602.Metal2 1.22785e-08f
Cred_6675 vdd.P2.GatPoly vout.$604.Metal2 4.73503e-13f
Cred_6676 vdd.P2.GatPoly vout.$606.Metal2 5.10067e-13f
Cred_6677 vdd.P2.GatPoly vout.$608.Metal2 6.71227e-13f
Cred_6678 vdd.P2.GatPoly vout.$610.Metal2 8.52011e-13f
Cred_6679 vdd.P2.GatPoly vout.$612.Metal2 1.32096e-12f
Cred_6680 vdd.P2.GatPoly vout.P0.GatPoly 1.55213e-06f
Cred_6681 vdd.P2.GatPoly vref 0.00031411f
Cred_6682 vdd.P2.GatPoly vref.P0.GatPoly 3.93299e-07f
Cred_6683 vdd.P2.GatPoly vref.P0.nSD 5.32287e-07f
Cred_6684 vdd.P2.GatPoly vref.P0.pSD 1.31714e-06f
Cred_6685 vdd.P2.GatPoly vss 0.00215787f
Cred_6686 vdd.P2.GatPoly vss.$1212.Metal5 0.00222543f
Cred_6687 vdd.P2.GatPoly vss.$1230.Metal5 0.00222543f
Cred_6688 vdd.P2.GatPoly vss.$1282.Metal5 0.00853777f
Cred_6689 vdd.P2.GatPoly vss.$1300.Metal5 0.00852177f
Cred_6690 vdd.P21.pSD vout 0.000862175f
Cred_6691 vdd.P21.pSD vout.$1008.Metal3 0.00360828f
Cred_6692 vdd.P21.pSD vout.$1010.Metal3 0.00436436f
Cred_6693 vdd.P21.pSD vout.$1048.Metal3 0.00274524f
Cred_6694 vdd.P21.pSD vout.$1050.Metal3 0.00348835f
Cred_6695 vdd.P21.pSD vout.$1070.Metal3 0.00218825f
Cred_6696 vdd.P21.pSD vout.$1088.Metal3 0.00268145f
Cred_6697 vdd.P21.pSD vout.$1110.Metal3 0.00298528f
Cred_6698 vdd.P21.pSD vout.$1128.Metal3 0.00293797f
Cred_6699 vdd.P21.pSD vout.$1150.Metal3 0.00304505f
Cred_6700 vdd.P21.pSD vout.$1168.Metal3 0.00254323f
Cred_6701 vdd.P21.pSD vout.$1190.Metal3 0.00397102f
Cred_6702 vdd.P21.pSD vout.$1208.Metal3 0.0022374f
Cred_6703 vdd.P21.pSD vout.$1299.Metal4 1.0382e-08f
Cred_6704 vdd.P21.pSD vout.$1313.Metal4 0.00184349f
Cred_6705 vdd.P21.pSD vout.$1323.Metal4 0.00173028f
Cred_6706 vdd.P21.pSD vout.$1333.Metal4 0.0042875f
Cred_6707 vdd.P21.pSD vout.$1343.Metal4 0.00166485f
Cred_6708 vdd.P21.pSD vout.$1353.Metal4 0.00162714f
Cred_6709 vdd.P21.pSD vout.$1363.Metal4 0.00156312f
Cred_6710 vdd.P21.pSD vout.$1373.Metal4 0.00154293f
Cred_6711 vdd.P21.pSD vout.$1384.Metal4 0.00152745f
Cred_6712 vdd.P21.pSD vout.$1395.Metal4 0.00142577f
Cred_6713 vdd.P21.pSD vout.$1405.Metal4 0.00130757f
Cred_6714 vdd.P21.pSD vout.$1415.Metal4 0.000839225f
Cred_6715 vdd.P21.pSD vout.$1416.Metal4 0.002998f
Cred_6716 vdd.P21.pSD vout.$164.Metal1 0.0318987f
Cred_6717 vdd.P21.pSD vout.$165.Metal1 0.030665f
Cred_6718 vdd.P21.pSD vout.$214.Metal1 0.0292217f
Cred_6719 vdd.P21.pSD vout.$215.Metal1 0.0283199f
Cred_6720 vdd.P21.pSD vout.$234.Metal1 0.022274f
Cred_6721 vdd.P21.pSD vout.$235.Metal1 0.0205553f
Cred_6722 vdd.P21.pSD vout.$274.Metal1 0.0211286f
Cred_6723 vdd.P21.pSD vout.$275.Metal1 0.0212323f
Cred_6724 vdd.P21.pSD vout.$294.Metal1 0.0206759f
Cred_6725 vdd.P21.pSD vout.$295.Metal1 0.0209742f
Cred_6726 vdd.P21.pSD vout.$334.Metal1 0.0208033f
Cred_6727 vdd.P21.pSD vout.$335.Metal1 0.0202739f
Cred_6728 vdd.P21.pSD vout.$354.Metal1 0.0267737f
Cred_6729 vdd.P21.pSD vout.$355.Metal1 0.0263875f
Cred_6730 vdd.P21.pSD vout.$404.Metal1 0.0282648f
Cred_6731 vdd.P21.pSD vout.$405.Metal1 0.0290611f
Cred_6732 vdd.P21.pSD vout.$600.Metal2 0.0257227f
Cred_6733 vdd.P21.pSD vout.$602.Metal2 0.0258594f
Cred_6734 vdd.P21.pSD vout.$620.Metal2 0.0206526f
Cred_6735 vdd.P21.pSD vout.$622.Metal2 0.0206532f
Cred_6736 vdd.P21.pSD vout.$660.Metal2 0.0200948f
Cred_6737 vdd.P21.pSD vout.$662.Metal2 0.0192027f
Cred_6738 vdd.P21.pSD vout.$680.Metal2 0.0125695f
Cred_6739 vdd.P21.pSD vout.$682.Metal2 0.0186619f
Cred_6740 vdd.P21.pSD vout.$700.Metal2 0.0128835f
Cred_6741 vdd.P21.pSD vout.$720.Metal2 0.0127461f
Cred_6742 vdd.P21.pSD vout.$722.Metal2 0.0185033f
Cred_6743 vdd.P21.pSD vout.$740.Metal2 0.0171571f
Cred_6744 vdd.P21.pSD vout.$742.Metal2 0.0115321f
Cred_6745 vdd.P21.pSD vout.$762.Metal2 0.0105472f
Cred_6746 vdd.P21.pSD vout.$780.Metal2 0.0152674f
Cred_6747 vdd.P21.pSD vout.$782.Metal2 0.00970213f
Cred_6748 vdd.P21.pSD vout.$800.Metal2 0.0143384f
Cred_6749 vdd.P21.pSD vout.$802.Metal2 0.0139897f
Cred_6750 vdd.P21.pSD vout.P0.GatPoly 1.35246e-07f
Cred_6751 vdd.P21.pSD vout.P16.pSD 0.000760626f
Cred_6752 vdd.P21.pSD vout.P18.pSD 0.000752061f
Cred_6753 vdd.P21.pSD vss 2.78193e-05f
Cred_6754 vdd.P21.pSD vss.$1212.Metal5 2.86902e-05f
Cred_6755 vdd.P21.pSD vss.$1230.Metal5 2.86902e-05f
Cred_6756 vdd.P21.pSD vss.$1282.Metal5 0.00010982f
Cred_6757 vdd.P21.pSD vss.$1300.Metal5 0.00010982f
Cred_6758 vdd.P23.pSD vout.$1010.Metal3 0.00420123f
Cred_6759 vdd.P23.pSD vout.$1050.Metal3 0.00195148f
Cred_6760 vdd.P23.pSD vout.$1070.Metal3 0.00271537f
Cred_6761 vdd.P23.pSD vout.$1110.Metal3 0.00367677f
Cred_6762 vdd.P23.pSD vout.$1150.Metal3 0.00303188f
Cred_6763 vdd.P23.pSD vout.$1190.Metal3 0.00367844f
Cred_6764 vdd.P23.pSD vout.$1313.Metal4 2.54269e-05f
Cred_6765 vdd.P23.pSD vout.$1323.Metal4 0.000452612f
Cred_6766 vdd.P23.pSD vout.$1333.Metal4 0.000458034f
Cred_6767 vdd.P23.pSD vout.$1343.Metal4 0.000435517f
Cred_6768 vdd.P23.pSD vout.$1353.Metal4 0.00042151f
Cred_6769 vdd.P23.pSD vout.$1363.Metal4 0.000414663f
Cred_6770 vdd.P23.pSD vout.$1373.Metal4 0.000438729f
Cred_6771 vdd.P23.pSD vout.$1384.Metal4 0.000488951f
Cred_6772 vdd.P23.pSD vout.$1395.Metal4 0.000438187f
Cred_6773 vdd.P23.pSD vout.$1405.Metal4 0.000418659f
Cred_6774 vdd.P23.pSD vout.$1416.Metal4 0.000973003f
Cred_6775 vdd.P23.pSD vout.$165.Metal1 0.0302372f
Cred_6776 vdd.P23.pSD vout.$215.Metal1 0.0271723f
Cred_6777 vdd.P23.pSD vout.$235.Metal1 0.0207439f
Cred_6778 vdd.P23.pSD vout.$275.Metal1 0.0200813f
Cred_6779 vdd.P23.pSD vout.$295.Metal1 0.0197155f
Cred_6780 vdd.P23.pSD vout.$335.Metal1 0.0194114f
Cred_6781 vdd.P23.pSD vout.$355.Metal1 0.0250894f
Cred_6782 vdd.P23.pSD vout.$405.Metal1 0.0271044f
Cred_6783 vdd.P23.pSD vout.$602.Metal2 0.0257235f
Cred_6784 vdd.P23.pSD vout.$622.Metal2 0.0203032f
Cred_6785 vdd.P23.pSD vout.$662.Metal2 0.0197601f
Cred_6786 vdd.P23.pSD vout.$682.Metal2 0.0184176f
Cred_6787 vdd.P23.pSD vout.$722.Metal2 0.0185366f
Cred_6788 vdd.P23.pSD vout.$742.Metal2 0.0115905f
Cred_6789 vdd.P23.pSD vout.$762.Metal2 0.0106097f
Cred_6790 vdd.P23.pSD vout.$782.Metal2 0.00973975f
Cred_6791 vdd.P23.pSD vout.$802.Metal2 0.0141826f
Cred_6792 vdd.P23.pSD vout.P18.pSD 0.000714674f
Cred_6793 vdd.P23.pSD vss 0.00160579f
Cred_6794 vdd.P23.pSD vss.$1212.Metal5 0.00165606f
Cred_6795 vdd.P23.pSD vss.$1230.Metal5 0.00165606f
Cred_6796 vdd.P23.pSD vss.$1282.Metal5 0.00633907f
Cred_6797 vdd.P23.pSD vss.$1300.Metal5 0.00633907f
Cred_6798 vdd.P25.pSD vout.$1010.Metal3 0.00154065f
Cred_6799 vdd.P25.pSD vout.$1050.Metal3 0.000966194f
Cred_6800 vdd.P25.pSD vout.$1070.Metal3 0.000889968f
Cred_6801 vdd.P25.pSD vout.$1110.Metal3 0.0012667f
Cred_6802 vdd.P25.pSD vout.$1150.Metal3 0.00124545f
Cred_6803 vdd.P25.pSD vout.$1190.Metal3 0.00151672f
Cred_6804 vdd.P25.pSD vout.$1313.Metal4 0.00254004f
Cred_6805 vdd.P25.pSD vout.$1333.Metal4 6.29625e-06f
Cred_6806 vdd.P25.pSD vout.$1363.Metal4 5.69764e-06f
Cred_6807 vdd.P25.pSD vout.$1373.Metal4 0.000383896f
Cred_6808 vdd.P25.pSD vout.$1384.Metal4 0.000417302f
Cred_6809 vdd.P25.pSD vout.$1395.Metal4 0.000383225f
Cred_6810 vdd.P25.pSD vout.$1405.Metal4 0.00035701f
Cred_6811 vdd.P25.pSD vout.$1416.Metal4 0.000619621f
Cred_6812 vdd.P25.pSD vout.$165.Metal1 3.92524e-05f
Cred_6813 vdd.P25.pSD vout.$215.Metal1 2.35964e-05f
Cred_6814 vdd.P25.pSD vout.$235.Metal1 2.50265e-06f
Cred_6815 vdd.P25.pSD vout.$275.Metal1 1.00861e-05f
Cred_6816 vdd.P25.pSD vout.$295.Metal1 9.81347e-06f
Cred_6817 vdd.P25.pSD vout.$405.Metal1 1.79641e-05f
Cred_6818 vdd.P25.pSD vout.$602.Metal2 0.00473686f
Cred_6819 vdd.P25.pSD vout.$622.Metal2 0.00403522f
Cred_6820 vdd.P25.pSD vout.$662.Metal2 0.00387968f
Cred_6821 vdd.P25.pSD vout.$682.Metal2 0.00346918f
Cred_6822 vdd.P25.pSD vout.$722.Metal2 0.00296889f
Cred_6823 vdd.P25.pSD vout.$742.Metal2 0.00183298f
Cred_6824 vdd.P25.pSD vout.$762.Metal2 0.0016861f
Cred_6825 vdd.P25.pSD vout.$782.Metal2 0.00150476f
Cred_6826 vdd.P25.pSD vout.$802.Metal2 0.00222013f
Cred_6827 vdd.P25.pSD vss 0.00445093f
Cred_6828 vdd.P25.pSD vss.$1212.Metal5 0.00459028f
Cred_6829 vdd.P25.pSD vss.$1230.Metal5 0.00459028f
Cred_6830 vdd.P25.pSD vss.$1282.Metal5 0.0175706f
Cred_6831 vdd.P25.pSD vss.$1300.Metal5 0.0175706f
Cred_6832 vdd.P3.pSD vout.$1032.Metal3 0.00567793f
Cred_6833 vdd.P3.pSD vout.$1034.Metal3 0.00668212f
Cred_6834 vdd.P3.pSD vout.$1072.Metal3 0.00231069f
Cred_6835 vdd.P3.pSD vout.$1074.Metal3 0.00311948f
Cred_6836 vdd.P3.pSD vout.$1112.Metal3 0.00323175f
Cred_6837 vdd.P3.pSD vout.$1114.Metal3 0.0027847f
Cred_6838 vdd.P3.pSD vout.$1152.Metal3 0.00498814f
Cred_6839 vdd.P3.pSD vout.$1154.Metal3 0.00443613f
Cred_6840 vdd.P3.pSD vout.$1328.Metal4 0.00185318f
Cred_6841 vdd.P3.pSD vout.$1329.Metal4 0.00185631f
Cred_6842 vdd.P3.pSD vout.$1368.Metal4 0.00586847f
Cred_6843 vdd.P3.pSD vout.$1369.Metal4 0.0147335f
Cred_6844 vdd.P3.pSD vout.$1408.Metal4 0.00376635f
Cred_6845 vdd.P3.pSD vout.$156.Metal1 0.0310525f
Cred_6846 vdd.P3.pSD vout.$157.Metal1 0.0310115f
Cred_6847 vdd.P3.pSD vout.$206.Metal1 0.028375f
Cred_6848 vdd.P3.pSD vout.$207.Metal1 0.0283199f
Cred_6849 vdd.P3.pSD vout.$226.Metal1 0.0211074f
Cred_6850 vdd.P3.pSD vout.$227.Metal1 0.0205553f
Cred_6851 vdd.P3.pSD vout.$266.Metal1 0.0208833f
Cred_6852 vdd.P3.pSD vout.$267.Metal1 0.0207714f
Cred_6853 vdd.P3.pSD vout.$286.Metal1 0.0210071f
Cred_6854 vdd.P3.pSD vout.$287.Metal1 0.0205258f
Cred_6855 vdd.P3.pSD vout.$326.Metal1 0.0208033f
Cred_6856 vdd.P3.pSD vout.$327.Metal1 0.0202852f
Cred_6857 vdd.P3.pSD vout.$346.Metal1 0.0267737f
Cred_6858 vdd.P3.pSD vout.$347.Metal1 0.0264795f
Cred_6859 vdd.P3.pSD vout.$396.Metal1 0.0282664f
Cred_6860 vdd.P3.pSD vout.$397.Metal1 0.0286332f
Cred_6861 vdd.P3.pSD vout.$584.Metal2 0.0266975f
Cred_6862 vdd.P3.pSD vout.$586.Metal2 0.026102f
Cred_6863 vdd.P3.pSD vout.$604.Metal2 0.0207062f
Cred_6864 vdd.P3.pSD vout.$606.Metal2 0.0207122f
Cred_6865 vdd.P3.pSD vout.$644.Metal2 0.0196515f
Cred_6866 vdd.P3.pSD vout.$646.Metal2 0.0196534f
Cred_6867 vdd.P3.pSD vout.$664.Metal2 0.0129779f
Cred_6868 vdd.P3.pSD vout.$666.Metal2 0.0125639f
Cred_6869 vdd.P3.pSD vout.$684.Metal2 0.0128765f
Cred_6870 vdd.P3.pSD vout.$686.Metal2 0.0124069f
Cred_6871 vdd.P3.pSD vout.$704.Metal2 0.0127461f
Cred_6872 vdd.P3.pSD vout.$706.Metal2 0.0124128f
Cred_6873 vdd.P3.pSD vout.$724.Metal2 0.0171575f
Cred_6874 vdd.P3.pSD vout.$726.Metal2 0.0167112f
Cred_6875 vdd.P3.pSD vout.$764.Metal2 0.0153086f
Cred_6876 vdd.P3.pSD vout.$766.Metal2 0.0149168f
Cred_6877 vdd.P3.pSD vout.$784.Metal2 0.014502f
Cred_6878 vdd.P3.pSD vout.$786.Metal2 0.0140549f
Cred_6879 vdd.P3.pSD vout.P0.pSD 0.000749846f
Cred_6880 vdd.P3.pSD vout.P2.pSD 0.000750483f
Cred_6881 vdd.P3.pSD vss.$1282.Metal5 0.0105607f
Cred_6882 vdd.P5.pSD vout.$1034.Metal3 0.00519546f
Cred_6883 vdd.P5.pSD vout.$1036.Metal3 0.00668474f
Cred_6884 vdd.P5.pSD vout.$1074.Metal3 0.00231185f
Cred_6885 vdd.P5.pSD vout.$1076.Metal3 0.00236293f
Cred_6886 vdd.P5.pSD vout.$1096.Metal3 0.0029775f
Cred_6887 vdd.P5.pSD vout.$1114.Metal3 0.00276659f
Cred_6888 vdd.P5.pSD vout.$1154.Metal3 0.00439834f
Cred_6889 vdd.P5.pSD vout.$1156.Metal3 0.00508222f
Cred_6890 vdd.P5.pSD vout.$1329.Metal4 0.00179453f
Cred_6891 vdd.P5.pSD vout.$1330.Metal4 0.00185714f
Cred_6892 vdd.P5.pSD vout.$1369.Metal4 0.0139857f
Cred_6893 vdd.P5.pSD vout.$1370.Metal4 0.00884288f
Cred_6894 vdd.P5.pSD vout.$157.Metal1 0.0310592f
Cred_6895 vdd.P5.pSD vout.$158.Metal1 0.0305791f
Cred_6896 vdd.P5.pSD vout.$207.Metal1 0.0283817f
Cred_6897 vdd.P5.pSD vout.$208.Metal1 0.0274943f
Cred_6898 vdd.P5.pSD vout.$227.Metal1 0.0216464f
Cred_6899 vdd.P5.pSD vout.$228.Metal1 0.0203726f
Cred_6900 vdd.P5.pSD vout.$267.Metal1 0.0209544f
Cred_6901 vdd.P5.pSD vout.$268.Metal1 0.0197561f
Cred_6902 vdd.P5.pSD vout.$287.Metal1 0.0210126f
Cred_6903 vdd.P5.pSD vout.$288.Metal1 0.0205909f
Cred_6904 vdd.P5.pSD vout.$327.Metal1 0.0208089f
Cred_6905 vdd.P5.pSD vout.$328.Metal1 0.0202906f
Cred_6906 vdd.P5.pSD vout.$347.Metal1 0.0267812f
Cred_6907 vdd.P5.pSD vout.$348.Metal1 0.026487f
Cred_6908 vdd.P5.pSD vout.$397.Metal1 0.0282746f
Cred_6909 vdd.P5.pSD vout.$398.Metal1 0.0291239f
Cred_6910 vdd.P5.pSD vout.$586.Metal2 0.0266604f
Cred_6911 vdd.P5.pSD vout.$588.Metal2 0.026069f
Cred_6912 vdd.P5.pSD vout.$606.Metal2 0.0207064f
Cred_6913 vdd.P5.pSD vout.$608.Metal2 0.0207185f
Cred_6914 vdd.P5.pSD vout.$646.Metal2 0.0196641f
Cred_6915 vdd.P5.pSD vout.$648.Metal2 0.0196626f
Cred_6916 vdd.P5.pSD vout.$666.Metal2 0.0125727f
Cred_6917 vdd.P5.pSD vout.$668.Metal2 0.0186438f
Cred_6918 vdd.P5.pSD vout.$686.Metal2 0.0125863f
Cred_6919 vdd.P5.pSD vout.$706.Metal2 0.0127546f
Cred_6920 vdd.P5.pSD vout.$708.Metal2 0.0185255f
Cred_6921 vdd.P5.pSD vout.$726.Metal2 0.0171705f
Cred_6922 vdd.P5.pSD vout.$728.Metal2 0.0167371f
Cred_6923 vdd.P5.pSD vout.$766.Metal2 0.0153187f
Cred_6924 vdd.P5.pSD vout.$768.Metal2 0.0149307f
Cred_6925 vdd.P5.pSD vout.$786.Metal2 0.014503f
Cred_6926 vdd.P5.pSD vout.$788.Metal2 0.0140763f
Cred_6927 vdd.P5.pSD vout.P2.pSD 0.000749195f
Cred_6928 vdd.P5.pSD vout.P4.pSD 0.000743052f
Cred_6929 vdd.P5.pSD vss.$1282.Metal5 0.0105566f
Cred_6930 vdd.P7.pSD vout.$1036.Metal3 0.00518819f
Cred_6931 vdd.P7.pSD vout.$1038.Metal3 0.00622706f
Cred_6932 vdd.P7.pSD vout.$1076.Metal3 0.00171827f
Cred_6933 vdd.P7.pSD vout.$1078.Metal3 0.00311922f
Cred_6934 vdd.P7.pSD vout.$1096.Metal3 0.00273296f
Cred_6935 vdd.P7.pSD vout.$1118.Metal3 0.00278443f
Cred_6936 vdd.P7.pSD vout.$1156.Metal3 0.0050802f
Cred_6937 vdd.P7.pSD vout.$1158.Metal3 0.00443547f
Cred_6938 vdd.P7.pSD vout.$1330.Metal4 0.00179353f
Cred_6939 vdd.P7.pSD vout.$1331.Metal4 0.00185618f
Cred_6940 vdd.P7.pSD vout.$1370.Metal4 0.0140099f
Cred_6941 vdd.P7.pSD vout.$1371.Metal4 0.00881199f
Cred_6942 vdd.P7.pSD vout.$158.Metal1 0.0314896f
Cred_6943 vdd.P7.pSD vout.$159.Metal1 0.0310104f
Cred_6944 vdd.P7.pSD vout.$208.Metal1 0.0292022f
Cred_6945 vdd.P7.pSD vout.$209.Metal1 0.0283229f
Cred_6946 vdd.P7.pSD vout.$228.Metal1 0.0218503f
Cred_6947 vdd.P7.pSD vout.$229.Metal1 0.0210887f
Cred_6948 vdd.P7.pSD vout.$268.Metal1 0.0221291f
Cred_6949 vdd.P7.pSD vout.$269.Metal1 0.0208365f
Cred_6950 vdd.P7.pSD vout.$288.Metal1 0.02107f
Cred_6951 vdd.P7.pSD vout.$289.Metal1 0.020525f
Cred_6952 vdd.P7.pSD vout.$328.Metal1 0.0208025f
Cred_6953 vdd.P7.pSD vout.$329.Metal1 0.0202844f
Cred_6954 vdd.P7.pSD vout.$348.Metal1 0.0267726f
Cred_6955 vdd.P7.pSD vout.$349.Metal1 0.0264784f
Cred_6956 vdd.P7.pSD vout.$398.Metal1 0.028265f
Cred_6957 vdd.P7.pSD vout.$399.Metal1 0.028632f
Cred_6958 vdd.P7.pSD vout.$588.Metal2 0.026654f
Cred_6959 vdd.P7.pSD vout.$590.Metal2 0.0261003f
Cred_6960 vdd.P7.pSD vout.$608.Metal2 0.0204785f
Cred_6961 vdd.P7.pSD vout.$610.Metal2 0.0209309f
Cred_6962 vdd.P7.pSD vout.$648.Metal2 0.0194334f
Cred_6963 vdd.P7.pSD vout.$650.Metal2 0.0198745f
Cred_6964 vdd.P7.pSD vout.$668.Metal2 0.0187299f
Cred_6965 vdd.P7.pSD vout.$670.Metal2 0.0125638f
Cred_6966 vdd.P7.pSD vout.$690.Metal2 0.0124058f
Cred_6967 vdd.P7.pSD vout.$708.Metal2 0.0189325f
Cred_6968 vdd.P7.pSD vout.$710.Metal2 0.0124116f
Cred_6969 vdd.P7.pSD vout.$728.Metal2 0.0171689f
Cred_6970 vdd.P7.pSD vout.$730.Metal2 0.0167093f
Cred_6971 vdd.P7.pSD vout.$768.Metal2 0.0153024f
Cred_6972 vdd.P7.pSD vout.$770.Metal2 0.0149148f
Cred_6973 vdd.P7.pSD vout.$788.Metal2 0.0144811f
Cred_6974 vdd.P7.pSD vout.$790.Metal2 0.0140522f
Cred_6975 vdd.P7.pSD vout.P4.pSD 0.000756743f
Cred_6976 vdd.P7.pSD vout.P6.pSD 0.000751188f
Cred_6977 vdd.P7.pSD vss.$1282.Metal5 0.00984808f
Cred_6978 vout vref 0.924044f
Cred_6979 vout vref.P0.GatPoly 0.0312716f
Cred_6980 vout vref.P0.nSD 0.0449771f
Cred_6981 vout vref.P0.pSD 0.0835236f
Cred_6982 vout vss 0.0453461f
Cred_6983 vout vss.$1212.Metal5 0.0467658f
Cred_6984 vout vss.$1230.Metal5 0.0467658f
Cred_6985 vout vss.$127.Metal1 6.8827e-05f
Cred_6986 vout vss.$1282.Metal5 0.17901f
Cred_6987 vout vss.$1300.Metal5 1.52474f
Cred_6988 vout vss.$406.Metal1 0.00260822f
Cred_6989 vout vss.$457.Metal2 1.00521e-06f
Cred_6990 vout vss.P0.GatPoly 2.46063e-06f
Cred_6991 vout vss.P0.pSD 0.00689287f
Cred_6992 vout.$1002.Metal3 vref 0.0106714f
Cred_6993 vout.$1002.Metal3 vref.P0.GatPoly 0.000416126f
Cred_6994 vout.$1002.Metal3 vref.P0.nSD 0.00238551f
Cred_6995 vout.$1002.Metal3 vref.P0.pSD 0.0130513f
Cred_6996 vout.$1002.Metal3 vss.$1300.Metal5 0.0049799f
Cred_6997 vout.$1010.Metal3 vss 0.00214343f
Cred_6998 vout.$1010.Metal3 vss.$1212.Metal5 0.00221054f
Cred_6999 vout.$1010.Metal3 vss.$1230.Metal5 0.00221054f
Cred_7000 vout.$1010.Metal3 vss.$1282.Metal5 0.00846149f
Cred_7001 vout.$1010.Metal3 vss.$1300.Metal5 0.00846149f
Cred_7002 vout.$1032.Metal3 vref 1.66781e-05f
Cred_7003 vout.$1032.Metal3 vref.P0.GatPoly 6.50354e-07f
Cred_7004 vout.$1032.Metal3 vref.P0.nSD 3.72826e-06f
Cred_7005 vout.$1032.Metal3 vref.P0.pSD 1.11434e-05f
Cred_7006 vout.$1032.Metal3 vss.$1282.Metal5 0.0556033f
Cred_7007 vout.$1034.Metal3 vref 7.94893e-05f
Cred_7008 vout.$1034.Metal3 vref.P0.GatPoly 3.09964e-06f
Cred_7009 vout.$1034.Metal3 vref.P0.nSD 1.77692e-05f
Cred_7010 vout.$1034.Metal3 vref.P0.pSD 5.39625e-05f
Cred_7011 vout.$1034.Metal3 vss.$1282.Metal5 0.0260163f
Cred_7012 vout.$1036.Metal3 vref 0.00010917f
Cred_7013 vout.$1036.Metal3 vref.P0.GatPoly 4.25701e-06f
Cred_7014 vout.$1036.Metal3 vref.P0.nSD 2.4404e-05f
Cred_7015 vout.$1036.Metal3 vref.P0.pSD 7.40848e-05f
Cred_7016 vout.$1036.Metal3 vss.$1282.Metal5 0.025987f
Cred_7017 vout.$1038.Metal3 vref 0.000174336f
Cred_7018 vout.$1038.Metal3 vref.P0.GatPoly 6.79811e-06f
Cred_7019 vout.$1038.Metal3 vref.P0.nSD 3.89713e-05f
Cred_7020 vout.$1038.Metal3 vref.P0.pSD 0.000118215f
Cred_7021 vout.$1038.Metal3 vss.$1282.Metal5 0.026002f
Cred_7022 vout.$1040.Metal3 vref 0.0196274f
Cred_7023 vout.$1040.Metal3 vref.P0.GatPoly 0.000765357f
Cred_7024 vout.$1040.Metal3 vref.P0.nSD 0.00438754f
Cred_7025 vout.$1040.Metal3 vref.P0.pSD 0.0244285f
Cred_7026 vout.$1040.Metal3 vss.$1282.Metal5 0.0240774f
Cred_7027 vout.$1042.Metal3 vref 0.00777025f
Cred_7028 vout.$1042.Metal3 vref.P0.GatPoly 0.000302996f
Cred_7029 vout.$1042.Metal3 vref.P0.nSD 0.00173698f
Cred_7030 vout.$1042.Metal3 vref.P0.pSD 0.0102208f
Cred_7031 vout.$1042.Metal3 vss.$1300.Metal5 0.00508524f
Cred_7032 vout.$1050.Metal3 vss 0.00138198f
Cred_7033 vout.$1050.Metal3 vss.$1212.Metal5 0.00142525f
Cred_7034 vout.$1050.Metal3 vss.$1230.Metal5 0.00142525f
Cred_7035 vout.$1050.Metal3 vss.$1282.Metal5 0.00545556f
Cred_7036 vout.$1050.Metal3 vss.$1300.Metal5 0.00545556f
Cred_7037 vout.$1070.Metal3 vss 0.00136439f
Cred_7038 vout.$1070.Metal3 vss.$1212.Metal5 0.00140711f
Cred_7039 vout.$1070.Metal3 vss.$1230.Metal5 0.00140711f
Cred_7040 vout.$1070.Metal3 vss.$1282.Metal5 0.00538613f
Cred_7041 vout.$1070.Metal3 vss.$1300.Metal5 0.00538613f
Cred_7042 vout.$1072.Metal3 vss.$1282.Metal5 0.0262308f
Cred_7043 vout.$1074.Metal3 vref 2.87351e-05f
Cred_7044 vout.$1074.Metal3 vref.P0.GatPoly 1.12051e-06f
Cred_7045 vout.$1074.Metal3 vref.P0.nSD 6.4235e-06f
Cred_7046 vout.$1074.Metal3 vref.P0.pSD 2.06225e-05f
Cred_7047 vout.$1074.Metal3 vss.$1282.Metal5 0.0109389f
Cred_7048 vout.$1076.Metal3 vref 3.8969e-05f
Cred_7049 vout.$1076.Metal3 vref.P0.GatPoly 1.51957e-06f
Cred_7050 vout.$1076.Metal3 vref.P0.nSD 8.71119e-06f
Cred_7051 vout.$1076.Metal3 vref.P0.pSD 2.7967e-05f
Cred_7052 vout.$1076.Metal3 vss.$1282.Metal5 0.00959107f
Cred_7053 vout.$1078.Metal3 vref 6.05245e-05f
Cred_7054 vout.$1078.Metal3 vref.P0.GatPoly 2.36012e-06f
Cred_7055 vout.$1078.Metal3 vref.P0.nSD 1.35298e-05f
Cred_7056 vout.$1078.Metal3 vref.P0.pSD 4.34369e-05f
Cred_7057 vout.$1078.Metal3 vss.$1282.Metal5 0.0109389f
Cred_7058 vout.$1080.Metal3 vref 0.00600484f
Cred_7059 vout.$1080.Metal3 vref.P0.GatPoly 0.000234155f
Cred_7060 vout.$1080.Metal3 vref.P0.nSD 0.00134233f
Cred_7061 vout.$1080.Metal3 vref.P0.pSD 0.00790366f
Cred_7062 vout.$1080.Metal3 vss.$1282.Metal5 0.0105114f
Cred_7063 vout.$1082.Metal3 vref 0.0052237f
Cred_7064 vout.$1082.Metal3 vref.P0.GatPoly 0.000203695f
Cred_7065 vout.$1082.Metal3 vref.P0.nSD 0.00116772f
Cred_7066 vout.$1082.Metal3 vref.P0.pSD 0.00705782f
Cred_7067 vout.$1082.Metal3 vss.$1300.Metal5 0.00409733f
Cred_7068 vout.$1096.Metal3 vss.$1282.Metal5 0.0027497f
Cred_7069 vout.$11.Metal1 vss.$10.Metal1 0.00096978f
Cred_7070 vout.$11.Metal1 vss.$1009.Metal4 4.57101e-08f
Cred_7071 vout.$11.Metal1 vss.$1011.Metal4 4.39354e-07f
Cred_7072 vout.$11.Metal1 vss.$1013.Metal4 1.37826e-07f
Cred_7073 vout.$11.Metal1 vss.$1282.Metal5 3.93181e-05f
Cred_7074 vout.$11.Metal1 vss.$13.Metal1 0.000452931f
Cred_7075 vout.$11.Metal1 vss.$461.Metal2 7.57928e-05f
Cred_7076 vout.$11.Metal1 vss.$463.Metal2 0.0253719f
Cred_7077 vout.$11.Metal1 vss.$467.Metal2 0.0103957f
Cred_7078 vout.$11.Metal1 vss.$469.Metal2 0.0231225f
Cred_7079 vout.$11.Metal1 vss.$799.Metal3 5.66496e-05f
Cred_7080 vout.$11.Metal1 vss.$801.Metal3 1.29179e-06f
Cred_7081 vout.$11.Metal1 vss.$805.Metal3 1.06264e-08f
Cred_7082 vout.$11.Metal1 vss.P0.nSD 1.07939e-05f
Cred_7083 vout.$11.Metal1 vss.P0.pSD 4.12133e-06f
Cred_7084 vout.$11.Metal1 vss.P1.nSD 0.0249385f
Cred_7085 vout.$11.Metal1 vss.P3.nSD 0.0236565f
Cred_7086 vout.$1110.Metal3 vss 0.00180304f
Cred_7087 vout.$1110.Metal3 vss.$1212.Metal5 0.00185949f
Cred_7088 vout.$1110.Metal3 vss.$1230.Metal5 0.00185949f
Cred_7089 vout.$1110.Metal3 vss.$1282.Metal5 0.00711776f
Cred_7090 vout.$1110.Metal3 vss.$1300.Metal5 0.00711776f
Cred_7091 vout.$1112.Metal3 vss.$1282.Metal5 0.0219264f
Cred_7092 vout.$1114.Metal3 vss.$1282.Metal5 0.00134783f
Cred_7093 vout.$1118.Metal3 vss.$1282.Metal5 0.00134783f
Cred_7094 vout.$1122.Metal3 vss.$1300.Metal5 0.000550795f
Cred_7095 vout.$1140.Metal3 vss.$1282.Metal5 0.00079018f
Cred_7096 vout.$1150.Metal3 vss 0.00180304f
Cred_7097 vout.$1150.Metal3 vss.$1212.Metal5 0.00185949f
Cred_7098 vout.$1150.Metal3 vss.$1230.Metal5 0.00185949f
Cred_7099 vout.$1150.Metal3 vss.$1282.Metal5 0.00711776f
Cred_7100 vout.$1150.Metal3 vss.$1300.Metal5 0.00711776f
Cred_7101 vout.$1152.Metal3 vss.$1282.Metal5 0.0400474f
Cred_7102 vout.$1190.Metal3 vss 0.00296396f
Cred_7103 vout.$1190.Metal3 vss.$1212.Metal5 0.00305676f
Cred_7104 vout.$1190.Metal3 vss.$1230.Metal5 0.00305676f
Cred_7105 vout.$1190.Metal3 vss.$1282.Metal5 0.0117006f
Cred_7106 vout.$1190.Metal3 vss.$1300.Metal5 0.0117006f
Cred_7107 vout.$12.Metal1 vss.$1282.Metal5 1.07499e-06f
Cred_7108 vout.$12.Metal1 vss.$13.Metal1 0.00224711f
Cred_7109 vout.$12.Metal1 vss.$467.Metal2 0.00560276f
Cred_7110 vout.$12.Metal1 vss.$469.Metal2 0.0231399f
Cred_7111 vout.$12.Metal1 vss.$473.Metal2 0.0203365f
Cred_7112 vout.$12.Metal1 vss.$475.Metal2 0.00840333f
Cred_7113 vout.$12.Metal1 vss.$805.Metal3 3.04853e-06f
Cred_7114 vout.$12.Metal1 vss.P3.nSD 0.0236558f
Cred_7115 vout.$12.Metal1 vss.P5.nSD 0.0236682f
Cred_7116 vout.$1208.Metal3 vss 0.000105742f
Cred_7117 vout.$1208.Metal3 vss.$1212.Metal5 0.000109052f
Cred_7118 vout.$1208.Metal3 vss.$1230.Metal5 0.000109052f
Cred_7119 vout.$1208.Metal3 vss.$1282.Metal5 0.00041743f
Cred_7120 vout.$1208.Metal3 vss.$1300.Metal5 0.00041743f
Cred_7121 vout.$121.Metal1 vref 2.17423e-08f
Cred_7122 vout.$121.Metal1 vref.P0.GatPoly 8.47826e-10f
Cred_7123 vout.$121.Metal1 vref.P0.nSD 7.079e-09f
Cred_7124 vout.$121.Metal1 vref.P0.pSD 8.51884e-09f
Cred_7125 vout.$121.Metal1 vss.$10.Metal1 5.35628e-05f
Cred_7126 vout.$121.Metal1 vss.$127.Metal1 0.000111478f
Cred_7127 vout.$121.Metal1 vss.$1282.Metal5 6.64258e-05f
Cred_7128 vout.$121.Metal1 vss.$406.Metal1 5.41729e-05f
Cred_7129 vout.$121.Metal1 vss.$457.Metal2 1.62812e-06f
Cred_7130 vout.$121.Metal1 vss.$461.Metal2 6.48762e-05f
Cred_7131 vout.$121.Metal1 vss.$463.Metal2 0.0243474f
Cred_7132 vout.$121.Metal1 vss.$467.Metal2 0.0101014f
Cred_7133 vout.$121.Metal1 vss.$469.Metal2 0.0229293f
Cred_7134 vout.$121.Metal1 vss.$799.Metal3 5.35628e-05f
Cred_7135 vout.$121.Metal1 vss.P0.GatPoly 3.98545e-06f
Cred_7136 vout.$121.Metal1 vss.P0.nSD 1.86055e-05f
Cred_7137 vout.$121.Metal1 vss.P0.pSD 0.00159255f
Cred_7138 vout.$121.Metal1 vss.P1.nSD 0.0247643f
Cred_7139 vout.$121.Metal1 vss.P3.nSD 0.0242862f
Cred_7140 vout.$122.Metal1 vref 1.24187e-07f
Cred_7141 vout.$122.Metal1 vref.P0.GatPoly 4.84259e-09f
Cred_7142 vout.$122.Metal1 vref.P0.nSD 4.03055e-08f
Cred_7143 vout.$122.Metal1 vref.P0.pSD 4.86577e-08f
Cred_7144 vout.$122.Metal1 vss.$127.Metal1 8.63275e-05f
Cred_7145 vout.$122.Metal1 vss.$1282.Metal5 6.65584e-05f
Cred_7146 vout.$122.Metal1 vss.$406.Metal1 7.00767e-05f
Cred_7147 vout.$122.Metal1 vss.$457.Metal2 1.2608e-06f
Cred_7148 vout.$122.Metal1 vss.$467.Metal2 0.00546171f
Cred_7149 vout.$122.Metal1 vss.$469.Metal2 0.0225296f
Cred_7150 vout.$122.Metal1 vss.$473.Metal2 0.0201435f
Cred_7151 vout.$122.Metal1 vss.$475.Metal2 0.00833525f
Cred_7152 vout.$122.Metal1 vss.P0.GatPoly 3.08629e-06f
Cred_7153 vout.$122.Metal1 vss.P0.pSD 0.00160306f
Cred_7154 vout.$122.Metal1 vss.P3.nSD 0.0238566f
Cred_7155 vout.$122.Metal1 vss.P5.nSD 0.0242979f
Cred_7156 vout.$123.Metal1 vref 1.70627e-07f
Cred_7157 vout.$123.Metal1 vref.P0.GatPoly 6.65351e-09f
Cred_7158 vout.$123.Metal1 vref.P0.nSD 5.53714e-08f
Cred_7159 vout.$123.Metal1 vref.P0.pSD 6.68536e-08f
Cred_7160 vout.$123.Metal1 vss.$127.Metal1 8.58415e-05f
Cred_7161 vout.$123.Metal1 vss.$1282.Metal5 4.3343e-05f
Cred_7162 vout.$123.Metal1 vss.$136.Metal1 3.64288e-05f
Cred_7163 vout.$123.Metal1 vss.$406.Metal1 0.000116284f
Cred_7164 vout.$123.Metal1 vss.$457.Metal2 1.2537e-06f
Cred_7165 vout.$123.Metal1 vss.$473.Metal2 0.0197899f
Cred_7166 vout.$123.Metal1 vss.$475.Metal2 0.0112785f
Cred_7167 vout.$123.Metal1 vss.$479.Metal2 0.025319f
Cred_7168 vout.$123.Metal1 vss.$811.Metal3 3.64288e-05f
Cred_7169 vout.$123.Metal1 vss.P0.GatPoly 3.06892e-06f
Cred_7170 vout.$123.Metal1 vss.P0.pSD 0.00205668f
Cred_7171 vout.$123.Metal1 vss.P5.nSD 0.0238672f
Cred_7172 vout.$123.Metal1 vss.P7.nSD 0.0242953f
Cred_7173 vout.$1235.Metal4 vref 0.00187235f
Cred_7174 vout.$1235.Metal4 vref.P0.GatPoly 7.30111e-05f
Cred_7175 vout.$1235.Metal4 vref.P0.nSD 0.000611428f
Cred_7176 vout.$1235.Metal4 vref.P0.pSD 0.000733606f
Cred_7177 vout.$1235.Metal4 vss.$10.Metal1 0.000682196f
Cred_7178 vout.$1235.Metal4 vss.$1009.Metal4 0.0011172f
Cred_7179 vout.$1235.Metal4 vss.$1011.Metal4 0.0107382f
Cred_7180 vout.$1235.Metal4 vss.$1013.Metal4 0.0125139f
Cred_7181 vout.$1235.Metal4 vss.$1015.Metal4 0.0131174f
Cred_7182 vout.$1235.Metal4 vss.$1017.Metal4 0.0104234f
Cred_7183 vout.$1235.Metal4 vss.$127.Metal1 1.14524e-09f
Cred_7184 vout.$1235.Metal4 vss.$1282.Metal5 0.424374f
Cred_7185 vout.$1235.Metal4 vss.$13.Metal1 0.00160914f
Cred_7186 vout.$1235.Metal4 vss.$406.Metal1 9.29656e-10f
Cred_7187 vout.$1235.Metal4 vss.$457.Metal2 1.67261e-11f
Cred_7188 vout.$1235.Metal4 vss.$461.Metal2 0.00236626f
Cred_7189 vout.$1235.Metal4 vss.$463.Metal2 0.00447077f
Cred_7190 vout.$1235.Metal4 vss.$467.Metal2 0.00726964f
Cred_7191 vout.$1235.Metal4 vss.$469.Metal2 0.0218236f
Cred_7192 vout.$1235.Metal4 vss.$473.Metal2 0.0149391f
Cred_7193 vout.$1235.Metal4 vss.$475.Metal2 0.0048729f
Cred_7194 vout.$1235.Metal4 vss.$799.Metal3 5.77855e-05f
Cred_7195 vout.$1235.Metal4 vss.$801.Metal3 0.00671116f
Cred_7196 vout.$1235.Metal4 vss.$805.Metal3 0.00912895f
Cred_7197 vout.$1235.Metal4 vss.$809.Metal3 0.00216216f
Cred_7198 vout.$1235.Metal4 vss.P0.GatPoly 4.09435e-11f
Cred_7199 vout.$1235.Metal4 vss.P0.nSD 0.000364847f
Cred_7200 vout.$1235.Metal4 vss.P0.pSD 3.0553e-06f
Cred_7201 vout.$1235.Metal4 vss.P1.nSD 0.000740894f
Cred_7202 vout.$1235.Metal4 vss.P3.nSD 0.00500128f
Cred_7203 vout.$1235.Metal4 vss.P5.nSD 0.00428303f
Cred_7204 vout.$1236.Metal4 vref 0.00256568f
Cred_7205 vout.$1236.Metal4 vref.P0.GatPoly 0.000100047f
Cred_7206 vout.$1236.Metal4 vref.P0.nSD 0.000837715f
Cred_7207 vout.$1236.Metal4 vref.P0.pSD 0.00100526f
Cred_7208 vout.$1236.Metal4 vss.$1017.Metal4 0.00272623f
Cred_7209 vout.$1236.Metal4 vss.$1019.Metal4 0.0131174f
Cred_7210 vout.$1236.Metal4 vss.$1021.Metal4 0.0131174f
Cred_7211 vout.$1236.Metal4 vss.$1023.Metal4 0.00368804f
Cred_7212 vout.$1236.Metal4 vss.$127.Metal1 1.1388e-09f
Cred_7213 vout.$1236.Metal4 vss.$1282.Metal5 0.28788f
Cred_7214 vout.$1236.Metal4 vss.$13.Metal1 0.000401335f
Cred_7215 vout.$1236.Metal4 vss.$136.Metal1 0.00222583f
Cred_7216 vout.$1236.Metal4 vss.$406.Metal1 1.54265e-09f
Cred_7217 vout.$1236.Metal4 vss.$457.Metal2 1.6632e-11f
Cred_7218 vout.$1236.Metal4 vss.$473.Metal2 0.0119847f
Cred_7219 vout.$1236.Metal4 vss.$475.Metal2 0.0107485f
Cred_7220 vout.$1236.Metal4 vss.$479.Metal2 0.016455f
Cred_7221 vout.$1236.Metal4 vss.$805.Metal3 0.000575173f
Cred_7222 vout.$1236.Metal4 vss.$809.Metal3 0.00650179f
Cred_7223 vout.$1236.Metal4 vss.$811.Metal3 0.00663346f
Cred_7224 vout.$1236.Metal4 vss.$815.Metal3 0.000744344f
Cred_7225 vout.$1236.Metal4 vss.P0.GatPoly 4.0713e-11f
Cred_7226 vout.$1236.Metal4 vss.P0.pSD 3.83106e-06f
Cred_7227 vout.$1236.Metal4 vss.P5.nSD 0.00414696f
Cred_7228 vout.$1236.Metal4 vss.P7.nSD 0.00428432f
Cred_7229 vout.$1237.Metal4 vref 0.00407726f
Cred_7230 vout.$1237.Metal4 vref.P0.GatPoly 0.00015899f
Cred_7231 vout.$1237.Metal4 vref.P0.nSD 0.00133083f
Cred_7232 vout.$1237.Metal4 vref.P0.pSD 0.00159751f
Cred_7233 vout.$1237.Metal4 vss.$1023.Metal4 0.00946083f
Cred_7234 vout.$1237.Metal4 vss.$1025.Metal4 0.0131174f
Cred_7235 vout.$1237.Metal4 vss.$1027.Metal4 0.0101023f
Cred_7236 vout.$1237.Metal4 vss.$127.Metal1 6.88707e-10f
Cred_7237 vout.$1237.Metal4 vss.$1282.Metal5 0.289553f
Cred_7238 vout.$1237.Metal4 vss.$136.Metal1 2.13148e-05f
Cred_7239 vout.$1237.Metal4 vss.$138.Metal1 0.00117931f
Cred_7240 vout.$1237.Metal4 vss.$406.Metal1 1.55468e-09f
Cred_7241 vout.$1237.Metal4 vss.$457.Metal2 1.00585e-11f
Cred_7242 vout.$1237.Metal4 vss.$475.Metal2 0.00180774f
Cred_7243 vout.$1237.Metal4 vss.$479.Metal2 0.0176844f
Cred_7244 vout.$1237.Metal4 vss.$483.Metal2 0.0152484f
Cred_7245 vout.$1237.Metal4 vss.$485.Metal2 0.00446722f
Cred_7246 vout.$1237.Metal4 vss.$811.Metal3 0.00194984f
Cred_7247 vout.$1237.Metal4 vss.$815.Metal3 0.00839423f
Cred_7248 vout.$1237.Metal4 vss.$819.Metal3 0.00206386f
Cred_7249 vout.$1237.Metal4 vss.P0.GatPoly 2.4622e-11f
Cred_7250 vout.$1237.Metal4 vss.P0.pSD 2.11211e-08f
Cred_7251 vout.$1237.Metal4 vss.P10.nSD 0.00428165f
Cred_7252 vout.$1237.Metal4 vss.P7.nSD 0.00414501f
Cred_7253 vout.$1238.Metal4 vref 0.0361297f
Cred_7254 vout.$1238.Metal4 vref.P0.GatPoly 0.00140885f
Cred_7255 vout.$1238.Metal4 vref.P0.nSD 0.0203393f
Cred_7256 vout.$1238.Metal4 vref.P0.pSD 0.014156f
Cred_7257 vout.$1238.Metal4 vss.$1027.Metal4 0.00304697f
Cred_7258 vout.$1238.Metal4 vss.$1029.Metal4 0.0131174f
Cred_7259 vout.$1238.Metal4 vss.$1031.Metal4 0.0131174f
Cred_7260 vout.$1238.Metal4 vss.$1033.Metal4 0.0165383f
Cred_7261 vout.$1238.Metal4 vss.$1037.Metal4 0.00338939f
Cred_7262 vout.$1238.Metal4 vss.$1247.Metal5 0.0389302f
Cred_7263 vout.$1238.Metal4 vss.$127.Metal1 6.87158e-10f
Cred_7264 vout.$1238.Metal4 vss.$1282.Metal5 0.349906f
Cred_7265 vout.$1238.Metal4 vss.$1300.Metal5 0.00899376f
Cred_7266 vout.$1238.Metal4 vss.$138.Metal1 0.00043782f
Cred_7267 vout.$1238.Metal4 vss.$141.Metal1 0.00224225f
Cred_7268 vout.$1238.Metal4 vss.$143.Metal1 1.09851e-05f
Cred_7269 vout.$1238.Metal4 vss.$406.Metal1 2.57923e-09f
Cred_7270 vout.$1238.Metal4 vss.$457.Metal2 1.00358e-11f
Cred_7271 vout.$1238.Metal4 vss.$483.Metal2 0.0124533f
Cred_7272 vout.$1238.Metal4 vss.$485.Metal2 0.0130972f
Cred_7273 vout.$1238.Metal4 vss.$489.Metal2 0.0345824f
Cred_7274 vout.$1238.Metal4 vss.$493.Metal2 0.00877426f
Cred_7275 vout.$1238.Metal4 vss.$495.Metal2 0.00252987f
Cred_7276 vout.$1238.Metal4 vss.$815.Metal3 0.00064284f
Cred_7277 vout.$1238.Metal4 vss.$819.Metal3 0.00652177f
Cred_7278 vout.$1238.Metal4 vss.$821.Metal3 0.00851158f
Cred_7279 vout.$1238.Metal4 vss.$825.Metal3 0.00539397f
Cred_7280 vout.$1238.Metal4 vss.P0.GatPoly 2.45665e-11f
Cred_7281 vout.$1238.Metal4 vss.P0.pSD 4.14862e-06f
Cred_7282 vout.$1238.Metal4 vss.P10.nSD 0.00428913f
Cred_7283 vout.$1238.Metal4 vss.P11.nSD 0.00842087f
Cred_7284 vout.$1238.Metal4 vss.P13.nSD 0.00168644f
Cred_7285 vout.$1239.Metal4 vref 0.00241166f
Cred_7286 vout.$1239.Metal4 vref.P0.GatPoly 9.40413e-05f
Cred_7287 vout.$1239.Metal4 vref.P0.nSD 0.00382028f
Cred_7288 vout.$1239.Metal4 vref.P0.pSD 0.000944914f
Cred_7289 vout.$1239.Metal4 vss.$1033.Metal4 0.00333105f
Cred_7290 vout.$1239.Metal4 vss.$1037.Metal4 0.01648f
Cred_7291 vout.$1239.Metal4 vss.$1039.Metal4 0.0131174f
Cred_7292 vout.$1239.Metal4 vss.$1041.Metal4 0.0131174f
Cred_7293 vout.$1239.Metal4 vss.$1043.Metal4 0.00303939f
Cred_7294 vout.$1239.Metal4 vss.$1247.Metal5 0.0236165f
Cred_7295 vout.$1239.Metal4 vss.$1300.Metal5 0.195042f
Cred_7296 vout.$1239.Metal4 vss.$141.Metal1 1.73406e-07f
Cred_7297 vout.$1239.Metal4 vss.$143.Metal1 0.000658791f
Cred_7298 vout.$1239.Metal4 vss.$146.Metal1 0.00132595f
Cred_7299 vout.$1239.Metal4 vss.$485.Metal2 1.47068e-05f
Cred_7300 vout.$1239.Metal4 vss.$489.Metal2 0.00103862f
Cred_7301 vout.$1239.Metal4 vss.$493.Metal2 0.016437f
Cred_7302 vout.$1239.Metal4 vss.$495.Metal2 0.00959003f
Cred_7303 vout.$1239.Metal4 vss.$499.Metal2 0.0104789f
Cred_7304 vout.$1239.Metal4 vss.$821.Metal3 1.73406e-07f
Cred_7305 vout.$1239.Metal4 vss.$825.Metal3 0.00539328f
Cred_7306 vout.$1239.Metal4 vss.$829.Metal3 0.00844213f
Cred_7307 vout.$1239.Metal4 vss.$831.Metal3 0.00015109f
Cred_7308 vout.$1239.Metal4 vss.P0.pSD 5.89433e-06f
Cred_7309 vout.$1239.Metal4 vss.P11.nSD 2.148e-05f
Cred_7310 vout.$1239.Metal4 vss.P13.nSD 0.0036204f
Cred_7311 vout.$1239.Metal4 vss.P15.nSD 0.00164875f
Cred_7312 vout.$124.Metal1 vref 2.72722e-07f
Cred_7313 vout.$124.Metal1 vref.P0.GatPoly 1.06346e-08f
Cred_7314 vout.$124.Metal1 vref.P0.nSD 8.84796e-08f
Cred_7315 vout.$124.Metal1 vref.P0.pSD 1.06855e-07f
Cred_7316 vout.$124.Metal1 vss.$127.Metal1 5.19142e-05f
Cred_7317 vout.$124.Metal1 vss.$1282.Metal5 5.54062e-05f
Cred_7318 vout.$124.Metal1 vss.$136.Metal1 3.57911e-05f
Cred_7319 vout.$124.Metal1 vss.$406.Metal1 0.000117191f
Cred_7320 vout.$124.Metal1 vss.$457.Metal2 7.582e-07f
Cred_7321 vout.$124.Metal1 vss.$475.Metal2 0.0030355f
Cred_7322 vout.$124.Metal1 vss.$479.Metal2 0.0248758f
Cred_7323 vout.$124.Metal1 vss.$483.Metal2 0.0204059f
Cred_7324 vout.$124.Metal1 vss.$485.Metal2 0.00748215f
Cred_7325 vout.$124.Metal1 vss.$811.Metal3 3.57911e-05f
Cred_7326 vout.$124.Metal1 vss.P0.GatPoly 1.85598e-06f
Cred_7327 vout.$124.Metal1 vss.P0.pSD 0.00159209f
Cred_7328 vout.$124.Metal1 vss.P10.nSD 0.0237824f
Cred_7329 vout.$124.Metal1 vss.P7.nSD 0.023865f
Cred_7330 vout.$1240.Metal4 vss.$1043.Metal4 0.010078f
Cred_7331 vout.$1240.Metal4 vss.$1045.Metal4 0.0131174f
Cred_7332 vout.$1240.Metal4 vss.$1047.Metal4 0.00943809f
Cred_7333 vout.$1240.Metal4 vss.$1300.Metal5 0.150749f
Cred_7334 vout.$1240.Metal4 vss.$146.Metal1 1.89351e-05f
Cred_7335 vout.$1240.Metal4 vss.$148.Metal1 6.63267e-08f
Cred_7336 vout.$1240.Metal4 vss.$150.Metal1 1.52659e-05f
Cred_7337 vout.$1240.Metal4 vss.$495.Metal2 0.00160592f
Cred_7338 vout.$1240.Metal4 vss.$499.Metal2 0.0104716f
Cred_7339 vout.$1240.Metal4 vss.$503.Metal2 0.0106131f
Cred_7340 vout.$1240.Metal4 vss.$507.Metal2 0.00129472f
Cred_7341 vout.$1240.Metal4 vss.$831.Metal3 1.89351e-05f
Cred_7342 vout.$1240.Metal4 vss.$835.Metal3 0.00178487f
Cred_7343 vout.$1240.Metal4 vss.$839.Metal3 1.52659e-05f
Cred_7344 vout.$1240.Metal4 vss.P15.nSD 0.00164678f
Cred_7345 vout.$1240.Metal4 vss.P17.nSD 0.00161154f
Cred_7346 vout.$1241.Metal4 vss.$1047.Metal4 0.00367926f
Cred_7347 vout.$1241.Metal4 vss.$1049.Metal4 0.0131174f
Cred_7348 vout.$1241.Metal4 vss.$1051.Metal4 0.0131174f
Cred_7349 vout.$1241.Metal4 vss.$1053.Metal4 0.0130273f
Cred_7350 vout.$1241.Metal4 vss.$1055.Metal4 0.0130038f
Cred_7351 vout.$1241.Metal4 vss.$1057.Metal4 0.00903921f
Cred_7352 vout.$1241.Metal4 vss.$1300.Metal5 0.213873f
Cred_7353 vout.$1241.Metal4 vss.$150.Metal1 1.07775e-05f
Cred_7354 vout.$1241.Metal4 vss.$153.Metal1 1.27197e-08f
Cred_7355 vout.$1241.Metal4 vss.$503.Metal2 0.00748583f
Cred_7356 vout.$1241.Metal4 vss.$507.Metal2 0.00594677f
Cred_7357 vout.$1241.Metal4 vss.$509.Metal2 0.0121625f
Cred_7358 vout.$1241.Metal4 vss.$513.Metal2 0.00618628f
Cred_7359 vout.$1241.Metal4 vss.$515.Metal2 0.00149957f
Cred_7360 vout.$1241.Metal4 vss.$839.Metal3 4.17138e-05f
Cred_7361 vout.$1241.Metal4 vss.$841.Metal3 2.28686e-05f
Cred_7362 vout.$1241.Metal4 vss.$845.Metal3 0.00154698f
Cred_7363 vout.$1241.Metal4 vss.P17.nSD 0.000979355f
Cred_7364 vout.$1241.Metal4 vss.P19.nSD 0.00202347f
Cred_7365 vout.$1241.Metal4 vss.P21.nSD 0.000857951f
Cred_7366 vout.$125.Metal1 vref 1.01999e-05f
Cred_7367 vout.$125.Metal1 vref.P0.GatPoly 3.97738e-07f
Cred_7368 vout.$125.Metal1 vref.P0.nSD 8.12609e-06f
Cred_7369 vout.$125.Metal1 vref.P0.pSD 3.99641e-06f
Cred_7370 vout.$125.Metal1 vss.$1033.Metal4 1.7771e-10f
Cred_7371 vout.$125.Metal1 vss.$1037.Metal4 1.7771e-10f
Cred_7372 vout.$125.Metal1 vss.$1247.Metal5 4.66465e-08f
Cred_7373 vout.$125.Metal1 vss.$127.Metal1 5.17974e-05f
Cred_7374 vout.$125.Metal1 vss.$1282.Metal5 5.43425e-05f
Cred_7375 vout.$125.Metal1 vss.$141.Metal1 3.90117e-05f
Cred_7376 vout.$125.Metal1 vss.$406.Metal1 0.00019442f
Cred_7377 vout.$125.Metal1 vss.$457.Metal2 7.56494e-07f
Cred_7378 vout.$125.Metal1 vss.$483.Metal2 0.0209101f
Cred_7379 vout.$125.Metal1 vss.$485.Metal2 0.0109757f
Cred_7380 vout.$125.Metal1 vss.$489.Metal2 0.0240641f
Cred_7381 vout.$125.Metal1 vss.$821.Metal3 3.90117e-05f
Cred_7382 vout.$125.Metal1 vss.$825.Metal3 2.09535e-12f
Cred_7383 vout.$125.Metal1 vss.P0.GatPoly 1.85181e-06f
Cred_7384 vout.$125.Metal1 vss.P0.pSD 0.0020143f
Cred_7385 vout.$125.Metal1 vss.P10.nSD 0.0243788f
Cred_7386 vout.$125.Metal1 vss.P11.nSD 0.0234159f
Cred_7387 vout.$1252.Metal4 vss 0.00150611f
Cred_7388 vout.$1252.Metal4 vss.$1057.Metal4 0.00398417f
Cred_7389 vout.$1252.Metal4 vss.$1059.Metal4 0.0127121f
Cred_7390 vout.$1252.Metal4 vss.$1061.Metal4 0.00132255f
Cred_7391 vout.$1252.Metal4 vss.$1212.Metal5 0.00155326f
Cred_7392 vout.$1252.Metal4 vss.$1230.Metal5 0.00155326f
Cred_7393 vout.$1252.Metal4 vss.$1282.Metal5 0.00594558f
Cred_7394 vout.$1252.Metal4 vss.$1300.Metal5 0.153684f
Cred_7395 vout.$1252.Metal4 vss.$150.Metal1 4.88251e-07f
Cred_7396 vout.$1252.Metal4 vss.$153.Metal1 1.26846e-09f
Cred_7397 vout.$1252.Metal4 vss.$156.Metal1 1.01e-05f
Cred_7398 vout.$1252.Metal4 vss.$503.Metal2 0.000339347f
Cred_7399 vout.$1252.Metal4 vss.$507.Metal2 0.000576758f
Cred_7400 vout.$1252.Metal4 vss.$509.Metal2 0.00129376f
Cred_7401 vout.$1252.Metal4 vss.$513.Metal2 0.00792172f
Cred_7402 vout.$1252.Metal4 vss.$515.Metal2 0.00277749f
Cred_7403 vout.$1252.Metal4 vss.$519.Metal2 0.00483678f
Cred_7404 vout.$1252.Metal4 vss.$521.Metal2 0.00315154f
Cred_7405 vout.$1252.Metal4 vss.$839.Metal3 4.88251e-07f
Cred_7406 vout.$1252.Metal4 vss.$849.Metal3 3.3504e-05f
Cred_7407 vout.$1252.Metal4 vss.$851.Metal3 3.01998e-05f
Cred_7408 vout.$1252.Metal4 vss.P0.pSD 1.1542e-11f
Cred_7409 vout.$1252.Metal4 vss.P17.nSD 6.36749e-05f
Cred_7410 vout.$1252.Metal4 vss.P19.nSD 0.000305303f
Cred_7411 vout.$1252.Metal4 vss.P21.nSD 0.00126713f
Cred_7412 vout.$1252.Metal4 vss.P23.nSD 0.000768023f
Cred_7413 vout.$1252.Metal4 vss.P25.nSD 0.000481743f
Cred_7414 vout.$126.Metal1 vref 1.57878e-06f
Cred_7415 vout.$126.Metal1 vref.P0.GatPoly 6.15635e-08f
Cred_7416 vout.$126.Metal1 vref.P0.nSD 1.29088e-06f
Cred_7417 vout.$126.Metal1 vref.P0.pSD 6.18582e-07f
Cred_7418 vout.$126.Metal1 vss.$127.Metal1 2.46725e-05f
Cred_7419 vout.$126.Metal1 vss.$1300.Metal5 6.78356e-07f
Cred_7420 vout.$126.Metal1 vss.$146.Metal1 4.41127e-05f
Cred_7421 vout.$126.Metal1 vss.$406.Metal1 0.000245069f
Cred_7422 vout.$126.Metal1 vss.$457.Metal2 3.60339e-07f
Cred_7423 vout.$126.Metal1 vss.$493.Metal2 0.022129f
Cred_7424 vout.$126.Metal1 vss.$495.Metal2 0.0108797f
Cred_7425 vout.$126.Metal1 vss.$499.Metal2 0.0243888f
Cred_7426 vout.$126.Metal1 vss.$831.Metal3 4.41127e-05f
Cred_7427 vout.$126.Metal1 vss.P0.GatPoly 8.82067e-07f
Cred_7428 vout.$126.Metal1 vss.P0.pSD 0.00149283f
Cred_7429 vout.$126.Metal1 vss.P13.nSD 0.0249628f
Cred_7430 vout.$126.Metal1 vss.P15.nSD 0.0240867f
Cred_7431 vout.$1261.Metal4 vss 0.00158075f
Cred_7432 vout.$1261.Metal4 vss.$1212.Metal5 0.00163024f
Cred_7433 vout.$1261.Metal4 vss.$1230.Metal5 0.00163024f
Cred_7434 vout.$1261.Metal4 vss.$1282.Metal5 0.00624022f
Cred_7435 vout.$1261.Metal4 vss.$1300.Metal5 0.0816548f
Cred_7436 vout.$1261.Metal4 vss.$150.Metal1 1.92903e-06f
Cred_7437 vout.$1261.Metal4 vss.$156.Metal1 2.0967e-06f
Cred_7438 vout.$1261.Metal4 vss.$503.Metal2 0.00134073f
Cred_7439 vout.$1261.Metal4 vss.$507.Metal2 0.00121783f
Cred_7440 vout.$1261.Metal4 vss.$509.Metal2 0.00254772f
Cred_7441 vout.$1261.Metal4 vss.$513.Metal2 0.00292267f
Cred_7442 vout.$1261.Metal4 vss.$515.Metal2 0.000886349f
Cred_7443 vout.$1261.Metal4 vss.$519.Metal2 0.00102507f
Cred_7444 vout.$1261.Metal4 vss.$521.Metal2 0.000914579f
Cred_7445 vout.$1261.Metal4 vss.$839.Metal3 1.92903e-06f
Cred_7446 vout.$1261.Metal4 vss.$851.Metal3 2.0967e-06f
Cred_7447 vout.$1261.Metal4 vss.P17.nSD 0.000288534f
Cred_7448 vout.$1261.Metal4 vss.P19.nSD 0.00070594f
Cred_7449 vout.$1261.Metal4 vss.P21.nSD 0.000709965f
Cred_7450 vout.$1261.Metal4 vss.P23.nSD 0.000223056f
Cred_7451 vout.$1261.Metal4 vss.P25.nSD 0.000192107f
Cred_7452 vout.$1264.Metal4 vref 0.000522936f
Cred_7453 vout.$1264.Metal4 vref.P0.GatPoly 2.03916e-05f
Cred_7454 vout.$1264.Metal4 vref.P0.nSD 0.000170262f
Cred_7455 vout.$1264.Metal4 vref.P0.pSD 0.000204892f
Cred_7456 vout.$1264.Metal4 vss.$10.Metal1 8.94949e-05f
Cred_7457 vout.$1264.Metal4 vss.$1009.Metal4 0.000137147f
Cred_7458 vout.$1264.Metal4 vss.$1011.Metal4 0.00131822f
Cred_7459 vout.$1264.Metal4 vss.$1013.Metal4 0.000414171f
Cred_7460 vout.$1264.Metal4 vss.$127.Metal1 7.95633e-10f
Cred_7461 vout.$1264.Metal4 vss.$1282.Metal5 0.185253f
Cred_7462 vout.$1264.Metal4 vss.$13.Metal1 4.09326e-05f
Cred_7463 vout.$1264.Metal4 vss.$406.Metal1 3.86639e-10f
Cred_7464 vout.$1264.Metal4 vss.$457.Metal2 1.16201e-11f
Cred_7465 vout.$1264.Metal4 vss.$461.Metal2 0.00151722f
Cred_7466 vout.$1264.Metal4 vss.$463.Metal2 0.00325834f
Cred_7467 vout.$1264.Metal4 vss.$467.Metal2 0.00192338f
Cred_7468 vout.$1264.Metal4 vss.$469.Metal2 0.00458018f
Cred_7469 vout.$1264.Metal4 vss.$799.Metal3 1.28426e-05f
Cred_7470 vout.$1264.Metal4 vss.$801.Metal3 0.00059542f
Cred_7471 vout.$1264.Metal4 vss.$805.Metal3 8.64333e-05f
Cred_7472 vout.$1264.Metal4 vss.P0.GatPoly 2.84447e-11f
Cred_7473 vout.$1264.Metal4 vss.P0.nSD 0.000328884f
Cred_7474 vout.$1264.Metal4 vss.P0.pSD 3.83822e-07f
Cred_7475 vout.$1264.Metal4 vss.P1.nSD 0.00082195f
Cred_7476 vout.$1264.Metal4 vss.P3.nSD 0.00125618f
Cred_7477 vout.$1269.Metal4 vref 0.0101683f
Cred_7478 vout.$1269.Metal4 vref.P0.GatPoly 0.000396507f
Cred_7479 vout.$1269.Metal4 vref.P0.nSD 0.00336968f
Cred_7480 vout.$1269.Metal4 vref.P0.pSD 0.00398405f
Cred_7481 vout.$1269.Metal4 vss 0.00156985f
Cred_7482 vout.$1269.Metal4 vss.$1033.Metal4 4.94627e-05f
Cred_7483 vout.$1269.Metal4 vss.$1037.Metal4 4.94627e-05f
Cred_7484 vout.$1269.Metal4 vss.$1043.Metal4 3.78175e-05f
Cred_7485 vout.$1269.Metal4 vss.$1047.Metal4 3.73448e-05f
Cred_7486 vout.$1269.Metal4 vss.$1053.Metal4 3.81787e-05f
Cred_7487 vout.$1269.Metal4 vss.$1057.Metal4 3.73448e-05f
Cred_7488 vout.$1269.Metal4 vss.$1212.Metal5 0.001619f
Cred_7489 vout.$1269.Metal4 vss.$1230.Metal5 0.001619f
Cred_7490 vout.$1269.Metal4 vss.$1247.Metal5 0.0129833f
Cred_7491 vout.$1269.Metal4 vss.$1282.Metal5 0.00619718f
Cred_7492 vout.$1269.Metal4 vss.$1300.Metal5 0.174887f
Cred_7493 vout.$1269.Metal4 vss.$146.Metal1 0.00333845f
Cred_7494 vout.$1269.Metal4 vss.$148.Metal1 0.0026148f
Cred_7495 vout.$1269.Metal4 vss.$150.Metal1 0.00546665f
Cred_7496 vout.$1269.Metal4 vss.$153.Metal1 0.00475053f
Cred_7497 vout.$1269.Metal4 vss.$156.Metal1 0.00210931f
Cred_7498 vout.$1269.Metal4 vss.$493.Metal2 0.00325049f
Cred_7499 vout.$1269.Metal4 vss.$495.Metal2 0.00300598f
Cred_7500 vout.$1269.Metal4 vss.$499.Metal2 0.00804672f
Cred_7501 vout.$1269.Metal4 vss.$503.Metal2 0.00780826f
Cred_7502 vout.$1269.Metal4 vss.$507.Metal2 0.00595286f
Cred_7503 vout.$1269.Metal4 vss.$509.Metal2 0.00622453f
Cred_7504 vout.$1269.Metal4 vss.$513.Metal2 0.00595707f
Cred_7505 vout.$1269.Metal4 vss.$515.Metal2 0.0037214f
Cred_7506 vout.$1269.Metal4 vss.$519.Metal2 0.000866273f
Cred_7507 vout.$1269.Metal4 vss.$521.Metal2 0.000780725f
Cred_7508 vout.$1269.Metal4 vss.$825.Metal3 5.83208e-07f
Cred_7509 vout.$1269.Metal4 vss.$831.Metal3 0.00900875f
Cred_7510 vout.$1269.Metal4 vss.$835.Metal3 0.00947209f
Cred_7511 vout.$1269.Metal4 vss.$839.Metal3 0.00872364f
Cred_7512 vout.$1269.Metal4 vss.$841.Metal3 0.00917856f
Cred_7513 vout.$1269.Metal4 vss.$845.Metal3 0.00950272f
Cred_7514 vout.$1269.Metal4 vss.$849.Metal3 0.00853993f
Cred_7515 vout.$1269.Metal4 vss.$851.Metal3 1.77053e-06f
Cred_7516 vout.$1269.Metal4 vss.P0.pSD 2.76792e-05f
Cred_7517 vout.$1269.Metal4 vss.P13.nSD 0.00264046f
Cred_7518 vout.$1269.Metal4 vss.P15.nSD 0.000738844f
Cred_7519 vout.$1269.Metal4 vss.P17.nSD 0.000737198f
Cred_7520 vout.$1269.Metal4 vss.P19.nSD 0.000734999f
Cred_7521 vout.$1269.Metal4 vss.P21.nSD 0.000733685f
Cred_7522 vout.$1269.Metal4 vss.P23.nSD 0.000211131f
Cred_7523 vout.$1269.Metal4 vss.P25.nSD 0.000183979f
Cred_7524 vout.$127.Metal1 vss.$127.Metal1 1.88449e-05f
Cred_7525 vout.$127.Metal1 vss.$146.Metal1 4.41215e-05f
Cred_7526 vout.$127.Metal1 vss.$150.Metal1 3.61027e-05f
Cred_7527 vout.$127.Metal1 vss.$406.Metal1 0.000314264f
Cred_7528 vout.$127.Metal1 vss.$457.Metal2 2.75227e-07f
Cred_7529 vout.$127.Metal1 vss.$495.Metal2 0.00374201f
Cred_7530 vout.$127.Metal1 vss.$499.Metal2 0.0243936f
Cred_7531 vout.$127.Metal1 vss.$503.Metal2 0.0250923f
Cred_7532 vout.$127.Metal1 vss.$507.Metal2 0.00306192f
Cred_7533 vout.$127.Metal1 vss.$831.Metal3 4.41215e-05f
Cred_7534 vout.$127.Metal1 vss.$839.Metal3 3.61027e-05f
Cred_7535 vout.$127.Metal1 vss.P0.GatPoly 6.73722e-07f
Cred_7536 vout.$127.Metal1 vss.P0.pSD 0.00142975f
Cred_7537 vout.$127.Metal1 vss.P15.nSD 0.0240882f
Cred_7538 vout.$127.Metal1 vss.P17.nSD 0.0240786f
Cred_7539 vout.$1279.Metal4 vref 0.00615186f
Cred_7540 vout.$1279.Metal4 vref.P0.GatPoly 0.000239888f
Cred_7541 vout.$1279.Metal4 vref.P0.nSD 0.00208043f
Cred_7542 vout.$1279.Metal4 vref.P0.pSD 0.00241036f
Cred_7543 vout.$1279.Metal4 vss 0.00158117f
Cred_7544 vout.$1279.Metal4 vss.$1033.Metal4 5.09395e-06f
Cred_7545 vout.$1279.Metal4 vss.$1037.Metal4 5.09395e-06f
Cred_7546 vout.$1279.Metal4 vss.$1212.Metal5 0.00163067f
Cred_7547 vout.$1279.Metal4 vss.$1230.Metal5 0.00163067f
Cred_7548 vout.$1279.Metal4 vss.$1247.Metal5 0.00133709f
Cred_7549 vout.$1279.Metal4 vss.$1282.Metal5 0.00624187f
Cred_7550 vout.$1279.Metal4 vss.$1300.Metal5 0.141967f
Cred_7551 vout.$1279.Metal4 vss.$146.Metal1 4.97445e-06f
Cred_7552 vout.$1279.Metal4 vss.$150.Metal1 4.07118e-06f
Cred_7553 vout.$1279.Metal4 vss.$156.Metal1 1.55211e-06f
Cred_7554 vout.$1279.Metal4 vss.$493.Metal2 0.000642029f
Cred_7555 vout.$1279.Metal4 vss.$495.Metal2 0.000628997f
Cred_7556 vout.$1279.Metal4 vss.$499.Metal2 0.00275025f
Cred_7557 vout.$1279.Metal4 vss.$503.Metal2 0.00282958f
Cred_7558 vout.$1279.Metal4 vss.$507.Metal2 0.00127681f
Cred_7559 vout.$1279.Metal4 vss.$509.Metal2 0.00225118f
Cred_7560 vout.$1279.Metal4 vss.$513.Metal2 0.00255587f
Cred_7561 vout.$1279.Metal4 vss.$515.Metal2 0.000751242f
Cred_7562 vout.$1279.Metal4 vss.$519.Metal2 0.000706223f
Cred_7563 vout.$1279.Metal4 vss.$521.Metal2 1.07446e-05f
Cred_7564 vout.$1279.Metal4 vss.$825.Metal3 6.0062e-08f
Cred_7565 vout.$1279.Metal4 vss.$831.Metal3 4.97445e-06f
Cred_7566 vout.$1279.Metal4 vss.$839.Metal3 4.07118e-06f
Cred_7567 vout.$1279.Metal4 vss.$851.Metal3 1.55211e-06f
Cred_7568 vout.$1279.Metal4 vss.P13.nSD 0.000206398f
Cred_7569 vout.$1279.Metal4 vss.P15.nSD 0.000774941f
Cred_7570 vout.$1279.Metal4 vss.P17.nSD 0.000774022f
Cred_7571 vout.$1279.Metal4 vss.P19.nSD 0.000774319f
Cred_7572 vout.$1279.Metal4 vss.P21.nSD 0.00077101f
Cred_7573 vout.$1279.Metal4 vss.P23.nSD 0.000204877f
Cred_7574 vout.$1279.Metal4 vss.P25.nSD 2.80465e-06f
Cred_7575 vout.$128.Metal1 vss.$127.Metal1 1.4267e-05f
Cred_7576 vout.$128.Metal1 vss.$150.Metal1 3.61098e-05f
Cred_7577 vout.$128.Metal1 vss.$406.Metal1 0.000404303f
Cred_7578 vout.$128.Metal1 vss.$457.Metal2 2.08368e-07f
Cred_7579 vout.$128.Metal1 vss.$503.Metal2 0.0250973f
Cred_7580 vout.$128.Metal1 vss.$507.Metal2 0.0113232f
Cred_7581 vout.$128.Metal1 vss.$509.Metal2 0.0199632f
Cred_7582 vout.$128.Metal1 vss.$839.Metal3 3.61098e-05f
Cred_7583 vout.$128.Metal1 vss.P0.GatPoly 5.1006e-07f
Cred_7584 vout.$128.Metal1 vss.P0.pSD 0.00134452f
Cred_7585 vout.$128.Metal1 vss.P17.nSD 0.0240801f
Cred_7586 vout.$128.Metal1 vss.P19.nSD 0.0240812f
Cred_7587 vout.$1289.Metal4 vref 0.00788594f
Cred_7588 vout.$1289.Metal4 vref.P0.GatPoly 0.000307507f
Cred_7589 vout.$1289.Metal4 vref.P0.nSD 0.00256756f
Cred_7590 vout.$1289.Metal4 vref.P0.pSD 0.00308979f
Cred_7591 vout.$1289.Metal4 vss 0.00156985f
Cred_7592 vout.$1289.Metal4 vss.$1212.Metal5 0.001619f
Cred_7593 vout.$1289.Metal4 vss.$1230.Metal5 0.001619f
Cred_7594 vout.$1289.Metal4 vss.$1282.Metal5 0.00619718f
Cred_7595 vout.$1289.Metal4 vss.$1300.Metal5 0.143993f
Cred_7596 vout.$1289.Metal4 vss.$146.Metal1 4.82935e-06f
Cred_7597 vout.$1289.Metal4 vss.$150.Metal1 3.95243e-06f
Cred_7598 vout.$1289.Metal4 vss.$156.Metal1 1.49166e-06f
Cred_7599 vout.$1289.Metal4 vss.$493.Metal2 0.000610863f
Cred_7600 vout.$1289.Metal4 vss.$495.Metal2 0.000606637f
Cred_7601 vout.$1289.Metal4 vss.$499.Metal2 0.00267003f
Cred_7602 vout.$1289.Metal4 vss.$503.Metal2 0.00274704f
Cred_7603 vout.$1289.Metal4 vss.$507.Metal2 0.00123956f
Cred_7604 vout.$1289.Metal4 vss.$509.Metal2 0.00218552f
Cred_7605 vout.$1289.Metal4 vss.$513.Metal2 0.00248795f
Cred_7606 vout.$1289.Metal4 vss.$515.Metal2 0.000729649f
Cred_7607 vout.$1289.Metal4 vss.$519.Metal2 0.000677903f
Cred_7608 vout.$1289.Metal4 vss.$831.Metal3 4.82935e-06f
Cred_7609 vout.$1289.Metal4 vss.$839.Metal3 3.95243e-06f
Cred_7610 vout.$1289.Metal4 vss.$851.Metal3 1.49166e-06f
Cred_7611 vout.$1289.Metal4 vss.P13.nSD 0.000209245f
Cred_7612 vout.$1289.Metal4 vss.P15.nSD 0.00080155f
Cred_7613 vout.$1289.Metal4 vss.P17.nSD 0.000800659f
Cred_7614 vout.$1289.Metal4 vss.P19.nSD 0.000800947f
Cred_7615 vout.$1289.Metal4 vss.P21.nSD 0.000799734f
Cred_7616 vout.$1289.Metal4 vss.P23.nSD 0.000209764f
Cred_7617 vout.$129.Metal1 vss.$127.Metal1 1.06354e-05f
Cred_7618 vout.$129.Metal1 vss.$406.Metal1 0.000521156f
Cred_7619 vout.$129.Metal1 vss.$457.Metal2 1.55329e-07f
Cred_7620 vout.$129.Metal1 vss.$507.Metal2 0.00826227f
Cred_7621 vout.$129.Metal1 vss.$509.Metal2 0.0199671f
Cred_7622 vout.$129.Metal1 vss.$513.Metal2 0.022569f
Cred_7623 vout.$129.Metal1 vss.$515.Metal2 0.00547127f
Cred_7624 vout.$129.Metal1 vss.P0.GatPoly 3.80227e-07f
Cred_7625 vout.$129.Metal1 vss.P0.pSD 0.00123148f
Cred_7626 vout.$129.Metal1 vss.P19.nSD 0.0240827f
Cred_7627 vout.$129.Metal1 vss.P21.nSD 0.0239026f
Cred_7628 vout.$1299.Metal4 vref 0.248702f
Cred_7629 vout.$1299.Metal4 vref.P0.GatPoly 0.00887489f
Cred_7630 vout.$1299.Metal4 vref.P0.nSD 0.0279912f
Cred_7631 vout.$1299.Metal4 vref.P0.pSD 0.0391556f
Cred_7632 vout.$1299.Metal4 vss 0.016156f
Cred_7633 vout.$1299.Metal4 vss.$1212.Metal5 0.0166618f
Cred_7634 vout.$1299.Metal4 vss.$1230.Metal5 0.0166618f
Cred_7635 vout.$1299.Metal4 vss.$127.Metal1 0.000373521f
Cred_7636 vout.$1299.Metal4 vss.$1282.Metal5 0.0637781f
Cred_7637 vout.$1299.Metal4 vss.$1300.Metal5 1.2108f
Cred_7638 vout.$1299.Metal4 vss.$146.Metal1 6.27124e-06f
Cred_7639 vout.$1299.Metal4 vss.$150.Metal1 5.40134e-06f
Cred_7640 vout.$1299.Metal4 vss.$156.Metal1 8.21252e-08f
Cred_7641 vout.$1299.Metal4 vss.$159.Metal1 0.000625426f
Cred_7642 vout.$1299.Metal4 vss.$406.Metal1 0.0288795f
Cred_7643 vout.$1299.Metal4 vss.$457.Metal2 5.45522e-06f
Cred_7644 vout.$1299.Metal4 vss.$493.Metal2 4.0683e-05f
Cred_7645 vout.$1299.Metal4 vss.$495.Metal2 0.000544997f
Cred_7646 vout.$1299.Metal4 vss.$499.Metal2 0.00346721f
Cred_7647 vout.$1299.Metal4 vss.$503.Metal2 0.00375408f
Cred_7648 vout.$1299.Metal4 vss.$507.Metal2 0.00169397f
Cred_7649 vout.$1299.Metal4 vss.$509.Metal2 0.00298671f
Cred_7650 vout.$1299.Metal4 vss.$513.Metal2 0.00339279f
Cred_7651 vout.$1299.Metal4 vss.$515.Metal2 0.000829459f
Cred_7652 vout.$1299.Metal4 vss.$519.Metal2 0.00049772f
Cred_7653 vout.$1299.Metal4 vss.$521.Metal2 0.00583169f
Cred_7654 vout.$1299.Metal4 vss.$525.Metal2 9.13426e-06f
Cred_7655 vout.$1299.Metal4 vss.$831.Metal3 6.27124e-06f
Cred_7656 vout.$1299.Metal4 vss.$839.Metal3 5.40134e-06f
Cred_7657 vout.$1299.Metal4 vss.$851.Metal3 8.21252e-08f
Cred_7658 vout.$1299.Metal4 vss.P0.GatPoly 1.33537e-05f
Cred_7659 vout.$1299.Metal4 vss.P0.pSD 0.0354754f
Cred_7660 vout.$1299.Metal4 vss.P1.GatPoly 0.000434363f
Cred_7661 vout.$1299.Metal4 vss.P13.nSD 1.43784e-05f
Cred_7662 vout.$1299.Metal4 vss.P15.nSD 0.00107305f
Cred_7663 vout.$1299.Metal4 vss.P17.nSD 0.00112804f
Cred_7664 vout.$1299.Metal4 vss.P19.nSD 0.00112843f
Cred_7665 vout.$1299.Metal4 vss.P21.nSD 0.00112438f
Cred_7666 vout.$1299.Metal4 vss.P23.nSD 1.19164e-05f
Cred_7667 vout.$1299.Metal4 vss.P25.nSD 0.00167273f
Cred_7668 vout.$13.Metal1 vss.$1282.Metal5 1.07499e-06f
Cred_7669 vout.$13.Metal1 vss.$136.Metal1 0.00132079f
Cred_7670 vout.$13.Metal1 vss.$473.Metal2 0.020675f
Cred_7671 vout.$13.Metal1 vss.$475.Metal2 0.0117109f
Cred_7672 vout.$13.Metal1 vss.$479.Metal2 0.0255421f
Cred_7673 vout.$13.Metal1 vss.$809.Metal3 1.15294e-06f
Cred_7674 vout.$13.Metal1 vss.$811.Metal3 3.84792e-05f
Cred_7675 vout.$13.Metal1 vss.P5.nSD 0.0241027f
Cred_7676 vout.$13.Metal1 vss.P7.nSD 0.0236656f
Cred_7677 vout.$130.Metal1 vss 3.4768e-07f
Cred_7678 vout.$130.Metal1 vss.$1212.Metal5 3.58565e-07f
Cred_7679 vout.$130.Metal1 vss.$1230.Metal5 3.58565e-07f
Cred_7680 vout.$130.Metal1 vss.$127.Metal1 7.70922e-06f
Cred_7681 vout.$130.Metal1 vss.$1282.Metal5 1.37251e-06f
Cred_7682 vout.$130.Metal1 vss.$1300.Metal5 1.37251e-06f
Cred_7683 vout.$130.Metal1 vss.$156.Metal1 5.0221e-05f
Cred_7684 vout.$130.Metal1 vss.$406.Metal1 0.000672574f
Cred_7685 vout.$130.Metal1 vss.$457.Metal2 1.12592e-07f
Cred_7686 vout.$130.Metal1 vss.$513.Metal2 0.0228867f
Cred_7687 vout.$130.Metal1 vss.$515.Metal2 0.00980762f
Cred_7688 vout.$130.Metal1 vss.$519.Metal2 0.0228286f
Cred_7689 vout.$130.Metal1 vss.$521.Metal2 6.41802e-05f
Cred_7690 vout.$130.Metal1 vss.$851.Metal3 5.0221e-05f
Cred_7691 vout.$130.Metal1 vss.P0.GatPoly 2.75612e-07f
Cred_7692 vout.$130.Metal1 vss.P0.pSD 0.00108314f
Cred_7693 vout.$130.Metal1 vss.P21.nSD 0.0242392f
Cred_7694 vout.$130.Metal1 vss.P23.nSD 0.02321f
Cred_7695 vout.$130.Metal1 vss.P25.nSD 1.84091e-05f
Cred_7696 vout.$1313.Metal4 vref 0.0636012f
Cred_7697 vout.$1313.Metal4 vref.P0.GatPoly 0.00246651f
Cred_7698 vout.$1313.Metal4 vref.P0.nSD 0.0130281f
Cred_7699 vout.$1313.Metal4 vref.P0.pSD 0.0375229f
Cred_7700 vout.$1313.Metal4 vss 0.0609472f
Cred_7701 vout.$1313.Metal4 vss.$1212.Metal5 0.0628553f
Cred_7702 vout.$1313.Metal4 vss.$1230.Metal5 0.0628553f
Cred_7703 vout.$1313.Metal4 vss.$127.Metal1 3.11696e-06f
Cred_7704 vout.$1313.Metal4 vss.$1282.Metal5 0.240597f
Cred_7705 vout.$1313.Metal4 vss.$1300.Metal5 0.582519f
Cred_7706 vout.$1313.Metal4 vss.$406.Metal1 0.000118118f
Cred_7707 vout.$1313.Metal4 vss.$457.Metal2 4.55228e-08f
Cred_7708 vout.$1313.Metal4 vss.P0.GatPoly 1.11434e-07f
Cred_7709 vout.$1313.Metal4 vss.P0.pSD 0.000312157f
Cred_7710 vout.$1323.Metal4 vref 0.00808104f
Cred_7711 vout.$1323.Metal4 vref.P0.GatPoly 0.000315115f
Cred_7712 vout.$1323.Metal4 vref.P0.nSD 0.00180645f
Cred_7713 vout.$1323.Metal4 vref.P0.pSD 0.00539929f
Cred_7714 vout.$1323.Metal4 vss 0.0095273f
Cred_7715 vout.$1323.Metal4 vss.$1212.Metal5 0.00982557f
Cred_7716 vout.$1323.Metal4 vss.$1230.Metal5 0.00982557f
Cred_7717 vout.$1323.Metal4 vss.$1282.Metal5 0.0376103f
Cred_7718 vout.$1323.Metal4 vss.$1300.Metal5 0.076421f
Cred_7719 vout.$1328.Metal4 vref 0.00104261f
Cred_7720 vout.$1328.Metal4 vref.P0.GatPoly 4.06559e-05f
Cred_7721 vout.$1328.Metal4 vref.P0.nSD 0.000233067f
Cred_7722 vout.$1328.Metal4 vref.P0.pSD 0.000703134f
Cred_7723 vout.$1328.Metal4 vss.$1282.Metal5 0.147809f
Cred_7724 vout.$1329.Metal4 vref 0.002812f
Cred_7725 vout.$1329.Metal4 vref.P0.GatPoly 0.000109652f
Cred_7726 vout.$1329.Metal4 vref.P0.nSD 0.0006286f
Cred_7727 vout.$1329.Metal4 vref.P0.pSD 0.00191543f
Cred_7728 vout.$1329.Metal4 vss.$1282.Metal5 0.11449f
Cred_7729 vout.$1330.Metal4 vref 0.00386606f
Cred_7730 vout.$1330.Metal4 vref.P0.GatPoly 0.000150754f
Cred_7731 vout.$1330.Metal4 vref.P0.nSD 0.000864225f
Cred_7732 vout.$1330.Metal4 vref.P0.pSD 0.00263271f
Cred_7733 vout.$1330.Metal4 vss.$1282.Metal5 0.114304f
Cred_7734 vout.$1331.Metal4 vref 0.00618783f
Cred_7735 vout.$1331.Metal4 vref.P0.GatPoly 0.000241291f
Cred_7736 vout.$1331.Metal4 vref.P0.nSD 0.00138324f
Cred_7737 vout.$1331.Metal4 vref.P0.pSD 0.00421138f
Cred_7738 vout.$1331.Metal4 vss.$1282.Metal5 0.114433f
Cred_7739 vout.$1332.Metal4 vref 0.0369575f
Cred_7740 vout.$1332.Metal4 vref.P0.GatPoly 0.00144113f
Cred_7741 vout.$1332.Metal4 vref.P0.nSD 0.00826154f
Cred_7742 vout.$1332.Metal4 vref.P0.pSD 0.0257504f
Cred_7743 vout.$1332.Metal4 vss.$1282.Metal5 0.108979f
Cred_7744 vout.$1333.Metal4 vref 0.0080741f
Cred_7745 vout.$1333.Metal4 vref.P0.GatPoly 0.000314844f
Cred_7746 vout.$1333.Metal4 vref.P0.nSD 0.0018049f
Cred_7747 vout.$1333.Metal4 vref.P0.pSD 0.00551862f
Cred_7748 vout.$1333.Metal4 vss 0.00988921f
Cred_7749 vout.$1333.Metal4 vss.$1212.Metal5 0.0101988f
Cred_7750 vout.$1333.Metal4 vss.$1230.Metal5 0.0101988f
Cred_7751 vout.$1333.Metal4 vss.$1282.Metal5 0.039039f
Cred_7752 vout.$1333.Metal4 vss.$1300.Metal5 0.0740043f
Cred_7753 vout.$1343.Metal4 vref 0.00607135f
Cred_7754 vout.$1343.Metal4 vref.P0.GatPoly 0.000236749f
Cred_7755 vout.$1343.Metal4 vref.P0.nSD 0.0013572f
Cred_7756 vout.$1343.Metal4 vref.P0.pSD 0.00424499f
Cred_7757 vout.$1343.Metal4 vss 0.0102241f
Cred_7758 vout.$1343.Metal4 vss.$1212.Metal5 0.0105442f
Cred_7759 vout.$1343.Metal4 vss.$1230.Metal5 0.0105442f
Cred_7760 vout.$1343.Metal4 vss.$1282.Metal5 0.0403612f
Cred_7761 vout.$1343.Metal4 vss.$1300.Metal5 0.073121f
Cred_7762 vout.$1353.Metal4 vref 0.00605512f
Cred_7763 vout.$1353.Metal4 vref.P0.GatPoly 0.000236116f
Cred_7764 vout.$1353.Metal4 vref.P0.nSD 0.00135357f
Cred_7765 vout.$1353.Metal4 vref.P0.pSD 0.00437099f
Cred_7766 vout.$1353.Metal4 vss 0.0105575f
Cred_7767 vout.$1353.Metal4 vss.$1212.Metal5 0.010888f
Cred_7768 vout.$1353.Metal4 vss.$1230.Metal5 0.010888f
Cred_7769 vout.$1353.Metal4 vss.$1282.Metal5 0.0416772f
Cred_7770 vout.$1353.Metal4 vss.$1300.Metal5 0.0701407f
Cred_7771 vout.$1363.Metal4 vref 0.00542462f
Cred_7772 vout.$1363.Metal4 vref.P0.GatPoly 0.00021153f
Cred_7773 vout.$1363.Metal4 vref.P0.nSD 0.00121263f
Cred_7774 vout.$1363.Metal4 vref.P0.pSD 0.00394651f
Cred_7775 vout.$1363.Metal4 vss 0.0109007f
Cred_7776 vout.$1363.Metal4 vss.$1212.Metal5 0.011242f
Cred_7777 vout.$1363.Metal4 vss.$1230.Metal5 0.011242f
Cred_7778 vout.$1363.Metal4 vss.$1282.Metal5 0.0430321f
Cred_7779 vout.$1363.Metal4 vss.$1300.Metal5 0.0671917f
Cred_7780 vout.$1368.Metal4 vss.$1282.Metal5 0.139707f
Cred_7781 vout.$1369.Metal4 vref 0.000866375f
Cred_7782 vout.$1369.Metal4 vref.P0.GatPoly 3.37838e-05f
Cred_7783 vout.$1369.Metal4 vref.P0.nSD 0.000193671f
Cred_7784 vout.$1369.Metal4 vref.P0.pSD 0.000623148f
Cred_7785 vout.$1369.Metal4 vss.$1282.Metal5 0.267838f
Cred_7786 vout.$1370.Metal4 vref 0.00117493f
Cred_7787 vout.$1370.Metal4 vref.P0.GatPoly 4.58157e-05f
Cred_7788 vout.$1370.Metal4 vref.P0.nSD 0.000262646f
Cred_7789 vout.$1370.Metal4 vref.P0.pSD 0.000845078f
Cred_7790 vout.$1370.Metal4 vss.$1282.Metal5 0.267811f
Cred_7791 vout.$1371.Metal4 vref 0.00182484f
Cred_7792 vout.$1371.Metal4 vref.P0.GatPoly 7.11585e-05f
Cred_7793 vout.$1371.Metal4 vref.P0.nSD 0.000407928f
Cred_7794 vout.$1371.Metal4 vref.P0.pSD 0.00131253f
Cred_7795 vout.$1371.Metal4 vss.$1282.Metal5 0.267838f
Cred_7796 vout.$1372.Metal4 vref 0.0210147f
Cred_7797 vout.$1372.Metal4 vref.P0.GatPoly 0.000819457f
Cred_7798 vout.$1372.Metal4 vref.P0.nSD 0.00469767f
Cred_7799 vout.$1372.Metal4 vref.P0.pSD 0.0286729f
Cred_7800 vout.$1372.Metal4 vss.$1033.Metal4 1.55168e-05f
Cred_7801 vout.$1372.Metal4 vss.$1037.Metal4 1.55168e-05f
Cred_7802 vout.$1372.Metal4 vss.$1247.Metal5 0.00407295f
Cred_7803 vout.$1372.Metal4 vss.$1282.Metal5 0.419021f
Cred_7804 vout.$1372.Metal4 vss.$1300.Metal5 0.0543614f
Cred_7805 vout.$1372.Metal4 vss.$825.Metal3 1.82957e-07f
Cred_7806 vout.$1373.Metal4 vref 0.00735117f
Cred_7807 vout.$1373.Metal4 vref.P0.GatPoly 0.000286654f
Cred_7808 vout.$1373.Metal4 vref.P0.nSD 0.00164329f
Cred_7809 vout.$1373.Metal4 vref.P0.pSD 0.00638606f
Cred_7810 vout.$1373.Metal4 vss 0.0112823f
Cred_7811 vout.$1373.Metal4 vss.$1212.Metal5 0.0116355f
Cred_7812 vout.$1373.Metal4 vss.$1230.Metal5 0.0116355f
Cred_7813 vout.$1373.Metal4 vss.$1282.Metal5 0.0455504f
Cred_7814 vout.$1373.Metal4 vss.$1300.Metal5 0.0975736f
Cred_7815 vout.$1383.Metal4 vref 0.00321129f
Cred_7816 vout.$1383.Metal4 vref.P0.GatPoly 0.000125222f
Cred_7817 vout.$1383.Metal4 vref.P0.nSD 0.000717858f
Cred_7818 vout.$1383.Metal4 vref.P0.pSD 0.00732168f
Cred_7819 vout.$1383.Metal4 vss 0.00949317f
Cred_7820 vout.$1383.Metal4 vss.$1033.Metal4 1.30468e-05f
Cred_7821 vout.$1383.Metal4 vss.$1037.Metal4 1.30468e-05f
Cred_7822 vout.$1383.Metal4 vss.$1212.Metal5 0.00979037f
Cred_7823 vout.$1383.Metal4 vss.$1230.Metal5 0.00979037f
Cred_7824 vout.$1383.Metal4 vss.$1247.Metal5 0.0034246f
Cred_7825 vout.$1383.Metal4 vss.$1282.Metal5 0.0374755f
Cred_7826 vout.$1383.Metal4 vss.$1300.Metal5 0.146708f
Cred_7827 vout.$1383.Metal4 vss.$825.Metal3 1.53833e-07f
Cred_7828 vout.$1384.Metal4 vss 0.0108004f
Cred_7829 vout.$1384.Metal4 vss.$1212.Metal5 0.0111385f
Cred_7830 vout.$1384.Metal4 vss.$1230.Metal5 0.0111385f
Cred_7831 vout.$1384.Metal4 vss.$1282.Metal5 0.0426358f
Cred_7832 vout.$1384.Metal4 vss.$1300.Metal5 0.0426358f
Cred_7833 vout.$1394.Metal4 vss 0.0129954f
Cred_7834 vout.$1394.Metal4 vss.$1212.Metal5 0.0134022f
Cred_7835 vout.$1394.Metal4 vss.$1230.Metal5 0.0134022f
Cred_7836 vout.$1394.Metal4 vss.$1282.Metal5 0.0513011f
Cred_7837 vout.$1394.Metal4 vss.$1300.Metal5 0.0513011f
Cred_7838 vout.$1395.Metal4 vss 0.00822581f
Cred_7839 vout.$1395.Metal4 vss.$1212.Metal5 0.00848334f
Cred_7840 vout.$1395.Metal4 vss.$1230.Metal5 0.00848334f
Cred_7841 vout.$1395.Metal4 vss.$1282.Metal5 0.0324725f
Cred_7842 vout.$1395.Metal4 vss.$1300.Metal5 0.0324725f
Cred_7843 vout.$14.Metal1 vss.$1282.Metal5 1.07499e-06f
Cred_7844 vout.$14.Metal1 vss.$136.Metal1 3.67155e-05f
Cred_7845 vout.$14.Metal1 vss.$138.Metal1 0.00224711f
Cred_7846 vout.$14.Metal1 vss.$475.Metal2 0.0031139f
Cred_7847 vout.$14.Metal1 vss.$479.Metal2 0.0255467f
Cred_7848 vout.$14.Metal1 vss.$483.Metal2 0.0210386f
Cred_7849 vout.$14.Metal1 vss.$485.Metal2 0.0077037f
Cred_7850 vout.$14.Metal1 vss.$811.Metal3 3.67155e-05f
Cred_7851 vout.$14.Metal1 vss.$815.Metal3 3.04853e-06f
Cred_7852 vout.$14.Metal1 vss.P10.nSD 0.0236658f
Cred_7853 vout.$14.Metal1 vss.P7.nSD 0.0236644f
Cred_7854 vout.$1405.Metal4 vss 0.00823476f
Cred_7855 vout.$1405.Metal4 vss.$1212.Metal5 0.00849257f
Cred_7856 vout.$1405.Metal4 vss.$1230.Metal5 0.00849257f
Cred_7857 vout.$1405.Metal4 vss.$1282.Metal5 0.0325078f
Cred_7858 vout.$1405.Metal4 vss.$1300.Metal5 0.0325078f
Cred_7859 vout.$1408.Metal4 vss.$1282.Metal5 0.159597f
Cred_7860 vout.$1415.Metal4 vss 0.013056f
Cred_7861 vout.$1415.Metal4 vss.$1212.Metal5 0.0134648f
Cred_7862 vout.$1415.Metal4 vss.$1230.Metal5 0.0134648f
Cred_7863 vout.$1415.Metal4 vss.$1282.Metal5 0.0515404f
Cred_7864 vout.$1415.Metal4 vss.$1300.Metal5 0.0515404f
Cred_7865 vout.$1416.Metal4 vss 0.0117306f
Cred_7866 vout.$1416.Metal4 vss.$1212.Metal5 0.0120978f
Cred_7867 vout.$1416.Metal4 vss.$1230.Metal5 0.0120978f
Cred_7868 vout.$1416.Metal4 vss.$1282.Metal5 0.0463081f
Cred_7869 vout.$1416.Metal4 vss.$1300.Metal5 0.0463081f
Cred_7870 vout.$15.Metal1 vss.$1282.Metal5 1.07499e-06f
Cred_7871 vout.$15.Metal1 vss.$138.Metal1 0.000348383f
Cred_7872 vout.$15.Metal1 vss.$141.Metal1 0.00191928f
Cred_7873 vout.$15.Metal1 vss.$483.Metal2 0.0210091f
Cred_7874 vout.$15.Metal1 vss.$485.Metal2 0.0110904f
Cred_7875 vout.$15.Metal1 vss.$489.Metal2 0.0242807f
Cred_7876 vout.$15.Metal1 vss.$493.Metal2 3.67898e-05f
Cred_7877 vout.$15.Metal1 vss.$495.Metal2 1.18677e-05f
Cred_7878 vout.$15.Metal1 vss.$819.Metal3 1.28858e-06f
Cred_7879 vout.$15.Metal1 vss.$821.Metal3 4.09391e-05f
Cred_7880 vout.$15.Metal1 vss.P0.pSD 3.27988e-06f
Cred_7881 vout.$15.Metal1 vss.P10.nSD 0.0236647f
Cred_7882 vout.$15.Metal1 vss.P11.nSD 0.0228013f
Cred_7883 vout.$15.Metal1 vss.P13.nSD 6.49687e-06f
Cred_7884 vout.$156.Metal1 vref 1.62939e-08f
Cred_7885 vout.$156.Metal1 vref.P0.GatPoly 6.35371e-10f
Cred_7886 vout.$156.Metal1 vref.P0.nSD 3.64237e-09f
Cred_7887 vout.$156.Metal1 vref.P0.pSD 1.08867e-08f
Cred_7888 vout.$156.Metal1 vss.$1282.Metal5 8.08919e-05f
Cred_7889 vout.$157.Metal1 vref 5.1071e-08f
Cred_7890 vout.$157.Metal1 vref.P0.GatPoly 1.99148e-09f
Cred_7891 vout.$157.Metal1 vref.P0.nSD 1.14165e-08f
Cred_7892 vout.$157.Metal1 vref.P0.pSD 3.36562e-08f
Cred_7893 vout.$157.Metal1 vss.$1282.Metal5 6.73255e-05f
Cred_7894 vout.$158.Metal1 vref 7.0662e-08f
Cred_7895 vout.$158.Metal1 vref.P0.GatPoly 2.75542e-09f
Cred_7896 vout.$158.Metal1 vref.P0.nSD 1.57959e-08f
Cred_7897 vout.$158.Metal1 vref.P0.pSD 4.65668e-08f
Cred_7898 vout.$158.Metal1 vss.$1282.Metal5 4.22677e-05f
Cred_7899 vout.$159.Metal1 vref 1.14637e-07f
Cred_7900 vout.$159.Metal1 vref.P0.GatPoly 4.4702e-09f
Cred_7901 vout.$159.Metal1 vref.P0.nSD 2.56262e-08f
Cred_7902 vout.$159.Metal1 vref.P0.pSD 7.55467e-08f
Cred_7903 vout.$159.Metal1 vss.$1282.Metal5 5.29893e-05f
Cred_7904 vout.$16.Metal1 vss.$1300.Metal5 1.07499e-06f
Cred_7905 vout.$16.Metal1 vss.$141.Metal1 6.91337e-08f
Cred_7906 vout.$16.Metal1 vss.$143.Metal1 0.000383264f
Cred_7907 vout.$16.Metal1 vss.$146.Metal1 0.00188817f
Cred_7908 vout.$16.Metal1 vss.$485.Metal2 5.86333e-06f
Cred_7909 vout.$16.Metal1 vss.$489.Metal2 4.26446e-05f
Cred_7910 vout.$16.Metal1 vss.$493.Metal2 0.0225127f
Cred_7911 vout.$16.Metal1 vss.$495.Metal2 0.0111213f
Cred_7912 vout.$16.Metal1 vss.$499.Metal2 0.0248238f
Cred_7913 vout.$16.Metal1 vss.$821.Metal3 6.91337e-08f
Cred_7914 vout.$16.Metal1 vss.$829.Metal3 1.42422e-06f
Cred_7915 vout.$16.Metal1 vss.$831.Metal3 4.63231e-05f
Cred_7916 vout.$16.Metal1 vss.P0.pSD 3.48728e-06f
Cred_7917 vout.$16.Metal1 vss.P11.nSD 6.50811e-06f
Cred_7918 vout.$16.Metal1 vss.P13.nSD 0.0245345f
Cred_7919 vout.$16.Metal1 vss.P15.nSD 0.0236739f
Cred_7920 vout.$160.Metal1 vref 9.48346e-06f
Cred_7921 vout.$160.Metal1 vref.P0.GatPoly 3.69802e-07f
Cred_7922 vout.$160.Metal1 vref.P0.nSD 2.11995e-06f
Cred_7923 vout.$160.Metal1 vref.P0.pSD 1.12921e-05f
Cred_7924 vout.$160.Metal1 vss.$1282.Metal5 5.16913e-05f
Cred_7925 vout.$161.Metal1 vref 1.44054e-06f
Cred_7926 vout.$161.Metal1 vref.P0.GatPoly 5.6173e-08f
Cred_7927 vout.$161.Metal1 vref.P0.nSD 3.22021e-07f
Cred_7928 vout.$161.Metal1 vref.P0.pSD 1.73978e-06f
Cred_7929 vout.$161.Metal1 vss.$1300.Metal5 6.79125e-07f
Cred_7930 vout.$165.Metal1 vss 2.92309e-07f
Cred_7931 vout.$165.Metal1 vss.$1212.Metal5 3.0146e-07f
Cred_7932 vout.$165.Metal1 vss.$1230.Metal5 3.0146e-07f
Cred_7933 vout.$165.Metal1 vss.$1282.Metal5 1.15393e-06f
Cred_7934 vout.$165.Metal1 vss.$1300.Metal5 1.15393e-06f
Cred_7935 vout.$17.Metal1 vss.$1300.Metal5 1.07499e-06f
Cred_7936 vout.$17.Metal1 vss.$146.Metal1 4.48615e-05f
Cred_7937 vout.$17.Metal1 vss.$148.Metal1 0.00224711f
Cred_7938 vout.$17.Metal1 vss.$150.Metal1 3.67263e-05f
Cred_7939 vout.$17.Metal1 vss.$495.Metal2 0.00380477f
Cred_7940 vout.$17.Metal1 vss.$499.Metal2 0.0248313f
Cred_7941 vout.$17.Metal1 vss.$503.Metal2 0.0255543f
Cred_7942 vout.$17.Metal1 vss.$507.Metal2 0.00311482f
Cred_7943 vout.$17.Metal1 vss.$831.Metal3 4.48615e-05f
Cred_7944 vout.$17.Metal1 vss.$835.Metal3 3.04853e-06f
Cred_7945 vout.$17.Metal1 vss.$839.Metal3 3.67263e-05f
Cred_7946 vout.$17.Metal1 vss.P15.nSD 0.0236727f
Cred_7947 vout.$17.Metal1 vss.P17.nSD 0.0236656f
Cred_7948 vout.$18.Metal1 vss.$1300.Metal5 4.07896e-07f
Cred_7949 vout.$18.Metal1 vss.$150.Metal1 0.00132145f
Cred_7950 vout.$18.Metal1 vss.$503.Metal2 0.0259987f
Cred_7951 vout.$18.Metal1 vss.$507.Metal2 0.0116131f
Cred_7952 vout.$18.Metal1 vss.$509.Metal2 0.0203043f
Cred_7953 vout.$18.Metal1 vss.$839.Metal3 3.81679e-05f
Cred_7954 vout.$18.Metal1 vss.$841.Metal3 4.37474e-07f
Cred_7955 vout.$18.Metal1 vss.P17.nSD 0.0240992f
Cred_7956 vout.$18.Metal1 vss.P19.nSD 0.0236674f
Cred_7957 vout.$19.Metal1 vss.$1053.Metal4 3.38546e-08f
Cred_7958 vout.$19.Metal1 vss.$1055.Metal4 4.27091e-08f
Cred_7959 vout.$19.Metal1 vss.$1057.Metal4 2.96879e-08f
Cred_7960 vout.$19.Metal1 vss.$1300.Metal5 7.09711e-07f
Cred_7961 vout.$19.Metal1 vss.$153.Metal1 0.00224711f
Cred_7962 vout.$19.Metal1 vss.$507.Metal2 0.0083993f
Cred_7963 vout.$19.Metal1 vss.$509.Metal2 0.0203268f
Cred_7964 vout.$19.Metal1 vss.$513.Metal2 0.0229361f
Cred_7965 vout.$19.Metal1 vss.$515.Metal2 0.00555338f
Cred_7966 vout.$19.Metal1 vss.$845.Metal3 1.36994e-06f
Cred_7967 vout.$19.Metal1 vss.P19.nSD 0.0236663f
Cred_7968 vout.$19.Metal1 vss.P21.nSD 0.0234446f
Cred_7969 vout.$20.Metal1 vss.$1057.Metal4 5.64936e-09f
Cred_7970 vout.$20.Metal1 vss.$1059.Metal4 1.80251e-08f
Cred_7971 vout.$20.Metal1 vss.$1061.Metal4 1.87532e-09f
Cred_7972 vout.$20.Metal1 vss.$1300.Metal5 2.7657e-05f
Cred_7973 vout.$20.Metal1 vss.$153.Metal1 0.000452926f
Cred_7974 vout.$20.Metal1 vss.$156.Metal1 0.00096506f
Cred_7975 vout.$20.Metal1 vss.$513.Metal2 0.0236973f
Cred_7976 vout.$20.Metal1 vss.$515.Metal2 0.0101355f
Cred_7977 vout.$20.Metal1 vss.$519.Metal2 0.0232312f
Cred_7978 vout.$20.Metal1 vss.$521.Metal2 7.47316e-05f
Cred_7979 vout.$20.Metal1 vss.$849.Metal3 6.43392e-07f
Cred_7980 vout.$20.Metal1 vss.$851.Metal3 5.15936e-05f
Cred_7981 vout.$20.Metal1 vss.P0.pSD 4.12128e-06f
Cred_7982 vout.$20.Metal1 vss.P21.nSD 0.0242536f
Cred_7983 vout.$20.Metal1 vss.P23.nSD 0.0228098f
Cred_7984 vout.$20.Metal1 vss.P25.nSD 1.06238e-05f
Cred_7985 vout.$206.Metal1 vss.$1282.Metal5 9.02745e-06f
Cred_7986 vout.$207.Metal1 vss.$1282.Metal5 9.02745e-06f
Cred_7987 vout.$208.Metal1 vss.$1282.Metal5 9.02745e-06f
Cred_7988 vout.$209.Metal1 vss.$1282.Metal5 9.02745e-06f
Cred_7989 vout.$210.Metal1 vss.$1282.Metal5 9.02745e-06f
Cred_7990 vout.$226.Metal1 vss.$1282.Metal5 9.57457e-07f
Cred_7991 vout.$227.Metal1 vss.$1282.Metal5 9.57457e-07f
Cred_7992 vout.$228.Metal1 vss.$1282.Metal5 9.57457e-07f
Cred_7993 vout.$229.Metal1 vss.$1282.Metal5 9.57457e-07f
Cred_7994 vout.$230.Metal1 vss.$1282.Metal5 9.57457e-07f
Cred_7995 vout.$396.Metal1 vss.$1282.Metal5 1.77774e-05f
Cred_7996 vout.$404.Metal1 vss 1.99012e-08f
Cred_7997 vout.$404.Metal1 vss.$1212.Metal5 2.05242e-08f
Cred_7998 vout.$404.Metal1 vss.$1230.Metal5 2.05242e-08f
Cred_7999 vout.$404.Metal1 vss.$1282.Metal5 7.85626e-08f
Cred_8000 vout.$404.Metal1 vss.$1300.Metal5 7.85626e-08f
Cred_8001 vout.$405.Metal1 vss 9.02685e-07f
Cred_8002 vout.$405.Metal1 vss.$1212.Metal5 9.30946e-07f
Cred_8003 vout.$405.Metal1 vss.$1230.Metal5 9.30946e-07f
Cred_8004 vout.$405.Metal1 vss.$1282.Metal5 3.56347e-06f
Cred_8005 vout.$405.Metal1 vss.$1300.Metal5 3.56347e-06f
Cred_8006 vout.$436.Metal2 vss.$10.Metal1 0.000118189f
Cred_8007 vout.$436.Metal2 vss.$1009.Metal4 3.63148e-06f
Cred_8008 vout.$436.Metal2 vss.$1011.Metal4 3.49049e-05f
Cred_8009 vout.$436.Metal2 vss.$1013.Metal4 1.09505e-05f
Cred_8010 vout.$436.Metal2 vss.$1282.Metal5 0.00252536f
Cred_8011 vout.$436.Metal2 vss.$13.Metal1 3.72873e-06f
Cred_8012 vout.$436.Metal2 vss.$461.Metal2 0.00827778f
Cred_8013 vout.$436.Metal2 vss.$463.Metal2 0.0486071f
Cred_8014 vout.$436.Metal2 vss.$467.Metal2 0.0223417f
Cred_8015 vout.$436.Metal2 vss.$469.Metal2 0.0459662f
Cred_8016 vout.$436.Metal2 vss.$799.Metal3 0.000166215f
Cred_8017 vout.$436.Metal2 vss.$801.Metal3 9.87396e-05f
Cred_8018 vout.$436.Metal2 vss.$805.Metal3 9.08872e-07f
Cred_8019 vout.$436.Metal2 vss.P0.nSD 0.00134005f
Cred_8020 vout.$436.Metal2 vss.P0.pSD 3.39287e-08f
Cred_8021 vout.$436.Metal2 vss.P1.nSD 0.00879129f
Cred_8022 vout.$436.Metal2 vss.P3.nSD 0.00882645f
Cred_8023 vout.$438.Metal2 vss.$1282.Metal5 9.02926e-05f
Cred_8024 vout.$438.Metal2 vss.$13.Metal1 3.32571e-05f
Cred_8025 vout.$438.Metal2 vss.$467.Metal2 0.0108386f
Cred_8026 vout.$438.Metal2 vss.$469.Metal2 0.0461415f
Cred_8027 vout.$438.Metal2 vss.$473.Metal2 0.0415723f
Cred_8028 vout.$438.Metal2 vss.$475.Metal2 0.0166097f
Cred_8029 vout.$438.Metal2 vss.$805.Metal3 0.000244746f
Cred_8030 vout.$438.Metal2 vss.P3.nSD 0.00858155f
Cred_8031 vout.$438.Metal2 vss.P5.nSD 0.00879331f
Cred_8032 vout.$440.Metal2 vss.$1282.Metal5 9.02926e-05f
Cred_8033 vout.$440.Metal2 vss.$136.Metal1 9.16545e-05f
Cred_8034 vout.$440.Metal2 vss.$473.Metal2 0.0392773f
Cred_8035 vout.$440.Metal2 vss.$475.Metal2 0.0244643f
Cred_8036 vout.$440.Metal2 vss.$479.Metal2 0.0512756f
Cred_8037 vout.$440.Metal2 vss.$809.Metal3 9.684e-05f
Cred_8038 vout.$440.Metal2 vss.$811.Metal3 0.000213319f
Cred_8039 vout.$440.Metal2 vss.P5.nSD 0.00860653f
Cred_8040 vout.$440.Metal2 vss.P7.nSD 0.00878943f
Cred_8041 vout.$442.Metal2 vss.$1282.Metal5 9.02926e-05f
Cred_8042 vout.$442.Metal2 vss.$136.Metal1 7.10266e-05f
Cred_8043 vout.$442.Metal2 vss.$138.Metal1 3.32571e-05f
Cred_8044 vout.$442.Metal2 vss.$475.Metal2 0.00602387f
Cred_8045 vout.$442.Metal2 vss.$479.Metal2 0.0507975f
Cred_8046 vout.$442.Metal2 vss.$483.Metal2 0.0429599f
Cred_8047 vout.$442.Metal2 vss.$485.Metal2 0.0152269f
Cred_8048 vout.$442.Metal2 vss.$811.Metal3 7.10266e-05f
Cred_8049 vout.$442.Metal2 vss.$815.Metal3 0.000244746f
Cred_8050 vout.$442.Metal2 vss.P10.nSD 0.00878854f
Cred_8051 vout.$442.Metal2 vss.P7.nSD 0.00859817f
Cred_8052 vout.$444.Metal2 vss.$1282.Metal5 9.02926e-05f
Cred_8053 vout.$444.Metal2 vss.$138.Metal1 2.53846e-06f
Cred_8054 vout.$444.Metal2 vss.$141.Metal1 0.000102809f
Cred_8055 vout.$444.Metal2 vss.$483.Metal2 0.0406485f
Cred_8056 vout.$444.Metal2 vss.$485.Metal2 0.0238388f
Cred_8057 vout.$444.Metal2 vss.$489.Metal2 0.0502517f
Cred_8058 vout.$444.Metal2 vss.$493.Metal2 0.00403259f
Cred_8059 vout.$444.Metal2 vss.$495.Metal2 0.00130084f
Cred_8060 vout.$444.Metal2 vss.$819.Metal3 0.000108233f
Cred_8061 vout.$444.Metal2 vss.$821.Metal3 0.000208738f
Cred_8062 vout.$444.Metal2 vss.P0.pSD 2.38986e-08f
Cred_8063 vout.$444.Metal2 vss.P10.nSD 0.00860217f
Cred_8064 vout.$444.Metal2 vss.P11.nSD 0.008731f
Cred_8065 vout.$444.Metal2 vss.P13.nSD 0.000808318f
Cred_8066 vout.$446.Metal2 vss.$1300.Metal5 9.02926e-05f
Cred_8067 vout.$446.Metal2 vss.$141.Metal1 7.57786e-06f
Cred_8068 vout.$446.Metal2 vss.$143.Metal1 2.79262e-06f
Cred_8069 vout.$446.Metal2 vss.$146.Metal1 0.000110176f
Cred_8070 vout.$446.Metal2 vss.$485.Metal2 0.00064269f
Cred_8071 vout.$446.Metal2 vss.$489.Metal2 0.00467435f
Cred_8072 vout.$446.Metal2 vss.$493.Metal2 0.0433604f
Cred_8073 vout.$446.Metal2 vss.$495.Metal2 0.0237139f
Cred_8074 vout.$446.Metal2 vss.$499.Metal2 0.0497339f
Cred_8075 vout.$446.Metal2 vss.$821.Metal3 7.57786e-06f
Cred_8076 vout.$446.Metal2 vss.$829.Metal3 0.000119626f
Cred_8077 vout.$446.Metal2 vss.$831.Metal3 0.000204979f
Cred_8078 vout.$446.Metal2 vss.P0.pSD 2.54098e-08f
Cred_8079 vout.$446.Metal2 vss.P11.nSD 0.00080955f
Cred_8080 vout.$446.Metal2 vss.P13.nSD 0.00886489f
Cred_8081 vout.$446.Metal2 vss.P15.nSD 0.00880894f
Cred_8082 vout.$448.Metal2 vss.$1300.Metal5 9.02926e-05f
Cred_8083 vout.$448.Metal2 vss.$146.Metal1 8.67852e-05f
Cred_8084 vout.$448.Metal2 vss.$148.Metal1 3.32571e-05f
Cred_8085 vout.$448.Metal2 vss.$150.Metal1 7.25919e-05f
Cred_8086 vout.$448.Metal2 vss.$495.Metal2 0.00736039f
Cred_8087 vout.$448.Metal2 vss.$499.Metal2 0.0494135f
Cred_8088 vout.$448.Metal2 vss.$503.Metal2 0.0518855f
Cred_8089 vout.$448.Metal2 vss.$507.Metal2 0.00615663f
Cred_8090 vout.$448.Metal2 vss.$831.Metal3 8.67852e-05f
Cred_8091 vout.$448.Metal2 vss.$835.Metal3 0.000244746f
Cred_8092 vout.$448.Metal2 vss.$839.Metal3 7.25919e-05f
Cred_8093 vout.$448.Metal2 vss.P15.nSD 0.00861419f
Cred_8094 vout.$448.Metal2 vss.P17.nSD 0.00878801f
Cred_8095 vout.$450.Metal2 vss.$1300.Metal5 2.05035e-05f
Cred_8096 vout.$450.Metal2 vss.$150.Metal1 8.93587e-05f
Cred_8097 vout.$450.Metal2 vss.$503.Metal2 0.0496956f
Cred_8098 vout.$450.Metal2 vss.$507.Metal2 0.0244848f
Cred_8099 vout.$450.Metal2 vss.$509.Metal2 0.0397987f
Cred_8100 vout.$450.Metal2 vss.$839.Metal3 0.000109767f
Cred_8101 vout.$450.Metal2 vss.$841.Metal3 2.19903e-05f
Cred_8102 vout.$450.Metal2 vss.P17.nSD 0.00851426f
Cred_8103 vout.$450.Metal2 vss.P19.nSD 0.00871684f
Cred_8104 vout.$452.Metal2 vss.$1053.Metal4 1.70176e-06f
Cred_8105 vout.$452.Metal2 vss.$1055.Metal4 2.14684e-06f
Cred_8106 vout.$452.Metal2 vss.$1057.Metal4 1.49231e-06f
Cred_8107 vout.$452.Metal2 vss.$1300.Metal5 3.56748e-05f
Cred_8108 vout.$452.Metal2 vss.$153.Metal1 3.32152e-05f
Cred_8109 vout.$452.Metal2 vss.$507.Metal2 0.0160892f
Cred_8110 vout.$452.Metal2 vss.$509.Metal2 0.0403125f
Cred_8111 vout.$452.Metal2 vss.$513.Metal2 0.046677f
Cred_8112 vout.$452.Metal2 vss.$515.Metal2 0.0109689f
Cred_8113 vout.$452.Metal2 vss.$845.Metal3 6.88623e-05f
Cred_8114 vout.$452.Metal2 vss.P19.nSD 0.00851495f
Cred_8115 vout.$452.Metal2 vss.P21.nSD 0.00868119f
Cred_8116 vout.$454.Metal2 vss.$1057.Metal4 2.83974e-07f
Cred_8117 vout.$454.Metal2 vss.$1059.Metal4 9.06061e-07f
Cred_8118 vout.$454.Metal2 vss.$1061.Metal4 9.42658e-08f
Cred_8119 vout.$454.Metal2 vss.$1300.Metal5 0.00139022f
Cred_8120 vout.$454.Metal2 vss.$153.Metal1 3.29604e-06f
Cred_8121 vout.$454.Metal2 vss.$156.Metal1 0.000114817f
Cred_8122 vout.$454.Metal2 vss.$513.Metal2 0.0442607f
Cred_8123 vout.$454.Metal2 vss.$515.Metal2 0.0217127f
Cred_8124 vout.$454.Metal2 vss.$519.Metal2 0.0474646f
Cred_8125 vout.$454.Metal2 vss.$521.Metal2 0.00816862f
Cred_8126 vout.$454.Metal2 vss.$849.Metal3 3.23412e-05f
Cred_8127 vout.$454.Metal2 vss.$851.Metal3 0.000127571f
Cred_8128 vout.$454.Metal2 vss.P0.pSD 2.99915e-08f
Cred_8129 vout.$454.Metal2 vss.P21.nSD 0.00849672f
Cred_8130 vout.$454.Metal2 vss.P23.nSD 0.00856268f
Cred_8131 vout.$454.Metal2 vss.P25.nSD 0.00132253f
Cred_8132 vout.$456.Metal2 vss.$10.Metal1 5.54509e-05f
Cred_8133 vout.$456.Metal2 vss.$461.Metal2 0.00430486f
Cred_8134 vout.$456.Metal2 vss.$463.Metal2 0.0255402f
Cred_8135 vout.$456.Metal2 vss.$467.Metal2 0.0106835f
Cred_8136 vout.$456.Metal2 vss.$469.Metal2 0.0246701f
Cred_8137 vout.$456.Metal2 vss.$799.Metal3 5.54509e-05f
Cred_8138 vout.$456.Metal2 vss.P0.nSD 0.000904234f
Cred_8139 vout.$456.Metal2 vss.P1.nSD 0.00608894f
Cred_8140 vout.$456.Metal2 vss.P3.nSD 0.00617483f
Cred_8141 vout.$458.Metal2 vss.$1282.Metal5 1.7772e-05f
Cred_8142 vout.$458.Metal2 vss.$13.Metal1 1.06943e-08f
Cred_8143 vout.$458.Metal2 vss.$467.Metal2 0.00842493f
Cred_8144 vout.$458.Metal2 vss.$469.Metal2 0.0347533f
Cred_8145 vout.$458.Metal2 vss.$473.Metal2 0.0305026f
Cred_8146 vout.$458.Metal2 vss.$475.Metal2 0.0126216f
Cred_8147 vout.$458.Metal2 vss.$805.Metal3 4.48542e-05f
Cred_8148 vout.$458.Metal2 vss.P3.nSD 0.00894521f
Cred_8149 vout.$458.Metal2 vss.P5.nSD 0.00893573f
Cred_8150 vout.$460.Metal2 vss.$1282.Metal5 1.7772e-05f
Cred_8151 vout.$460.Metal2 vss.$136.Metal1 5.51682e-05f
Cred_8152 vout.$460.Metal2 vss.$473.Metal2 0.0305284f
Cred_8153 vout.$460.Metal2 vss.$475.Metal2 0.0173115f
Cred_8154 vout.$460.Metal2 vss.$479.Metal2 0.0383394f
Cred_8155 vout.$460.Metal2 vss.$809.Metal3 1.90607e-05f
Cred_8156 vout.$460.Metal2 vss.$811.Metal3 8.09532e-05f
Cred_8157 vout.$460.Metal2 vss.P5.nSD 0.00896216f
Cred_8158 vout.$460.Metal2 vss.P7.nSD 0.0089317f
Cred_8159 vout.$462.Metal2 vss.$1282.Metal5 1.7772e-05f
Cred_8160 vout.$462.Metal2 vss.$136.Metal1 5.52094e-05f
Cred_8161 vout.$462.Metal2 vss.$138.Metal1 1.06943e-08f
Cred_8162 vout.$462.Metal2 vss.$475.Metal2 0.0046824f
Cred_8163 vout.$462.Metal2 vss.$479.Metal2 0.0383725f
Cred_8164 vout.$462.Metal2 vss.$483.Metal2 0.0315571f
Cred_8165 vout.$462.Metal2 vss.$485.Metal2 0.0115708f
Cred_8166 vout.$462.Metal2 vss.$811.Metal3 5.52094e-05f
Cred_8167 vout.$462.Metal2 vss.$815.Metal3 4.48542e-05f
Cred_8168 vout.$462.Metal2 vss.P10.nSD 0.0089321f
Cred_8169 vout.$462.Metal2 vss.P7.nSD 0.00895813f
Cred_8170 vout.$464.Metal2 vss.$1282.Metal5 1.7772e-05f
Cred_8171 vout.$464.Metal2 vss.$138.Metal1 8.16279e-10f
Cred_8172 vout.$464.Metal2 vss.$141.Metal1 6.12434e-05f
Cred_8173 vout.$464.Metal2 vss.$483.Metal2 0.0315972f
Cred_8174 vout.$464.Metal2 vss.$485.Metal2 0.0167799f
Cred_8175 vout.$464.Metal2 vss.$489.Metal2 0.0377733f
Cred_8176 vout.$464.Metal2 vss.$493.Metal2 0.00311563f
Cred_8177 vout.$464.Metal2 vss.$495.Metal2 0.00100504f
Cred_8178 vout.$464.Metal2 vss.$819.Metal3 2.13031e-05f
Cred_8179 vout.$464.Metal2 vss.$821.Metal3 8.47845e-05f
Cred_8180 vout.$464.Metal2 vss.P0.pSD 7.68494e-12f
Cred_8181 vout.$464.Metal2 vss.P10.nSD 0.00896222f
Cred_8182 vout.$464.Metal2 vss.P11.nSD 0.00893864f
Cred_8183 vout.$464.Metal2 vss.P13.nSD 0.000837534f
Cred_8184 vout.$466.Metal2 vss.$1300.Metal5 1.7772e-05f
Cred_8185 vout.$466.Metal2 vss.$141.Metal1 5.85476e-06f
Cred_8186 vout.$466.Metal2 vss.$143.Metal1 8.98007e-10f
Cred_8187 vout.$466.Metal2 vss.$146.Metal1 6.82102e-05f
Cred_8188 vout.$466.Metal2 vss.$485.Metal2 0.000496551f
Cred_8189 vout.$466.Metal2 vss.$489.Metal2 0.00361146f
Cred_8190 vout.$466.Metal2 vss.$493.Metal2 0.0332542f
Cred_8191 vout.$466.Metal2 vss.$495.Metal2 0.0165123f
Cred_8192 vout.$466.Metal2 vss.$499.Metal2 0.0377081f
Cred_8193 vout.$466.Metal2 vss.$821.Metal3 5.85476e-06f
Cred_8194 vout.$466.Metal2 vss.$829.Metal3 2.35455e-05f
Cred_8195 vout.$466.Metal2 vss.$831.Metal3 8.95089e-05f
Cred_8196 vout.$466.Metal2 vss.P0.pSD 8.17089e-12f
Cred_8197 vout.$466.Metal2 vss.P11.nSD 0.000838486f
Cred_8198 vout.$466.Metal2 vss.P13.nSD 0.00912458f
Cred_8199 vout.$466.Metal2 vss.P15.nSD 0.00905682f
Cred_8200 vout.$468.Metal2 vss.$1300.Metal5 1.7772e-05f
Cred_8201 vout.$468.Metal2 vss.$146.Metal1 6.66975e-05f
Cred_8202 vout.$468.Metal2 vss.$148.Metal1 1.06943e-08f
Cred_8203 vout.$468.Metal2 vss.$150.Metal1 5.65995e-05f
Cred_8204 vout.$468.Metal2 vss.$495.Metal2 0.00565672f
Cred_8205 vout.$468.Metal2 vss.$499.Metal2 0.0368758f
Cred_8206 vout.$468.Metal2 vss.$503.Metal2 0.0393386f
Cred_8207 vout.$468.Metal2 vss.$507.Metal2 0.00480029f
Cred_8208 vout.$468.Metal2 vss.$831.Metal3 6.66975e-05f
Cred_8209 vout.$468.Metal2 vss.$835.Metal3 4.48542e-05f
Cred_8210 vout.$468.Metal2 vss.$839.Metal3 5.65995e-05f
Cred_8211 vout.$468.Metal2 vss.P15.nSD 0.00886347f
Cred_8212 vout.$468.Metal2 vss.P17.nSD 0.00916392f
Cred_8213 vout.$470.Metal2 vss.$150.Metal1 5.44053e-05f
Cred_8214 vout.$470.Metal2 vss.$503.Metal2 0.0378131f
Cred_8215 vout.$470.Metal2 vss.$507.Metal2 0.0173532f
Cred_8216 vout.$470.Metal2 vss.$509.Metal2 0.0307859f
Cred_8217 vout.$470.Metal2 vss.$839.Metal3 5.44053e-05f
Cred_8218 vout.$470.Metal2 vss.P17.nSD 0.00882862f
Cred_8219 vout.$470.Metal2 vss.P19.nSD 0.0090316f
Cred_8220 vout.$472.Metal2 vss.$507.Metal2 0.0124484f
Cred_8221 vout.$472.Metal2 vss.$509.Metal2 0.0300837f
Cred_8222 vout.$472.Metal2 vss.$513.Metal2 0.0350186f
Cred_8223 vout.$472.Metal2 vss.$515.Metal2 0.00848937f
Cred_8224 vout.$472.Metal2 vss.P19.nSD 0.00883259f
Cred_8225 vout.$472.Metal2 vss.P21.nSD 0.00900785f
Cred_8226 vout.$474.Metal2 vss 1.0902e-05f
Cred_8227 vout.$474.Metal2 vss.$1212.Metal5 1.12433e-05f
Cred_8228 vout.$474.Metal2 vss.$1230.Metal5 1.12433e-05f
Cred_8229 vout.$474.Metal2 vss.$1282.Metal5 4.3037e-05f
Cred_8230 vout.$474.Metal2 vss.$1300.Metal5 4.3037e-05f
Cred_8231 vout.$474.Metal2 vss.$156.Metal1 7.86006e-05f
Cred_8232 vout.$474.Metal2 vss.$513.Metal2 0.0342417f
Cred_8233 vout.$474.Metal2 vss.$515.Metal2 0.0149672f
Cred_8234 vout.$474.Metal2 vss.$519.Metal2 0.0362222f
Cred_8235 vout.$474.Metal2 vss.$521.Metal2 0.00634902f
Cred_8236 vout.$474.Metal2 vss.$851.Metal3 7.86006e-05f
Cred_8237 vout.$474.Metal2 vss.P21.nSD 0.00881467f
Cred_8238 vout.$474.Metal2 vss.P23.nSD 0.00884905f
Cred_8239 vout.$474.Metal2 vss.P25.nSD 0.00138557f
Cred_8240 vout.$476.Metal2 vss.$10.Metal1 5.08531e-05f
Cred_8241 vout.$476.Metal2 vss.$1282.Metal5 0.000130038f
Cred_8242 vout.$476.Metal2 vss.$461.Metal2 0.00415318f
Cred_8243 vout.$476.Metal2 vss.$463.Metal2 0.0234386f
Cred_8244 vout.$476.Metal2 vss.$467.Metal2 0.00946641f
Cred_8245 vout.$476.Metal2 vss.$469.Metal2 0.0212581f
Cred_8246 vout.$476.Metal2 vss.$799.Metal3 5.08531e-05f
Cred_8247 vout.$476.Metal2 vss.P0.nSD 0.000978703f
Cred_8248 vout.$476.Metal2 vss.P1.nSD 0.00606411f
Cred_8249 vout.$476.Metal2 vss.P3.nSD 0.0057911f
Cred_8250 vout.$496.Metal2 vss.$10.Metal1 4.78966e-05f
Cred_8251 vout.$496.Metal2 vss.$1282.Metal5 0.0010181f
Cred_8252 vout.$496.Metal2 vss.$461.Metal2 0.00398322f
Cred_8253 vout.$496.Metal2 vss.$463.Metal2 0.0220816f
Cred_8254 vout.$496.Metal2 vss.$467.Metal2 0.00904158f
Cred_8255 vout.$496.Metal2 vss.$469.Metal2 0.02054f
Cred_8256 vout.$496.Metal2 vss.$799.Metal3 4.78966e-05f
Cred_8257 vout.$496.Metal2 vss.P0.nSD 0.00103974f
Cred_8258 vout.$496.Metal2 vss.P1.nSD 0.00650145f
Cred_8259 vout.$496.Metal2 vss.P3.nSD 0.00636793f
Cred_8260 vout.$498.Metal2 vref 2.93836e-06f
Cred_8261 vout.$498.Metal2 vref.P0.GatPoly 1.14579e-07f
Cred_8262 vout.$498.Metal2 vref.P0.nSD 9.54789e-07f
Cred_8263 vout.$498.Metal2 vref.P0.pSD 1.15128e-06f
Cred_8264 vout.$498.Metal2 vss.$127.Metal1 2.04259e-10f
Cred_8265 vout.$498.Metal2 vss.$1282.Metal5 0.00146941f
Cred_8266 vout.$498.Metal2 vss.$406.Metal1 1.65808e-10f
Cred_8267 vout.$498.Metal2 vss.$457.Metal2 2.98317e-12f
Cred_8268 vout.$498.Metal2 vss.$467.Metal2 0.00768403f
Cred_8269 vout.$498.Metal2 vss.$469.Metal2 0.0316966f
Cred_8270 vout.$498.Metal2 vss.$473.Metal2 0.0272715f
Cred_8271 vout.$498.Metal2 vss.$475.Metal2 0.0112848f
Cred_8272 vout.$498.Metal2 vss.P0.GatPoly 7.30246e-12f
Cred_8273 vout.$498.Metal2 vss.P0.pSD 3.79299e-09f
Cred_8274 vout.$498.Metal2 vss.P3.nSD 0.00941152f
Cred_8275 vout.$498.Metal2 vss.P5.nSD 0.00924924f
Cred_8276 vout.$500.Metal2 vref 4.03507e-06f
Cred_8277 vout.$500.Metal2 vref.P0.GatPoly 1.57345e-07f
Cred_8278 vout.$500.Metal2 vref.P0.nSD 1.31099e-06f
Cred_8279 vout.$500.Metal2 vref.P0.pSD 1.58098e-06f
Cred_8280 vout.$500.Metal2 vss.$127.Metal1 2.03109e-10f
Cred_8281 vout.$500.Metal2 vss.$1282.Metal5 0.00146824f
Cred_8282 vout.$500.Metal2 vss.$136.Metal1 4.93196e-05f
Cred_8283 vout.$500.Metal2 vss.$406.Metal1 2.75139e-10f
Cred_8284 vout.$500.Metal2 vss.$457.Metal2 2.96638e-12f
Cred_8285 vout.$500.Metal2 vss.$473.Metal2 0.0278436f
Cred_8286 vout.$500.Metal2 vss.$475.Metal2 0.0157044f
Cred_8287 vout.$500.Metal2 vss.$479.Metal2 0.0342784f
Cred_8288 vout.$500.Metal2 vss.$811.Metal3 4.93196e-05f
Cred_8289 vout.$500.Metal2 vss.P0.GatPoly 7.26135e-12f
Cred_8290 vout.$500.Metal2 vss.P0.pSD 4.8663e-09f
Cred_8291 vout.$500.Metal2 vss.P5.nSD 0.00942697f
Cred_8292 vout.$500.Metal2 vss.P7.nSD 0.00924564f
Cred_8293 vout.$502.Metal2 vref 6.44221e-06f
Cred_8294 vout.$502.Metal2 vref.P0.GatPoly 2.5121e-07f
Cred_8295 vout.$502.Metal2 vref.P0.nSD 2.09249e-06f
Cred_8296 vout.$502.Metal2 vref.P0.pSD 2.52412e-06f
Cred_8297 vout.$502.Metal2 vss.$127.Metal1 1.22834e-10f
Cred_8298 vout.$502.Metal2 vss.$1282.Metal5 0.00146907f
Cred_8299 vout.$502.Metal2 vss.$136.Metal1 5.03542e-05f
Cred_8300 vout.$502.Metal2 vss.$406.Metal1 2.77284e-10f
Cred_8301 vout.$502.Metal2 vss.$457.Metal2 1.79397e-12f
Cred_8302 vout.$502.Metal2 vss.$475.Metal2 0.00427062f
Cred_8303 vout.$502.Metal2 vss.$479.Metal2 0.0349975f
Cred_8304 vout.$502.Metal2 vss.$483.Metal2 0.0282051f
Cred_8305 vout.$502.Metal2 vss.$485.Metal2 0.0103419f
Cred_8306 vout.$502.Metal2 vss.$811.Metal3 5.03542e-05f
Cred_8307 vout.$502.Metal2 vss.P0.GatPoly 4.39143e-12f
Cred_8308 vout.$502.Metal2 vss.P0.pSD 3.76704e-09f
Cred_8309 vout.$502.Metal2 vss.P10.nSD 0.00923505f
Cred_8310 vout.$502.Metal2 vss.P7.nSD 0.0094233f
Cred_8311 vout.$504.Metal2 vref 0.000262184f
Cred_8312 vout.$504.Metal2 vref.P0.GatPoly 1.02237e-05f
Cred_8313 vout.$504.Metal2 vref.P0.nSD 0.000215481f
Cred_8314 vout.$504.Metal2 vref.P0.pSD 0.000102727f
Cred_8315 vout.$504.Metal2 vss.$1033.Metal4 4.78374e-09f
Cred_8316 vout.$504.Metal2 vss.$1037.Metal4 4.78374e-09f
Cred_8317 vout.$504.Metal2 vss.$1247.Metal5 1.25567e-06f
Cred_8318 vout.$504.Metal2 vss.$127.Metal1 1.22558e-10f
Cred_8319 vout.$504.Metal2 vss.$1282.Metal5 0.00144474f
Cred_8320 vout.$504.Metal2 vss.$141.Metal1 5.63538e-05f
Cred_8321 vout.$504.Metal2 vss.$406.Metal1 4.60017e-10f
Cred_8322 vout.$504.Metal2 vss.$457.Metal2 1.78994e-12f
Cred_8323 vout.$504.Metal2 vss.$483.Metal2 0.0282102f
Cred_8324 vout.$504.Metal2 vss.$485.Metal2 0.0151232f
Cred_8325 vout.$504.Metal2 vss.$489.Metal2 0.0347614f
Cred_8326 vout.$504.Metal2 vss.$493.Metal2 0.0009959f
Cred_8327 vout.$504.Metal2 vss.$495.Metal2 0.000321258f
Cred_8328 vout.$504.Metal2 vss.$821.Metal3 5.63538e-05f
Cred_8329 vout.$504.Metal2 vss.$825.Metal3 5.64044e-11f
Cred_8330 vout.$504.Metal2 vss.P0.GatPoly 4.38155e-12f
Cred_8331 vout.$504.Metal2 vss.P0.pSD 4.76603e-09f
Cred_8332 vout.$504.Metal2 vss.P10.nSD 0.00923318f
Cred_8333 vout.$504.Metal2 vss.P11.nSD 0.00949668f
Cred_8334 vout.$504.Metal2 vss.P13.nSD 0.00028915f
Cred_8335 vout.$506.Metal2 vref 3.68142e-05f
Cred_8336 vout.$506.Metal2 vref.P0.GatPoly 1.43555e-06f
Cred_8337 vout.$506.Metal2 vref.P0.nSD 3.45579e-05f
Cred_8338 vout.$506.Metal2 vref.P0.pSD 1.44242e-05f
Cred_8339 vout.$506.Metal2 vss.$1300.Metal5 2.49904e-05f
Cred_8340 vout.$506.Metal2 vss.$141.Metal1 1.87145e-06f
Cred_8341 vout.$506.Metal2 vss.$146.Metal1 6.09068e-05f
Cred_8342 vout.$506.Metal2 vss.$485.Metal2 0.00015872f
Cred_8343 vout.$506.Metal2 vss.$489.Metal2 0.00115439f
Cred_8344 vout.$506.Metal2 vss.$493.Metal2 0.0306118f
Cred_8345 vout.$506.Metal2 vss.$495.Metal2 0.0150404f
Cred_8346 vout.$506.Metal2 vss.$499.Metal2 0.0336738f
Cred_8347 vout.$506.Metal2 vss.$821.Metal3 1.87145e-06f
Cred_8348 vout.$506.Metal2 vss.$831.Metal3 6.09068e-05f
Cred_8349 vout.$506.Metal2 vss.P11.nSD 0.000289454f
Cred_8350 vout.$506.Metal2 vss.P13.nSD 0.00969339f
Cred_8351 vout.$506.Metal2 vss.P15.nSD 0.00934369f
Cred_8352 vout.$508.Metal2 vss.$146.Metal1 6.06278e-05f
Cred_8353 vout.$508.Metal2 vss.$150.Metal1 4.98472e-05f
Cred_8354 vout.$508.Metal2 vss.$495.Metal2 0.00514194f
Cred_8355 vout.$508.Metal2 vss.$499.Metal2 0.0335196f
Cred_8356 vout.$508.Metal2 vss.$503.Metal2 0.0346451f
Cred_8357 vout.$508.Metal2 vss.$507.Metal2 0.00422762f
Cred_8358 vout.$508.Metal2 vss.$831.Metal3 6.06278e-05f
Cred_8359 vout.$508.Metal2 vss.$839.Metal3 4.98472e-05f
Cred_8360 vout.$508.Metal2 vss.P15.nSD 0.00930464f
Cred_8361 vout.$508.Metal2 vss.P17.nSD 0.00933244f
Cred_8362 vout.$510.Metal2 vss.$150.Metal1 4.96189e-05f
Cred_8363 vout.$510.Metal2 vss.$503.Metal2 0.0344865f
Cred_8364 vout.$510.Metal2 vss.$507.Metal2 0.0156138f
Cred_8365 vout.$510.Metal2 vss.$509.Metal2 0.0275633f
Cred_8366 vout.$510.Metal2 vss.$839.Metal3 4.96189e-05f
Cred_8367 vout.$510.Metal2 vss.P17.nSD 0.00929344f
Cred_8368 vout.$510.Metal2 vss.P19.nSD 0.00933608f
Cred_8369 vout.$512.Metal2 vss.$507.Metal2 0.0113533f
Cred_8370 vout.$512.Metal2 vss.$509.Metal2 0.0274371f
Cred_8371 vout.$512.Metal2 vss.$513.Metal2 0.0313711f
Cred_8372 vout.$512.Metal2 vss.$515.Metal2 0.00760511f
Cred_8373 vout.$512.Metal2 vss.P19.nSD 0.00929706f
Cred_8374 vout.$512.Metal2 vss.P21.nSD 0.00931395f
Cred_8375 vout.$514.Metal2 vss 1.13196e-05f
Cred_8376 vout.$514.Metal2 vss.$1212.Metal5 1.1674e-05f
Cred_8377 vout.$514.Metal2 vss.$1230.Metal5 1.1674e-05f
Cred_8378 vout.$514.Metal2 vss.$1282.Metal5 4.46858e-05f
Cred_8379 vout.$514.Metal2 vss.$1300.Metal5 4.46858e-05f
Cred_8380 vout.$514.Metal2 vss.$156.Metal1 7.06756e-05f
Cred_8381 vout.$514.Metal2 vss.$513.Metal2 0.0312333f
Cred_8382 vout.$514.Metal2 vss.$515.Metal2 0.0135658f
Cred_8383 vout.$514.Metal2 vss.$519.Metal2 0.0325949f
Cred_8384 vout.$514.Metal2 vss.$521.Metal2 0.00602357f
Cred_8385 vout.$514.Metal2 vss.$851.Metal3 7.06756e-05f
Cred_8386 vout.$514.Metal2 vss.P21.nSD 0.0092866f
Cred_8387 vout.$514.Metal2 vss.P23.nSD 0.00918329f
Cred_8388 vout.$514.Metal2 vss.P25.nSD 0.00152082f
Cred_8389 vout.$516.Metal2 vref 1.85806e-06f
Cred_8390 vout.$516.Metal2 vref.P0.GatPoly 7.2454e-08f
Cred_8391 vout.$516.Metal2 vref.P0.nSD 6.04962e-07f
Cred_8392 vout.$516.Metal2 vref.P0.pSD 7.28008e-07f
Cred_8393 vout.$516.Metal2 vss.$10.Metal1 8.5299e-05f
Cred_8394 vout.$516.Metal2 vss.$127.Metal1 8.11813e-07f
Cred_8395 vout.$516.Metal2 vss.$1282.Metal5 0.00496553f
Cred_8396 vout.$516.Metal2 vss.$406.Metal1 3.94501e-07f
Cred_8397 vout.$516.Metal2 vss.$457.Metal2 1.18564e-08f
Cred_8398 vout.$516.Metal2 vss.$461.Metal2 0.00723168f
Cred_8399 vout.$516.Metal2 vss.$463.Metal2 0.039336f
Cred_8400 vout.$516.Metal2 vss.$467.Metal2 0.0159378f
Cred_8401 vout.$516.Metal2 vss.$469.Metal2 0.0359018f
Cred_8402 vout.$516.Metal2 vss.$799.Metal3 8.5299e-05f
Cred_8403 vout.$516.Metal2 vss.P0.GatPoly 2.90231e-08f
Cred_8404 vout.$516.Metal2 vss.P0.nSD 0.00203998f
Cred_8405 vout.$516.Metal2 vss.P0.pSD 1.15973e-05f
Cred_8406 vout.$516.Metal2 vss.P1.nSD 0.0123314f
Cred_8407 vout.$516.Metal2 vss.P3.nSD 0.0118689f
Cred_8408 vout.$518.Metal2 vref 1.14847e-05f
Cred_8409 vout.$518.Metal2 vref.P0.GatPoly 4.47838e-07f
Cred_8410 vout.$518.Metal2 vref.P0.nSD 3.72821e-06f
Cred_8411 vout.$518.Metal2 vref.P0.pSD 4.49982e-06f
Cred_8412 vout.$518.Metal2 vss.$127.Metal1 6.29025e-07f
Cred_8413 vout.$518.Metal2 vss.$1282.Metal5 0.00511853f
Cred_8414 vout.$518.Metal2 vss.$406.Metal1 5.10614e-07f
Cred_8415 vout.$518.Metal2 vss.$457.Metal2 9.18683e-09f
Cred_8416 vout.$518.Metal2 vss.$467.Metal2 0.00909255f
Cred_8417 vout.$518.Metal2 vss.$469.Metal2 0.0375068f
Cred_8418 vout.$518.Metal2 vss.$473.Metal2 0.0316881f
Cred_8419 vout.$518.Metal2 vss.$475.Metal2 0.0131123f
Cred_8420 vout.$518.Metal2 vss.P0.GatPoly 2.24883e-08f
Cred_8421 vout.$518.Metal2 vss.P0.pSD 1.16807e-05f
Cred_8422 vout.$518.Metal2 vss.P3.nSD 0.0123841f
Cred_8423 vout.$518.Metal2 vss.P5.nSD 0.0119409f
Cred_8424 vout.$520.Metal2 vref 1.57779e-05f
Cred_8425 vout.$520.Metal2 vref.P0.GatPoly 6.15251e-07f
Cred_8426 vout.$520.Metal2 vref.P0.nSD 5.12129e-06f
Cred_8427 vout.$520.Metal2 vref.P0.pSD 6.18196e-06f
Cred_8428 vout.$520.Metal2 vss.$127.Metal1 6.25485e-07f
Cred_8429 vout.$520.Metal2 vss.$1282.Metal5 0.00394935f
Cred_8430 vout.$520.Metal2 vss.$136.Metal1 5.73067e-05f
Cred_8431 vout.$520.Metal2 vss.$406.Metal1 8.47305e-07f
Cred_8432 vout.$520.Metal2 vss.$457.Metal2 9.13512e-09f
Cred_8433 vout.$520.Metal2 vss.$473.Metal2 0.0328944f
Cred_8434 vout.$520.Metal2 vss.$475.Metal2 0.0184718f
Cred_8435 vout.$520.Metal2 vss.$479.Metal2 0.0398297f
Cred_8436 vout.$520.Metal2 vss.$811.Metal3 5.73067e-05f
Cred_8437 vout.$520.Metal2 vss.P0.GatPoly 2.23617e-08f
Cred_8438 vout.$520.Metal2 vss.P0.pSD 1.4986e-05f
Cred_8439 vout.$520.Metal2 vss.P5.nSD 0.0123824f
Cred_8440 vout.$520.Metal2 vss.P7.nSD 0.0119367f
Cred_8441 vout.$522.Metal2 vref 2.52133e-05f
Cred_8442 vout.$522.Metal2 vref.P0.GatPoly 9.83177e-07f
Cred_8443 vout.$522.Metal2 vref.P0.nSD 8.18174e-06f
Cred_8444 vout.$522.Metal2 vref.P0.pSD 9.87883e-06f
Cred_8445 vout.$522.Metal2 vss.$127.Metal1 3.78273e-07f
Cred_8446 vout.$522.Metal2 vss.$1282.Metal5 0.00455727f
Cred_8447 vout.$522.Metal2 vss.$136.Metal1 5.95844e-05f
Cred_8448 vout.$522.Metal2 vss.$406.Metal1 8.53909e-07f
Cred_8449 vout.$522.Metal2 vss.$457.Metal2 5.52463e-09f
Cred_8450 vout.$522.Metal2 vss.$475.Metal2 0.00505345f
Cred_8451 vout.$522.Metal2 vss.$479.Metal2 0.0414128f
Cred_8452 vout.$522.Metal2 vss.$483.Metal2 0.0328006f
Cred_8453 vout.$522.Metal2 vss.$485.Metal2 0.0120269f
Cred_8454 vout.$522.Metal2 vss.$811.Metal3 5.95844e-05f
Cred_8455 vout.$522.Metal2 vss.P0.GatPoly 1.35236e-08f
Cred_8456 vout.$522.Metal2 vss.P0.pSD 1.16008e-05f
Cred_8457 vout.$522.Metal2 vss.P10.nSD 0.0119375f
Cred_8458 vout.$522.Metal2 vss.P7.nSD 0.0123981f
Cred_8459 vout.$524.Metal2 vref 0.000959216f
Cred_8460 vout.$524.Metal2 vref.P0.GatPoly 3.7404e-05f
Cred_8461 vout.$524.Metal2 vref.P0.nSD 0.000770721f
Cred_8462 vout.$524.Metal2 vref.P0.pSD 0.000375831f
Cred_8463 vout.$524.Metal2 vss.$1033.Metal4 1.67501e-08f
Cred_8464 vout.$524.Metal2 vss.$1037.Metal4 1.67501e-08f
Cred_8465 vout.$524.Metal2 vss.$1247.Metal5 4.39667e-06f
Cred_8466 vout.$524.Metal2 vss.$127.Metal1 3.77422e-07f
Cred_8467 vout.$524.Metal2 vss.$1282.Metal5 0.00446001f
Cred_8468 vout.$524.Metal2 vss.$141.Metal1 6.40245e-05f
Cred_8469 vout.$524.Metal2 vss.$406.Metal1 1.41664e-06f
Cred_8470 vout.$524.Metal2 vss.$457.Metal2 5.5122e-09f
Cred_8471 vout.$524.Metal2 vss.$483.Metal2 0.0341815f
Cred_8472 vout.$524.Metal2 vss.$485.Metal2 0.0179632f
Cred_8473 vout.$524.Metal2 vss.$489.Metal2 0.0394931f
Cred_8474 vout.$524.Metal2 vss.$821.Metal3 6.40245e-05f
Cred_8475 vout.$524.Metal2 vss.$825.Metal3 1.97498e-10f
Cred_8476 vout.$524.Metal2 vss.P0.GatPoly 1.34932e-08f
Cred_8477 vout.$524.Metal2 vss.P0.pSD 1.46772e-05f
Cred_8478 vout.$524.Metal2 vss.P10.nSD 0.0124382f
Cred_8479 vout.$524.Metal2 vss.P11.nSD 0.0120013f
Cred_8480 vout.$526.Metal2 vref 7.93599e-05f
Cred_8481 vout.$526.Metal2 vref.P0.GatPoly 3.09459e-06f
Cred_8482 vout.$526.Metal2 vref.P0.nSD 6.48881e-05f
Cred_8483 vout.$526.Metal2 vref.P0.pSD 3.1094e-05f
Cred_8484 vout.$526.Metal2 vss.$127.Metal1 1.79547e-07f
Cred_8485 vout.$526.Metal2 vss.$1300.Metal5 3.40986e-05f
Cred_8486 vout.$526.Metal2 vss.$146.Metal1 7.19781e-05f
Cred_8487 vout.$526.Metal2 vss.$406.Metal1 1.78342e-06f
Cred_8488 vout.$526.Metal2 vss.$457.Metal2 2.62226e-09f
Cred_8489 vout.$526.Metal2 vss.$493.Metal2 0.0345002f
Cred_8490 vout.$526.Metal2 vss.$495.Metal2 0.0172337f
Cred_8491 vout.$526.Metal2 vss.$499.Metal2 0.0397948f
Cred_8492 vout.$526.Metal2 vss.$831.Metal3 7.19781e-05f
Cred_8493 vout.$526.Metal2 vss.P0.GatPoly 6.41899e-09f
Cred_8494 vout.$526.Metal2 vss.P0.pSD 1.08636e-05f
Cred_8495 vout.$526.Metal2 vss.P13.nSD 0.012157f
Cred_8496 vout.$526.Metal2 vss.P15.nSD 0.0122735f
Cred_8497 vout.$528.Metal2 vss.$127.Metal1 1.37138e-07f
Cred_8498 vout.$528.Metal2 vss.$146.Metal1 6.99197e-05f
Cred_8499 vout.$528.Metal2 vss.$150.Metal1 5.89081e-05f
Cred_8500 vout.$528.Metal2 vss.$406.Metal1 2.28697e-06f
Cred_8501 vout.$528.Metal2 vss.$457.Metal2 2.00288e-09f
Cred_8502 vout.$528.Metal2 vss.$495.Metal2 0.00593f
Cred_8503 vout.$528.Metal2 vss.$499.Metal2 0.0386568f
Cred_8504 vout.$528.Metal2 vss.$503.Metal2 0.0409427f
Cred_8505 vout.$528.Metal2 vss.$507.Metal2 0.00499609f
Cred_8506 vout.$528.Metal2 vss.$831.Metal3 6.99197e-05f
Cred_8507 vout.$528.Metal2 vss.$839.Metal3 5.89081e-05f
Cred_8508 vout.$528.Metal2 vss.P0.GatPoly 4.90282e-09f
Cred_8509 vout.$528.Metal2 vss.P0.pSD 1.04046e-05f
Cred_8510 vout.$528.Metal2 vss.P15.nSD 0.0119342f
Cred_8511 vout.$528.Metal2 vss.P17.nSD 0.0122603f
Cred_8512 vout.$530.Metal2 vss.$127.Metal1 1.03824e-07f
Cred_8513 vout.$530.Metal2 vss.$150.Metal1 5.72236e-05f
Cred_8514 vout.$530.Metal2 vss.$406.Metal1 2.9422e-06f
Cred_8515 vout.$530.Metal2 vss.$457.Metal2 1.51634e-09f
Cred_8516 vout.$530.Metal2 vss.$503.Metal2 0.0397719f
Cred_8517 vout.$530.Metal2 vss.$507.Metal2 0.018332f
Cred_8518 vout.$530.Metal2 vss.$509.Metal2 0.0325736f
Cred_8519 vout.$530.Metal2 vss.$839.Metal3 5.72236e-05f
Cred_8520 vout.$530.Metal2 vss.P0.GatPoly 3.71182e-09f
Cred_8521 vout.$530.Metal2 vss.P0.pSD 9.78439e-06f
Cred_8522 vout.$530.Metal2 vss.P17.nSD 0.0119213f
Cred_8523 vout.$530.Metal2 vss.P19.nSD 0.0122646f
Cred_8524 vout.$532.Metal2 vss.$127.Metal1 7.73963e-08f
Cred_8525 vout.$532.Metal2 vss.$406.Metal1 3.79256e-06f
Cred_8526 vout.$532.Metal2 vss.$457.Metal2 1.13036e-09f
Cred_8527 vout.$532.Metal2 vss.$507.Metal2 0.0130933f
Cred_8528 vout.$532.Metal2 vss.$509.Metal2 0.0316421f
Cred_8529 vout.$532.Metal2 vss.$513.Metal2 0.0370785f
Cred_8530 vout.$532.Metal2 vss.$515.Metal2 0.00898873f
Cred_8531 vout.$532.Metal2 vss.P0.GatPoly 2.76699e-09f
Cred_8532 vout.$532.Metal2 vss.P0.pSD 8.96178e-06f
Cred_8533 vout.$532.Metal2 vss.P19.nSD 0.0119254f
Cred_8534 vout.$532.Metal2 vss.P21.nSD 0.0122437f
Cred_8535 vout.$534.Metal2 vss 1.74767e-05f
Cred_8536 vout.$534.Metal2 vss.$1212.Metal5 1.80239e-05f
Cred_8537 vout.$534.Metal2 vss.$1230.Metal5 1.80239e-05f
Cred_8538 vout.$534.Metal2 vss.$127.Metal1 5.61016e-08f
Cred_8539 vout.$534.Metal2 vss.$1282.Metal5 6.89916e-05f
Cred_8540 vout.$534.Metal2 vss.$1300.Metal5 6.89916e-05f
Cred_8541 vout.$534.Metal2 vss.$156.Metal1 8.38492e-05f
Cred_8542 vout.$534.Metal2 vss.$406.Metal1 4.89447e-06f
Cred_8543 vout.$534.Metal2 vss.$457.Metal2 8.19356e-10f
Cred_8544 vout.$534.Metal2 vss.$513.Metal2 0.0360163f
Cred_8545 vout.$534.Metal2 vss.$515.Metal2 0.0158426f
Cred_8546 vout.$534.Metal2 vss.$519.Metal2 0.0386714f
Cred_8547 vout.$534.Metal2 vss.$521.Metal2 0.00715896f
Cred_8548 vout.$534.Metal2 vss.$851.Metal3 8.38492e-05f
Cred_8549 vout.$534.Metal2 vss.P0.GatPoly 2.00569e-09f
Cred_8550 vout.$534.Metal2 vss.P0.pSD 7.88224e-06f
Cred_8551 vout.$534.Metal2 vss.P21.nSD 0.0119083f
Cred_8552 vout.$534.Metal2 vss.P23.nSD 0.0121101f
Cred_8553 vout.$534.Metal2 vss.P25.nSD 0.00201946f
Cred_8554 vout.$584.Metal2 vref 1.5001e-06f
Cred_8555 vout.$584.Metal2 vref.P0.GatPoly 5.84956e-08f
Cred_8556 vout.$584.Metal2 vref.P0.nSD 3.35336e-07f
Cred_8557 vout.$584.Metal2 vref.P0.pSD 1.00228e-06f
Cred_8558 vout.$584.Metal2 vss.$1282.Metal5 0.00623998f
Cred_8559 vout.$586.Metal2 vref 4.60572e-06f
Cred_8560 vout.$586.Metal2 vref.P0.GatPoly 1.79597e-07f
Cred_8561 vout.$586.Metal2 vref.P0.nSD 1.02957e-06f
Cred_8562 vout.$586.Metal2 vref.P0.pSD 3.03581e-06f
Cred_8563 vout.$586.Metal2 vss.$1282.Metal5 0.00495651f
Cred_8564 vout.$588.Metal2 vref 6.37248e-06f
Cred_8565 vout.$588.Metal2 vref.P0.GatPoly 2.48491e-07f
Cred_8566 vout.$588.Metal2 vref.P0.nSD 1.42452e-06f
Cred_8567 vout.$588.Metal2 vref.P0.pSD 4.20035e-06f
Cred_8568 vout.$588.Metal2 vss.$1282.Metal5 0.00369719f
Cred_8569 vout.$590.Metal2 vref 1.03383e-05f
Cred_8570 vout.$590.Metal2 vref.P0.GatPoly 4.03134e-07f
Cred_8571 vout.$590.Metal2 vref.P0.nSD 2.31104e-06f
Cred_8572 vout.$590.Metal2 vref.P0.pSD 6.81436e-06f
Cred_8573 vout.$590.Metal2 vss.$1282.Metal5 0.00423612f
Cred_8574 vout.$592.Metal2 vref 0.000900506f
Cred_8575 vout.$592.Metal2 vref.P0.GatPoly 3.51147e-05f
Cred_8576 vout.$592.Metal2 vref.P0.nSD 0.000201301f
Cred_8577 vout.$592.Metal2 vref.P0.pSD 0.0010754f
Cred_8578 vout.$592.Metal2 vss.$1282.Metal5 0.00411363f
Cred_8579 vout.$594.Metal2 vref 7.23274e-05f
Cred_8580 vout.$594.Metal2 vref.P0.GatPoly 2.82036e-06f
Cred_8581 vout.$594.Metal2 vref.P0.nSD 1.61682e-05f
Cred_8582 vout.$594.Metal2 vref.P0.pSD 8.73517e-05f
Cred_8583 vout.$594.Metal2 vss.$1300.Metal5 3.40979e-05f
Cred_8584 vout.$602.Metal2 vss 1.46764e-05f
Cred_8585 vout.$602.Metal2 vss.$1212.Metal5 1.51359e-05f
Cred_8586 vout.$602.Metal2 vss.$1230.Metal5 1.51359e-05f
Cred_8587 vout.$602.Metal2 vss.$1282.Metal5 5.7937e-05f
Cred_8588 vout.$602.Metal2 vss.$1300.Metal5 5.7937e-05f
Cred_8589 vout.$604.Metal2 vref 3.34304e-07f
Cred_8590 vout.$604.Metal2 vref.P0.GatPoly 1.3036e-08f
Cred_8591 vout.$604.Metal2 vref.P0.nSD 7.4731e-08f
Cred_8592 vout.$604.Metal2 vref.P0.pSD 2.23363e-07f
Cred_8593 vout.$604.Metal2 vss.$1282.Metal5 0.0022135f
Cred_8594 vout.$606.Metal2 vref 1.0007e-06f
Cred_8595 vout.$606.Metal2 vref.P0.GatPoly 3.90217e-08f
Cred_8596 vout.$606.Metal2 vref.P0.nSD 2.23698e-07f
Cred_8597 vout.$606.Metal2 vref.P0.pSD 6.59765e-07f
Cred_8598 vout.$606.Metal2 vss.$1282.Metal5 0.0018461f
Cred_8599 vout.$608.Metal2 vref 1.38457e-06f
Cred_8600 vout.$608.Metal2 vref.P0.GatPoly 5.39905e-08f
Cred_8601 vout.$608.Metal2 vref.P0.nSD 3.0951e-07f
Cred_8602 vout.$608.Metal2 vref.P0.pSD 9.12853e-07f
Cred_8603 vout.$608.Metal2 vss.$1282.Metal5 0.00184552f
Cred_8604 vout.$61.Metal1 vss.$10.Metal1 6.93507e-05f
Cred_8605 vout.$61.Metal1 vss.$463.Metal2 0.0315172f
Cred_8606 vout.$61.Metal1 vss.$467.Metal2 0.0130049f
Cred_8607 vout.$61.Metal1 vss.$469.Metal2 0.0293831f
Cred_8608 vout.$61.Metal1 vss.$799.Metal3 6.93507e-05f
Cred_8609 vout.$61.Metal1 vss.P1.nSD 0.0331707f
Cred_8610 vout.$61.Metal1 vss.P3.nSD 0.03223f
Cred_8611 vout.$610.Metal2 vref 2.24623e-06f
Cred_8612 vout.$610.Metal2 vref.P0.GatPoly 8.75904e-08f
Cred_8613 vout.$610.Metal2 vref.P0.nSD 5.02127e-07f
Cred_8614 vout.$610.Metal2 vref.P0.pSD 1.48095e-06f
Cred_8615 vout.$610.Metal2 vss.$1282.Metal5 0.00184582f
Cred_8616 vout.$612.Metal2 vref 0.000257968f
Cred_8617 vout.$612.Metal2 vref.P0.GatPoly 1.00593e-05f
Cred_8618 vout.$612.Metal2 vref.P0.nSD 5.76667e-05f
Cred_8619 vout.$612.Metal2 vref.P0.pSD 0.000311372f
Cred_8620 vout.$612.Metal2 vss.$1282.Metal5 0.0018112f
Cred_8621 vout.$614.Metal2 vref 4.43371e-05f
Cred_8622 vout.$614.Metal2 vref.P0.GatPoly 1.7289e-06f
Cred_8623 vout.$614.Metal2 vref.P0.nSD 9.91119e-06f
Cred_8624 vout.$614.Metal2 vref.P0.pSD 5.45836e-05f
Cred_8625 vout.$614.Metal2 vss.$1300.Metal5 2.117e-05f
Cred_8626 vout.$62.Metal1 vss.$467.Metal2 0.00717692f
Cred_8627 vout.$62.Metal1 vss.$469.Metal2 0.0296048f
Cred_8628 vout.$62.Metal1 vss.$473.Metal2 0.0259947f
Cred_8629 vout.$62.Metal1 vss.$475.Metal2 0.0107564f
Cred_8630 vout.$62.Metal1 vss.P3.nSD 0.0322904f
Cred_8631 vout.$62.Metal1 vss.P5.nSD 0.0323013f
Cred_8632 vout.$622.Metal2 vss 9.11193e-06f
Cred_8633 vout.$622.Metal2 vss.$1212.Metal5 9.3972e-06f
Cred_8634 vout.$622.Metal2 vss.$1230.Metal5 9.3972e-06f
Cred_8635 vout.$622.Metal2 vss.$1282.Metal5 3.59706e-05f
Cred_8636 vout.$622.Metal2 vss.$1300.Metal5 3.59706e-05f
Cred_8637 vout.$63.Metal1 vss.$136.Metal1 4.70104e-05f
Cred_8638 vout.$63.Metal1 vss.$473.Metal2 0.0260061f
Cred_8639 vout.$63.Metal1 vss.$475.Metal2 0.0147482f
Cred_8640 vout.$63.Metal1 vss.$479.Metal2 0.0326735f
Cred_8641 vout.$63.Metal1 vss.$811.Metal3 4.70104e-05f
Cred_8642 vout.$63.Metal1 vss.P5.nSD 0.0323048f
Cred_8643 vout.$63.Metal1 vss.P7.nSD 0.0322979f
Cred_8644 vout.$64.Metal1 vss.$136.Metal1 4.70311e-05f
Cred_8645 vout.$64.Metal1 vss.$475.Metal2 0.00398878f
Cred_8646 vout.$64.Metal1 vss.$479.Metal2 0.0326879f
Cred_8647 vout.$64.Metal1 vss.$483.Metal2 0.0264615f
Cred_8648 vout.$64.Metal1 vss.$485.Metal2 0.00970256f
Cred_8649 vout.$64.Metal1 vss.$811.Metal3 4.70311e-05f
Cred_8650 vout.$64.Metal1 vss.P10.nSD 0.0317885f
Cred_8651 vout.$64.Metal1 vss.P7.nSD 0.0323014f
Cred_8652 vout.$644.Metal2 vss.$1282.Metal5 0.00165604f
Cred_8653 vout.$646.Metal2 vref 2.32132e-07f
Cred_8654 vout.$646.Metal2 vref.P0.GatPoly 9.05185e-09f
Cred_8655 vout.$646.Metal2 vref.P0.nSD 5.18913e-08f
Cred_8656 vout.$646.Metal2 vref.P0.pSD 1.66051e-07f
Cred_8657 vout.$646.Metal2 vss.$1282.Metal5 0.001582f
Cred_8658 vout.$648.Metal2 vref 3.14805e-07f
Cred_8659 vout.$648.Metal2 vref.P0.GatPoly 1.22756e-08f
Cred_8660 vout.$648.Metal2 vref.P0.nSD 7.03721e-08f
Cred_8661 vout.$648.Metal2 vref.P0.pSD 2.25189e-07f
Cred_8662 vout.$648.Metal2 vss.$1282.Metal5 0.001582f
Cred_8663 vout.$65.Metal1 vss.$141.Metal1 5.07334e-05f
Cred_8664 vout.$65.Metal1 vss.$483.Metal2 0.0273371f
Cred_8665 vout.$65.Metal1 vss.$485.Metal2 0.0143264f
Cred_8666 vout.$65.Metal1 vss.$489.Metal2 0.0312946f
Cred_8667 vout.$65.Metal1 vss.$493.Metal2 1.99623e-05f
Cred_8668 vout.$65.Metal1 vss.$495.Metal2 6.43944e-06f
Cred_8669 vout.$65.Metal1 vss.$821.Metal3 5.07334e-05f
Cred_8670 vout.$65.Metal1 vss.P10.nSD 0.0328115f
Cred_8671 vout.$65.Metal1 vss.P11.nSD 0.0313972f
Cred_8672 vout.$65.Metal1 vss.P13.nSD 5.79585e-06f
Cred_8673 vout.$650.Metal2 vref 4.88938e-07f
Cred_8674 vout.$650.Metal2 vref.P0.GatPoly 1.90658e-08f
Cred_8675 vout.$650.Metal2 vref.P0.nSD 1.09298e-07f
Cred_8676 vout.$650.Metal2 vref.P0.pSD 3.49752e-07f
Cred_8677 vout.$650.Metal2 vss.$1282.Metal5 0.001582f
Cred_8678 vout.$652.Metal2 vref 4.49585e-05f
Cred_8679 vout.$652.Metal2 vref.P0.GatPoly 1.75313e-06f
Cred_8680 vout.$652.Metal2 vref.P0.nSD 1.00501e-05f
Cred_8681 vout.$652.Metal2 vref.P0.pSD 5.89876e-05f
Cred_8682 vout.$652.Metal2 vss.$1282.Metal5 0.00157896f
Cred_8683 vout.$654.Metal2 vref 3.66282e-05f
Cred_8684 vout.$654.Metal2 vref.P0.GatPoly 1.42829e-06f
Cred_8685 vout.$654.Metal2 vref.P0.nSD 8.18794e-06f
Cred_8686 vout.$654.Metal2 vref.P0.pSD 4.94602e-05f
Cred_8687 vout.$654.Metal2 vss.$1300.Metal5 2.49156e-05f
Cred_8688 vout.$66.Metal1 vss.$141.Metal1 3.75121e-08f
Cred_8689 vout.$66.Metal1 vss.$146.Metal1 5.74565e-05f
Cred_8690 vout.$66.Metal1 vss.$485.Metal2 3.18146e-06f
Cred_8691 vout.$66.Metal1 vss.$489.Metal2 2.31391e-05f
Cred_8692 vout.$66.Metal1 vss.$493.Metal2 0.0286107f
Cred_8693 vout.$66.Metal1 vss.$495.Metal2 0.0141022f
Cred_8694 vout.$66.Metal1 vss.$499.Metal2 0.0317662f
Cred_8695 vout.$66.Metal1 vss.$821.Metal3 3.75121e-08f
Cred_8696 vout.$66.Metal1 vss.$831.Metal3 5.74565e-05f
Cred_8697 vout.$66.Metal1 vss.P11.nSD 5.80195e-06f
Cred_8698 vout.$66.Metal1 vss.P13.nSD 0.0332076f
Cred_8699 vout.$66.Metal1 vss.P15.nSD 0.0323107f
Cred_8700 vout.$664.Metal2 vss.$1282.Metal5 0.0010181f
Cred_8701 vout.$666.Metal2 vss.$1282.Metal5 0.0010181f
Cred_8702 vout.$668.Metal2 vss.$1282.Metal5 0.0010181f
Cred_8703 vout.$67.Metal1 vss.$146.Metal1 5.74506e-05f
Cred_8704 vout.$67.Metal1 vss.$150.Metal1 4.70234e-05f
Cred_8705 vout.$67.Metal1 vss.$495.Metal2 0.00487248f
Cred_8706 vout.$67.Metal1 vss.$499.Metal2 0.031763f
Cred_8707 vout.$67.Metal1 vss.$503.Metal2 0.0326825f
Cred_8708 vout.$67.Metal1 vss.$507.Metal2 0.00398813f
Cred_8709 vout.$67.Metal1 vss.$831.Metal3 5.74506e-05f
Cred_8710 vout.$67.Metal1 vss.$839.Metal3 4.70234e-05f
Cred_8711 vout.$67.Metal1 vss.P15.nSD 0.0323099f
Cred_8712 vout.$67.Metal1 vss.P17.nSD 0.0323001f
Cred_8713 vout.$670.Metal2 vss.$1282.Metal5 0.0010181f
Cred_8714 vout.$672.Metal2 vss.$1282.Metal5 0.0010181f
Cred_8715 vout.$68.Metal1 vss.$150.Metal1 4.70186e-05f
Cred_8716 vout.$68.Metal1 vss.$503.Metal2 0.0326792f
Cred_8717 vout.$68.Metal1 vss.$507.Metal2 0.0147471f
Cred_8718 vout.$68.Metal1 vss.$509.Metal2 0.0260019f
Cred_8719 vout.$68.Metal1 vss.$839.Metal3 4.70186e-05f
Cred_8720 vout.$68.Metal1 vss.P17.nSD 0.0322993f
Cred_8721 vout.$68.Metal1 vss.P19.nSD 0.0323035f
Cred_8722 vout.$682.Metal2 vss 8.9456e-06f
Cred_8723 vout.$682.Metal2 vss.$1212.Metal5 9.22567e-06f
Cred_8724 vout.$682.Metal2 vss.$1230.Metal5 9.22567e-06f
Cred_8725 vout.$682.Metal2 vss.$1282.Metal5 3.5314e-05f
Cred_8726 vout.$682.Metal2 vss.$1300.Metal5 3.5314e-05f
Cred_8727 vout.$684.Metal2 vss.$1282.Metal5 0.000111534f
Cred_8728 vout.$686.Metal2 vss.$1282.Metal5 2.70166e-05f
Cred_8729 vout.$69.Metal1 vss.$507.Metal2 0.0107583f
Cred_8730 vout.$69.Metal1 vss.$509.Metal2 0.0259992f
Cred_8731 vout.$69.Metal1 vss.$513.Metal2 0.0293326f
Cred_8732 vout.$69.Metal1 vss.$515.Metal2 0.00711094f
Cred_8733 vout.$69.Metal1 vss.P19.nSD 0.0323027f
Cred_8734 vout.$69.Metal1 vss.P21.nSD 0.0320032f
Cred_8735 vout.$690.Metal2 vss.$1282.Metal5 2.70166e-05f
Cred_8736 vout.$692.Metal2 vss.$1282.Metal5 3.23124e-05f
Cred_8737 vout.$694.Metal2 vss.$1300.Metal5 1.10404e-05f
Cred_8738 vout.$70.Metal1 vss.$156.Metal1 6.59122e-05f
Cred_8739 vout.$70.Metal1 vss.$513.Metal2 0.0298643f
Cred_8740 vout.$70.Metal1 vss.$515.Metal2 0.0128299f
Cred_8741 vout.$70.Metal1 vss.$519.Metal2 0.0299577f
Cred_8742 vout.$70.Metal1 vss.$521.Metal2 4.06823e-05f
Cred_8743 vout.$70.Metal1 vss.$851.Metal3 6.59122e-05f
Cred_8744 vout.$70.Metal1 vss.P21.nSD 0.0325742f
Cred_8745 vout.$70.Metal1 vss.P23.nSD 0.0314102f
Cred_8746 vout.$70.Metal1 vss.P25.nSD 9.58683e-06f
Cred_8747 vout.$712.Metal2 vss.$1282.Metal5 1.58387e-05f
Cred_8748 vout.$722.Metal2 vss 8.9456e-06f
Cred_8749 vout.$722.Metal2 vss.$1212.Metal5 9.22567e-06f
Cred_8750 vout.$722.Metal2 vss.$1230.Metal5 9.22567e-06f
Cred_8751 vout.$722.Metal2 vss.$1282.Metal5 3.5314e-05f
Cred_8752 vout.$722.Metal2 vss.$1300.Metal5 3.5314e-05f
Cred_8753 vout.$724.Metal2 vss.$1282.Metal5 0.00010949f
Cred_8754 vout.$762.Metal2 vss 8.9456e-06f
Cred_8755 vout.$762.Metal2 vss.$1212.Metal5 9.22567e-06f
Cred_8756 vout.$762.Metal2 vss.$1230.Metal5 9.22567e-06f
Cred_8757 vout.$762.Metal2 vss.$1282.Metal5 3.5314e-05f
Cred_8758 vout.$762.Metal2 vss.$1300.Metal5 3.5314e-05f
Cred_8759 vout.$764.Metal2 vss.$1282.Metal5 0.000485622f
Cred_8760 vout.$784.Metal2 vss.$1282.Metal5 0.00168331f
Cred_8761 vout.$800.Metal2 vss 9.99209e-07f
Cred_8762 vout.$800.Metal2 vss.$1212.Metal5 1.03049e-06f
Cred_8763 vout.$800.Metal2 vss.$1230.Metal5 1.03049e-06f
Cred_8764 vout.$800.Metal2 vss.$1282.Metal5 3.94451e-06f
Cred_8765 vout.$800.Metal2 vss.$1300.Metal5 3.94451e-06f
Cred_8766 vout.$802.Metal2 vss 7.75381e-05f
Cred_8767 vout.$802.Metal2 vss.$1212.Metal5 7.99656e-05f
Cred_8768 vout.$802.Metal2 vss.$1230.Metal5 7.99656e-05f
Cred_8769 vout.$802.Metal2 vss.$1282.Metal5 0.000306092f
Cred_8770 vout.$802.Metal2 vss.$1300.Metal5 0.000306092f
Cred_8771 vout.$858.Metal3 vss.$1300.Metal5 0.00106376f
Cred_8772 vout.$858.Metal3 vss.$150.Metal1 1.12099e-05f
Cred_8773 vout.$858.Metal3 vss.$503.Metal2 0.007552f
Cred_8774 vout.$858.Metal3 vss.$507.Metal2 0.00343841f
Cred_8775 vout.$858.Metal3 vss.$509.Metal2 0.00599152f
Cred_8776 vout.$858.Metal3 vss.$839.Metal3 0.0015546f
Cred_8777 vout.$858.Metal3 vss.$841.Metal3 0.00114089f
Cred_8778 vout.$858.Metal3 vss.P17.nSD 0.00134894f
Cred_8779 vout.$858.Metal3 vss.P19.nSD 0.00135133f
Cred_8780 vout.$860.Metal3 vss.$1053.Metal4 8.829e-05f
Cred_8781 vout.$860.Metal3 vss.$1055.Metal4 0.000111382f
Cred_8782 vout.$860.Metal3 vss.$1057.Metal4 7.74235e-05f
Cred_8783 vout.$860.Metal3 vss.$1300.Metal5 0.00185087f
Cred_8784 vout.$860.Metal3 vss.$153.Metal1 6.40227e-07f
Cred_8785 vout.$860.Metal3 vss.$507.Metal2 0.00250023f
Cred_8786 vout.$860.Metal3 vss.$509.Metal2 0.0060698f
Cred_8787 vout.$860.Metal3 vss.$513.Metal2 0.00690114f
Cred_8788 vout.$860.Metal3 vss.$515.Metal2 0.00166632f
Cred_8789 vout.$860.Metal3 vss.$845.Metal3 0.00269804f
Cred_8790 vout.$860.Metal3 vss.P19.nSD 0.00135703f
Cred_8791 vout.$860.Metal3 vss.P21.nSD 0.00135532f
Cred_8792 vout.$862.Metal3 vss 0.00161582f
Cred_8793 vout.$862.Metal3 vss.$1057.Metal4 1.4733e-05f
Cred_8794 vout.$862.Metal3 vss.$1059.Metal4 4.70079e-05f
Cred_8795 vout.$862.Metal3 vss.$1061.Metal4 4.89066e-06f
Cred_8796 vout.$862.Metal3 vss.$1212.Metal5 0.00166641f
Cred_8797 vout.$862.Metal3 vss.$1230.Metal5 0.00166641f
Cred_8798 vout.$862.Metal3 vss.$1282.Metal5 0.00637867f
Cred_8799 vout.$862.Metal3 vss.$1300.Metal5 0.0180181f
Cred_8800 vout.$862.Metal3 vss.$153.Metal1 6.35255e-08f
Cred_8801 vout.$862.Metal3 vss.$156.Metal1 1.4711e-05f
Cred_8802 vout.$862.Metal3 vss.$513.Metal2 0.00630997f
Cred_8803 vout.$862.Metal3 vss.$515.Metal2 0.00280135f
Cred_8804 vout.$862.Metal3 vss.$519.Metal2 0.00686714f
Cred_8805 vout.$862.Metal3 vss.$521.Metal2 0.00360828f
Cred_8806 vout.$862.Metal3 vss.$849.Metal3 0.00167791f
Cred_8807 vout.$862.Metal3 vss.$851.Metal3 0.00102133f
Cred_8808 vout.$862.Metal3 vss.P0.pSD 5.78034e-10f
Cred_8809 vout.$862.Metal3 vss.P21.nSD 0.00124137f
Cred_8810 vout.$862.Metal3 vss.P23.nSD 0.00124789f
Cred_8811 vout.$862.Metal3 vss.P25.nSD 0.000617743f
Cred_8812 vout.$864.Metal3 vss.$10.Metal1 3.93043e-05f
Cred_8813 vout.$864.Metal3 vss.$1009.Metal4 6.95184e-05f
Cred_8814 vout.$864.Metal3 vss.$1011.Metal4 0.000668194f
Cred_8815 vout.$864.Metal3 vss.$1013.Metal4 0.000209665f
Cred_8816 vout.$864.Metal3 vss.$1282.Metal5 0.0466738f
Cred_8817 vout.$864.Metal3 vss.$13.Metal1 9.80067e-06f
Cred_8818 vout.$864.Metal3 vss.$461.Metal2 0.00490896f
Cred_8819 vout.$864.Metal3 vss.$463.Metal2 0.00922124f
Cred_8820 vout.$864.Metal3 vss.$467.Metal2 0.00381341f
Cred_8821 vout.$864.Metal3 vss.$469.Metal2 0.00854119f
Cred_8822 vout.$864.Metal3 vss.$799.Metal3 0.000955598f
Cred_8823 vout.$864.Metal3 vss.$801.Metal3 0.00169947f
Cred_8824 vout.$864.Metal3 vss.$805.Metal3 2.05706e-05f
Cred_8825 vout.$864.Metal3 vss.P0.nSD 0.000909601f
Cred_8826 vout.$864.Metal3 vss.P0.pSD 8.91786e-08f
Cred_8827 vout.$864.Metal3 vss.P1.nSD 0.00181253f
Cred_8828 vout.$864.Metal3 vss.P3.nSD 0.00180713f
Cred_8829 vout.$886.Metal3 vref 0.000146592f
Cred_8830 vout.$886.Metal3 vref.P0.GatPoly 5.71627e-06f
Cred_8831 vout.$886.Metal3 vref.P0.nSD 4.76336e-05f
Cred_8832 vout.$886.Metal3 vref.P0.pSD 5.74363e-05f
Cred_8833 vout.$886.Metal3 vss.$127.Metal1 1.01903e-08f
Cred_8834 vout.$886.Metal3 vss.$1282.Metal5 0.0262205f
Cred_8835 vout.$886.Metal3 vss.$13.Metal1 5.3353e-07f
Cred_8836 vout.$886.Metal3 vss.$406.Metal1 8.27203e-09f
Cred_8837 vout.$886.Metal3 vss.$457.Metal2 1.48828e-10f
Cred_8838 vout.$886.Metal3 vss.$467.Metal2 0.00346486f
Cred_8839 vout.$886.Metal3 vss.$469.Metal2 0.0143155f
Cred_8840 vout.$886.Metal3 vss.$473.Metal2 0.0127651f
Cred_8841 vout.$886.Metal3 vss.$475.Metal2 0.00527258f
Cred_8842 vout.$886.Metal3 vss.$805.Metal3 0.00223774f
Cred_8843 vout.$886.Metal3 vss.P0.GatPoly 3.64313e-10f
Cred_8844 vout.$886.Metal3 vss.P0.pSD 1.89229e-07f
Cred_8845 vout.$886.Metal3 vss.P3.nSD 0.00363858f
Cred_8846 vout.$886.Metal3 vss.P5.nSD 0.00371328f
Cred_8847 vout.$888.Metal3 vref 0.000201306f
Cred_8848 vout.$888.Metal3 vref.P0.GatPoly 7.84982e-06f
Cred_8849 vout.$888.Metal3 vref.P0.nSD 6.54041e-05f
Cred_8850 vout.$888.Metal3 vref.P0.pSD 7.88739e-05f
Cred_8851 vout.$888.Metal3 vss.$127.Metal1 1.01329e-08f
Cred_8852 vout.$888.Metal3 vss.$1282.Metal5 0.0261624f
Cred_8853 vout.$888.Metal3 vss.$136.Metal1 2.33494e-05f
Cred_8854 vout.$888.Metal3 vss.$406.Metal1 1.37265e-08f
Cred_8855 vout.$888.Metal3 vss.$457.Metal2 1.4799e-10f
Cred_8856 vout.$888.Metal3 vss.$473.Metal2 0.0125544f
Cred_8857 vout.$888.Metal3 vss.$475.Metal2 0.00718225f
Cred_8858 vout.$888.Metal3 vss.$479.Metal2 0.0160291f
Cred_8859 vout.$888.Metal3 vss.$809.Metal3 0.000950921f
Cred_8860 vout.$888.Metal3 vss.$811.Metal3 0.00130974f
Cred_8861 vout.$888.Metal3 vss.P0.GatPoly 3.62262e-10f
Cred_8862 vout.$888.Metal3 vss.P0.pSD 2.42775e-07f
Cred_8863 vout.$888.Metal3 vss.P5.nSD 0.00364528f
Cred_8864 vout.$888.Metal3 vss.P7.nSD 0.00371162f
Cred_8865 vout.$890.Metal3 vref 0.000321396f
Cred_8866 vout.$890.Metal3 vref.P0.GatPoly 1.25326e-05f
Cred_8867 vout.$890.Metal3 vref.P0.nSD 0.000104393f
Cred_8868 vout.$890.Metal3 vref.P0.pSD 0.000125926f
Cred_8869 vout.$890.Metal3 vss.$127.Metal1 6.12808e-09f
Cred_8870 vout.$890.Metal3 vss.$1282.Metal5 0.0262034f
Cred_8871 vout.$890.Metal3 vss.$136.Metal1 2.27056e-05f
Cred_8872 vout.$890.Metal3 vss.$138.Metal1 5.3353e-07f
Cred_8873 vout.$890.Metal3 vss.$406.Metal1 1.38335e-08f
Cred_8874 vout.$890.Metal3 vss.$457.Metal2 8.94998e-11f
Cred_8875 vout.$890.Metal3 vss.$475.Metal2 0.0019257f
Cred_8876 vout.$890.Metal3 vss.$479.Metal2 0.015804f
Cred_8877 vout.$890.Metal3 vss.$483.Metal2 0.0132059f
Cred_8878 vout.$890.Metal3 vss.$485.Metal2 0.00483375f
Cred_8879 vout.$890.Metal3 vss.$811.Metal3 2.27056e-05f
Cred_8880 vout.$890.Metal3 vss.$815.Metal3 0.00223774f
Cred_8881 vout.$890.Metal3 vss.P0.GatPoly 2.19085e-10f
Cred_8882 vout.$890.Metal3 vss.P0.pSD 1.87935e-07f
Cred_8883 vout.$890.Metal3 vss.P10.nSD 0.0037119f
Cred_8884 vout.$890.Metal3 vss.P7.nSD 0.00364389f
Cred_8885 vout.$892.Metal3 vref 0.0130802f
Cred_8886 vout.$892.Metal3 vref.P0.GatPoly 0.000510053f
Cred_8887 vout.$892.Metal3 vref.P0.nSD 0.0107502f
Cred_8888 vout.$892.Metal3 vref.P0.pSD 0.00512494f
Cred_8889 vout.$892.Metal3 vss.$1033.Metal4 1.06022e-05f
Cred_8890 vout.$892.Metal3 vss.$1037.Metal4 1.06022e-05f
Cred_8891 vout.$892.Metal3 vss.$1247.Metal5 0.00278292f
Cred_8892 vout.$892.Metal3 vss.$127.Metal1 6.11429e-09f
Cred_8893 vout.$892.Metal3 vss.$1282.Metal5 0.0235806f
Cred_8894 vout.$892.Metal3 vss.$138.Metal1 4.07235e-08f
Cred_8895 vout.$892.Metal3 vss.$141.Metal1 2.70019e-05f
Cred_8896 vout.$892.Metal3 vss.$406.Metal1 2.29498e-08f
Cred_8897 vout.$892.Metal3 vss.$457.Metal2 8.92984e-11f
Cred_8898 vout.$892.Metal3 vss.$483.Metal2 0.0132663f
Cred_8899 vout.$892.Metal3 vss.$485.Metal2 0.00715783f
Cred_8900 vout.$892.Metal3 vss.$489.Metal2 0.0164447f
Cred_8901 vout.$892.Metal3 vss.$493.Metal2 0.00118809f
Cred_8902 vout.$892.Metal3 vss.$495.Metal2 0.000383255f
Cred_8903 vout.$892.Metal3 vss.$819.Metal3 0.00106279f
Cred_8904 vout.$892.Metal3 vss.$821.Metal3 0.00120145f
Cred_8905 vout.$892.Metal3 vss.$825.Metal3 1.25009e-07f
Cred_8906 vout.$892.Metal3 vss.P0.GatPoly 2.18592e-10f
Cred_8907 vout.$892.Metal3 vss.P0.pSD 2.38156e-07f
Cred_8908 vout.$892.Metal3 vss.P10.nSD 0.00371017f
Cred_8909 vout.$892.Metal3 vss.P11.nSD 0.0038619f
Cred_8910 vout.$892.Metal3 vss.P13.nSD 0.000284488f
Cred_8911 vout.$894.Metal3 vref 0.00183663f
Cred_8912 vout.$894.Metal3 vref.P0.GatPoly 7.16182e-05f
Cred_8913 vout.$894.Metal3 vref.P0.nSD 0.00172407f
Cred_8914 vout.$894.Metal3 vref.P0.pSD 0.00071961f
Cred_8915 vout.$894.Metal3 vss.$1033.Metal4 1.03635e-05f
Cred_8916 vout.$894.Metal3 vss.$1037.Metal4 1.03635e-05f
Cred_8917 vout.$894.Metal3 vss.$1247.Metal5 0.00272028f
Cred_8918 vout.$894.Metal3 vss.$1300.Metal5 0.00213338f
Cred_8919 vout.$894.Metal3 vss.$141.Metal1 2.23261e-06f
Cred_8920 vout.$894.Metal3 vss.$143.Metal1 4.48008e-08f
Cred_8921 vout.$894.Metal3 vss.$146.Metal1 2.21336e-05f
Cred_8922 vout.$894.Metal3 vss.$485.Metal2 0.000189351f
Cred_8923 vout.$894.Metal3 vss.$489.Metal2 0.00137717f
Cred_8924 vout.$894.Metal3 vss.$493.Metal2 0.0104121f
Cred_8925 vout.$894.Metal3 vss.$495.Metal2 0.00524208f
Cred_8926 vout.$894.Metal3 vss.$499.Metal2 0.0120578f
Cred_8927 vout.$894.Metal3 vss.$821.Metal3 2.23261e-06f
Cred_8928 vout.$894.Metal3 vss.$825.Metal3 1.22195e-07f
Cred_8929 vout.$894.Metal3 vss.$829.Metal3 0.00117466f
Cred_8930 vout.$894.Metal3 vss.$831.Metal3 0.00108471f
Cred_8931 vout.$894.Metal3 vss.P0.pSD 4.07639e-10f
Cred_8932 vout.$894.Metal3 vss.P11.nSD 0.000284851f
Cred_8933 vout.$894.Metal3 vss.P13.nSD 0.00256988f
Cred_8934 vout.$894.Metal3 vss.P15.nSD 0.00261903f
Cred_8935 vout.$896.Metal3 vss.$1300.Metal5 0.000886628f
Cred_8936 vout.$896.Metal3 vss.$146.Metal1 2.08814e-05f
Cred_8937 vout.$896.Metal3 vss.$148.Metal1 5.3353e-07f
Cred_8938 vout.$896.Metal3 vss.$150.Metal1 1.71098e-05f
Cred_8939 vout.$896.Metal3 vss.$495.Metal2 0.00177098f
Cred_8940 vout.$896.Metal3 vss.$499.Metal2 0.0115678f
Cred_8941 vout.$896.Metal3 vss.$503.Metal2 0.0119148f
Cred_8942 vout.$896.Metal3 vss.$507.Metal2 0.00145111f
Cred_8943 vout.$896.Metal3 vss.$831.Metal3 2.08814e-05f
Cred_8944 vout.$896.Metal3 vss.$835.Metal3 0.00223774f
Cred_8945 vout.$896.Metal3 vss.$839.Metal3 1.71098e-05f
Cred_8946 vout.$896.Metal3 vss.P15.nSD 0.00250384f
Cred_8947 vout.$896.Metal3 vss.P17.nSD 0.00250333f
Cred_8948 vout.$898.Metal3 vss.$150.Metal1 8.05229e-06f
Cred_8949 vout.$898.Metal3 vss.$503.Metal2 0.00559656f
Cred_8950 vout.$898.Metal3 vss.$507.Metal2 0.0025314f
Cred_8951 vout.$898.Metal3 vss.$509.Metal2 0.00446714f
Cred_8952 vout.$898.Metal3 vss.$839.Metal3 8.05229e-06f
Cred_8953 vout.$898.Metal3 vss.P17.nSD 0.00137573f
Cred_8954 vout.$898.Metal3 vss.P19.nSD 0.00137826f
Cred_8955 vout.$900.Metal3 vss.$507.Metal2 0.00184244f
Cred_8956 vout.$900.Metal3 vss.$509.Metal2 0.00445256f
Cred_8957 vout.$900.Metal3 vss.$513.Metal2 0.00508529f
Cred_8958 vout.$900.Metal3 vss.$515.Metal2 0.0012328f
Cred_8959 vout.$900.Metal3 vss.P19.nSD 0.00137632f
Cred_8960 vout.$900.Metal3 vss.P21.nSD 0.00137578f
Cred_8961 vout.$902.Metal3 vss 0.00223946f
Cred_8962 vout.$902.Metal3 vss.$1212.Metal5 0.00230957f
Cred_8963 vout.$902.Metal3 vss.$1230.Metal5 0.00230957f
Cred_8964 vout.$902.Metal3 vss.$1282.Metal5 0.00884055f
Cred_8965 vout.$902.Metal3 vss.$1300.Metal5 0.00884055f
Cred_8966 vout.$902.Metal3 vss.$156.Metal1 1.02678e-05f
Cred_8967 vout.$902.Metal3 vss.$513.Metal2 0.00447829f
Cred_8968 vout.$902.Metal3 vss.$515.Metal2 0.00195647f
Cred_8969 vout.$902.Metal3 vss.$519.Metal2 0.00487049f
Cred_8970 vout.$902.Metal3 vss.$521.Metal2 0.00258636f
Cred_8971 vout.$902.Metal3 vss.$851.Metal3 1.02678e-05f
Cred_8972 vout.$902.Metal3 vss.P21.nSD 0.00121043f
Cred_8973 vout.$902.Metal3 vss.P23.nSD 0.00121486f
Cred_8974 vout.$902.Metal3 vss.P25.nSD 0.000604494f
Cred_8975 vout.$904.Metal3 vref 4.86548e-05f
Cred_8976 vout.$904.Metal3 vref.P0.GatPoly 1.89726e-06f
Cred_8977 vout.$904.Metal3 vref.P0.nSD 1.58414e-05f
Cred_8978 vout.$904.Metal3 vref.P0.pSD 1.90634e-05f
Cred_8979 vout.$904.Metal3 vss.$10.Metal1 1.45397e-05f
Cred_8980 vout.$904.Metal3 vss.$127.Metal1 1.45838e-08f
Cred_8981 vout.$904.Metal3 vss.$1282.Metal5 0.0527741f
Cred_8982 vout.$904.Metal3 vss.$406.Metal1 7.087e-09f
Cred_8983 vout.$904.Metal3 vss.$457.Metal2 2.12994e-10f
Cred_8984 vout.$904.Metal3 vss.$461.Metal2 0.00360715f
Cred_8985 vout.$904.Metal3 vss.$463.Metal2 0.00689252f
Cred_8986 vout.$904.Metal3 vss.$467.Metal2 0.00276846f
Cred_8987 vout.$904.Metal3 vss.$469.Metal2 0.0063332f
Cred_8988 vout.$904.Metal3 vss.$799.Metal3 1.45397e-05f
Cred_8989 vout.$904.Metal3 vss.P0.GatPoly 5.21384e-10f
Cred_8990 vout.$904.Metal3 vss.P0.nSD 0.00096555f
Cred_8991 vout.$904.Metal3 vss.P0.pSD 2.0834e-07f
Cred_8992 vout.$904.Metal3 vss.P1.nSD 0.0019732f
Cred_8993 vout.$904.Metal3 vss.P3.nSD 0.00196429f
Cred_8994 vout.$934.Metal3 vref 0.0102705f
Cred_8995 vout.$934.Metal3 vref.P0.GatPoly 0.00040049f
Cred_8996 vout.$934.Metal3 vref.P0.nSD 0.00914129f
Cred_8997 vout.$934.Metal3 vref.P0.pSD 0.00402407f
Cred_8998 vout.$934.Metal3 vss.$127.Metal1 3.46021e-09f
Cred_8999 vout.$934.Metal3 vss.$1300.Metal5 0.00547001f
Cred_9000 vout.$934.Metal3 vss.$146.Metal1 8.7361e-06f
Cred_9001 vout.$934.Metal3 vss.$406.Metal1 3.43697e-08f
Cred_9002 vout.$934.Metal3 vss.$457.Metal2 5.05359e-11f
Cred_9003 vout.$934.Metal3 vss.$493.Metal2 0.00553963f
Cred_9004 vout.$934.Metal3 vss.$495.Metal2 0.0025279f
Cred_9005 vout.$934.Metal3 vss.$499.Metal2 0.00482997f
Cred_9006 vout.$934.Metal3 vss.$831.Metal3 8.7361e-06f
Cred_9007 vout.$934.Metal3 vss.P0.GatPoly 1.23706e-10f
Cred_9008 vout.$934.Metal3 vss.P0.pSD 2.09362e-07f
Cred_9009 vout.$934.Metal3 vss.P13.nSD 0.00189511f
Cred_9010 vout.$934.Metal3 vss.P15.nSD 0.00145057f
Cred_9011 vout.$936.Metal3 vss.$127.Metal1 2.64291e-09f
Cred_9012 vout.$936.Metal3 vss.$146.Metal1 1.14353e-05f
Cred_9013 vout.$936.Metal3 vss.$150.Metal1 7.14978e-06f
Cred_9014 vout.$936.Metal3 vss.$406.Metal1 4.40741e-08f
Cred_9015 vout.$936.Metal3 vss.$457.Metal2 3.85993e-11f
Cred_9016 vout.$936.Metal3 vss.$495.Metal2 0.000969848f
Cred_9017 vout.$936.Metal3 vss.$499.Metal2 0.0063223f
Cred_9018 vout.$936.Metal3 vss.$503.Metal2 0.00496929f
Cred_9019 vout.$936.Metal3 vss.$507.Metal2 0.000606384f
Cred_9020 vout.$936.Metal3 vss.$831.Metal3 1.14353e-05f
Cred_9021 vout.$936.Metal3 vss.$839.Metal3 7.14978e-06f
Cred_9022 vout.$936.Metal3 vss.P0.GatPoly 9.44865e-11f
Cred_9023 vout.$936.Metal3 vss.P0.pSD 2.00516e-07f
Cred_9024 vout.$936.Metal3 vss.P15.nSD 0.00189546f
Cred_9025 vout.$936.Metal3 vss.P17.nSD 0.00144896f
Cred_9026 vout.$938.Metal3 vss.$127.Metal1 2.00089e-09f
Cred_9027 vout.$938.Metal3 vss.$150.Metal1 9.35888e-06f
Cred_9028 vout.$938.Metal3 vss.$406.Metal1 5.67016e-08f
Cred_9029 vout.$938.Metal3 vss.$457.Metal2 2.92227e-11f
Cred_9030 vout.$938.Metal3 vss.$503.Metal2 0.00650468f
Cred_9031 vout.$938.Metal3 vss.$507.Metal2 0.00242968f
Cred_9032 vout.$938.Metal3 vss.$509.Metal2 0.00395352f
Cred_9033 vout.$938.Metal3 vss.$839.Metal3 9.35888e-06f
Cred_9034 vout.$938.Metal3 vss.P0.GatPoly 7.15336e-11f
Cred_9035 vout.$938.Metal3 vss.P0.pSD 1.88563e-07f
Cred_9036 vout.$938.Metal3 vss.P17.nSD 0.00189335f
Cred_9037 vout.$938.Metal3 vss.P19.nSD 0.00144948f
Cred_9038 vout.$940.Metal3 vss.$127.Metal1 1.49157e-09f
Cred_9039 vout.$940.Metal3 vss.$406.Metal1 7.30898e-08f
Cred_9040 vout.$940.Metal3 vss.$457.Metal2 2.17842e-11f
Cred_9041 vout.$940.Metal3 vss.$507.Metal2 0.0021414f
Cred_9042 vout.$940.Metal3 vss.$509.Metal2 0.00517505f
Cred_9043 vout.$940.Metal3 vss.$513.Metal2 0.00450059f
Cred_9044 vout.$940.Metal3 vss.$515.Metal2 0.00109105f
Cred_9045 vout.$940.Metal3 vss.P0.GatPoly 5.33251e-11f
Cred_9046 vout.$940.Metal3 vss.P0.pSD 1.7271e-07f
Cred_9047 vout.$940.Metal3 vss.P19.nSD 0.00189403f
Cred_9048 vout.$940.Metal3 vss.P21.nSD 0.00144728f
Cred_9049 vout.$942.Metal3 vss 0.00262354f
Cred_9050 vout.$942.Metal3 vss.$1212.Metal5 0.00270568f
Cred_9051 vout.$942.Metal3 vss.$1230.Metal5 0.00270568f
Cred_9052 vout.$942.Metal3 vss.$127.Metal1 1.08118e-09f
Cred_9053 vout.$942.Metal3 vss.$1282.Metal5 0.0103568f
Cred_9054 vout.$942.Metal3 vss.$1300.Metal5 0.0103568f
Cred_9055 vout.$942.Metal3 vss.$156.Metal1 1.03139e-05f
Cred_9056 vout.$942.Metal3 vss.$406.Metal1 9.43254e-08f
Cred_9057 vout.$942.Metal3 vss.$457.Metal2 1.57905e-11f
Cred_9058 vout.$942.Metal3 vss.$513.Metal2 0.00450483f
Cred_9059 vout.$942.Metal3 vss.$515.Metal2 0.00196682f
Cred_9060 vout.$942.Metal3 vss.$519.Metal2 0.00488925f
Cred_9061 vout.$942.Metal3 vss.$521.Metal2 0.00255853f
Cred_9062 vout.$942.Metal3 vss.$851.Metal3 1.03139e-05f
Cred_9063 vout.$942.Metal3 vss.P0.GatPoly 3.86533e-11f
Cred_9064 vout.$942.Metal3 vss.P0.pSD 1.51905e-07f
Cred_9065 vout.$942.Metal3 vss.P21.nSD 0.00144869f
Cred_9066 vout.$942.Metal3 vss.P23.nSD 0.00145093f
Cred_9067 vout.$942.Metal3 vss.P25.nSD 0.000710715f
Cred_9068 vout.P0.GatPoly vref 0.00610862f
Cred_9069 vout.P0.GatPoly vref.P0.GatPoly 0.000231837f
Cred_9070 vout.P0.GatPoly vref.P0.nSD 0.000144302f
Cred_9071 vout.P0.GatPoly vref.P0.pSD 0.000253659f
Cred_9072 vout.P0.GatPoly vss 0.000483662f
Cred_9073 vout.P0.GatPoly vss.$1212.Metal5 0.000498804f
Cred_9074 vout.P0.GatPoly vss.$1230.Metal5 0.000498804f
Cred_9075 vout.P0.GatPoly vss.$127.Metal1 1.07966e-08f
Cred_9076 vout.P0.GatPoly vss.$1282.Metal5 0.00190932f
Cred_9077 vout.P0.GatPoly vss.$1300.Metal5 0.00261354f
Cred_9078 vout.P0.GatPoly vss.$406.Metal1 4.09142e-07f
Cred_9079 vout.P0.GatPoly vss.$457.Metal2 1.57684e-10f
Cred_9080 vout.P0.GatPoly vss.P0.GatPoly 3.85991e-10f
Cred_9081 vout.P0.GatPoly vss.P0.pSD 1.08126e-06f
Cred_9082 vout.P0.nSD vss.$10.Metal1 8.23317e-06f
Cred_9083 vout.P0.nSD vss.$1282.Metal5 0.0065047f
Cred_9084 vout.P0.nSD vss.$463.Metal2 0.00147193f
Cred_9085 vout.P0.nSD vss.$467.Metal2 0.00196885f
Cred_9086 vout.P0.nSD vss.$469.Metal2 0.000894243f
Cred_9087 vout.P0.nSD vss.$799.Metal3 8.23317e-06f
Cred_9088 vout.P0.nSD vss.P1.nSD 0.000972855f
Cred_9089 vout.P0.nSD vss.P3.nSD 0.000950008f
Cred_9090 vout.P0.pSD vss.$1282.Metal5 0.00494752f
Cred_9091 vout.P10.nSD vss.$146.Metal1 7.8743e-06f
Cred_9092 vout.P10.nSD vss.$493.Metal2 0.000858089f
Cred_9093 vout.P10.nSD vss.$495.Metal2 0.000944634f
Cred_9094 vout.P10.nSD vss.$499.Metal2 0.0014795f
Cred_9095 vout.P10.nSD vss.$831.Metal3 7.8743e-06f
Cred_9096 vout.P10.nSD vss.P13.nSD 0.00097083f
Cred_9097 vout.P10.nSD vss.P15.nSD 0.000951759f
Cred_9098 vout.P10.pSD vss.$1300.Metal5 0.00164697f
Cred_9099 vout.P12.nSD vss.$146.Metal1 1.73581e-06f
Cred_9100 vout.P12.nSD vss.$148.Metal1 0.00150504f
Cred_9101 vout.P12.nSD vss.$150.Metal1 1.42062e-06f
Cred_9102 vout.P12.nSD vss.$495.Metal2 0.000147217f
Cred_9103 vout.P12.nSD vss.$499.Metal2 0.0020012f
Cred_9104 vout.P12.nSD vss.$503.Metal2 0.00202888f
Cred_9105 vout.P12.nSD vss.$507.Metal2 0.000120485f
Cred_9106 vout.P12.nSD vss.$831.Metal3 1.73581e-06f
Cred_9107 vout.P12.nSD vss.$835.Metal3 0.00199562f
Cred_9108 vout.P12.nSD vss.$839.Metal3 1.42062e-06f
Cred_9109 vout.P12.nSD vss.P15.nSD 0.000950661f
Cred_9110 vout.P12.nSD vss.P17.nSD 0.000950341f
Cred_9111 vout.P14.nSD vss.$150.Metal1 7.55967e-06f
Cred_9112 vout.P14.nSD vss.$503.Metal2 0.00150733f
Cred_9113 vout.P14.nSD vss.$507.Metal2 0.00202f
Cred_9114 vout.P14.nSD vss.$509.Metal2 0.000785541f
Cred_9115 vout.P14.nSD vss.$839.Metal3 7.55967e-06f
Cred_9116 vout.P14.nSD vss.P17.nSD 0.000951239f
Cred_9117 vout.P14.nSD vss.P19.nSD 0.000950445f
Cred_9118 vout.P16.nSD vss.$153.Metal1 0.00145828f
Cred_9119 vout.P16.nSD vss.$507.Metal2 0.000325052f
Cred_9120 vout.P16.nSD vss.$509.Metal2 0.00181756f
Cred_9121 vout.P16.nSD vss.$513.Metal2 0.00192145f
Cred_9122 vout.P16.nSD vss.$515.Metal2 0.000215619f
Cred_9123 vout.P16.nSD vss.$845.Metal3 0.00193353f
Cred_9124 vout.P16.nSD vss.P19.nSD 0.000950445f
Cred_9125 vout.P16.nSD vss.P21.nSD 0.000944858f
Cred_9126 vout.P18.nSD vss.$1300.Metal5 0.00443016f
Cred_9127 vout.P18.nSD vss.$156.Metal1 8.14418e-06f
Cred_9128 vout.P18.nSD vss.$513.Metal2 0.00089906f
Cred_9129 vout.P18.nSD vss.$515.Metal2 0.00196247f
Cred_9130 vout.P18.nSD vss.$519.Metal2 0.00143149f
Cred_9131 vout.P18.nSD vss.$851.Metal3 8.14418e-06f
Cred_9132 vout.P18.nSD vss.P21.nSD 0.000955159f
Cred_9133 vout.P18.nSD vss.P23.nSD 0.000931663f
Cred_9134 vout.P18.pSD vss 0.000301203f
Cred_9135 vout.P18.pSD vss.$1212.Metal5 0.000310633f
Cred_9136 vout.P18.pSD vss.$1230.Metal5 0.000310633f
Cred_9137 vout.P18.pSD vss.$1282.Metal5 0.00118904f
Cred_9138 vout.P18.pSD vss.$1300.Metal5 0.00118904f
Cred_9139 vout.P2.nSD vss.$1282.Metal5 0.00165027f
Cred_9140 vout.P2.nSD vss.$13.Metal1 0.00146243f
Cred_9141 vout.P2.nSD vss.$467.Metal2 0.000216786f
Cred_9142 vout.P2.nSD vss.$469.Metal2 0.00227841f
Cred_9143 vout.P2.nSD vss.$473.Metal2 0.00216971f
Cred_9144 vout.P2.nSD vss.$475.Metal2 0.000325052f
Cred_9145 vout.P2.nSD vss.$805.Metal3 0.00193768f
Cred_9146 vout.P2.nSD vss.P3.nSD 0.000950008f
Cred_9147 vout.P2.nSD vss.P5.nSD 0.000950445f
Cred_9148 vout.P2.pSD vss.$1282.Metal5 0.00329395f
Cred_9149 vout.P4.nSD vss.$1282.Metal5 0.00328675f
Cred_9150 vout.P4.nSD vss.$136.Metal1 7.55967e-06f
Cred_9151 vout.P4.nSD vss.$473.Metal2 0.000785541f
Cred_9152 vout.P4.nSD vss.$475.Metal2 0.00202f
Cred_9153 vout.P4.nSD vss.$479.Metal2 0.00150733f
Cred_9154 vout.P4.nSD vss.$811.Metal3 7.55967e-06f
Cred_9155 vout.P4.nSD vss.P5.nSD 0.000950445f
Cred_9156 vout.P4.nSD vss.P7.nSD 0.000951239f
Cred_9157 vout.P4.pSD vss.$1282.Metal5 0.00329395f
Cred_9158 vout.P6.nSD vss.$1282.Metal5 0.00165027f
Cred_9159 vout.P6.nSD vss.$136.Metal1 1.42062e-06f
Cred_9160 vout.P6.nSD vss.$138.Metal1 0.00150881f
Cred_9161 vout.P6.nSD vss.$475.Metal2 0.000120485f
Cred_9162 vout.P6.nSD vss.$479.Metal2 0.00234849f
Cred_9163 vout.P6.nSD vss.$483.Metal2 0.00216399f
Cred_9164 vout.P6.nSD vss.$485.Metal2 0.000294386f
Cred_9165 vout.P6.nSD vss.$811.Metal3 1.42062e-06f
Cred_9166 vout.P6.nSD vss.$815.Metal3 0.00199939f
Cred_9167 vout.P6.nSD vss.P10.nSD 0.000938746f
Cred_9168 vout.P6.nSD vss.P7.nSD 0.000950341f
Cred_9169 vout.P6.pSD vss.$1282.Metal5 0.00329395f
Cred_9170 vout.P8.nSD vss.$1282.Metal5 0.0032401f
Cred_9171 vout.P8.nSD vss.$141.Metal1 1.544e-06f
Cred_9172 vout.P8.nSD vss.$483.Metal2 0.000822526f
Cred_9173 vout.P8.nSD vss.$485.Metal2 0.00148634f
Cred_9174 vout.P8.nSD vss.$489.Metal2 0.000952405f
Cred_9175 vout.P8.nSD vss.$821.Metal3 1.544e-06f
Cred_9176 vout.P8.nSD vss.P10.nSD 0.000961958f
Cred_9177 vout.P8.nSD vss.P11.nSD 0.00092992f
Cred_9178 vout.P8.pSD vss.$1282.Metal5 0.00329395f
Cred_9179 vref vss 0.0407531f
Cred_9180 vref vss.$1033.Metal4 0.000441481f
Cred_9181 vref vss.$1037.Metal4 0.000441481f
Cred_9182 vref vss.$1063.Metal4 5.89478e-06f
Cred_9183 vref vss.$1212.Metal5 0.042029f
Cred_9184 vref vss.$1230.Metal5 0.042029f
Cred_9185 vref vss.$1247.Metal5 0.115883f
Cred_9186 vref vss.$127.Metal1 0.000849331f
Cred_9187 vref vss.$1282.Metal5 0.614272f
Cred_9188 vref vss.$1300.Metal5 0.566447f
Cred_9189 vref vss.$141.Metal1 5.01914e-05f
Cred_9190 vref vss.$143.Metal1 0.000174047f
Cred_9191 vref vss.$159.Metal1 0.00160855f
Cred_9192 vref vss.$406.Metal1 0.0387934f
Cred_9193 vref vss.$457.Metal2 1.24044e-05f
Cred_9194 vref vss.$461.Metal2 0.000477661f
Cred_9195 vref vss.$463.Metal2 3.77101e-05f
Cred_9196 vref vss.$485.Metal2 0.00425681f
Cred_9197 vref vss.$489.Metal2 0.0312111f
Cred_9198 vref vss.$493.Metal2 0.0250599f
Cred_9199 vref vss.$495.Metal2 0.0080029f
Cred_9200 vref vss.$519.Metal2 5.89478e-06f
Cred_9201 vref vss.$525.Metal2 2.34926e-05f
Cred_9202 vref vss.$821.Metal3 5.01914e-05f
Cred_9203 vref vss.$825.Metal3 0.000716125f
Cred_9204 vref vss.$851.Metal3 0.000499945f
Cred_9205 vref vss.$855.Metal3 0.00151163f
Cred_9206 vref vss.$857.Metal3 0.00101168f
Cred_9207 vref vss.P0.GatPoly 6.80163e-05f
Cred_9208 vref vss.P0.nSD 0.000137009f
Cred_9209 vref vss.P0.pSD 0.0416941f
Cred_9210 vref vss.P1.GatPoly 0.00162935f
Cred_9211 vref vss.P11.nSD 0.0157337f
Cred_9212 vref vss.P13.nSD 0.0144226f
Cred_9213 vref.P0.GatPoly vss.$1033.Metal4 1.72153e-05f
Cred_9214 vref.P0.GatPoly vss.$1037.Metal4 1.72153e-05f
Cred_9215 vref.P0.GatPoly vss.$1247.Metal5 0.00451877f
Cred_9216 vref.P0.GatPoly vss.$127.Metal1 6.18048e-05f
Cred_9217 vref.P0.GatPoly vss.$1282.Metal5 0.0185312f
Cred_9218 vref.P0.GatPoly vss.$1300.Metal5 0.0132892f
Cred_9219 vref.P0.GatPoly vss.$141.Metal1 1.95718e-06f
Cred_9220 vref.P0.GatPoly vss.$143.Metal1 6.78684e-06f
Cred_9221 vref.P0.GatPoly vss.$406.Metal1 0.000457745f
Cred_9222 vref.P0.GatPoly vss.$457.Metal2 9.0265e-07f
Cred_9223 vref.P0.GatPoly vss.$461.Metal2 1.86261e-05f
Cred_9224 vref.P0.GatPoly vss.$463.Metal2 1.47048e-06f
Cred_9225 vref.P0.GatPoly vss.$485.Metal2 0.000165992f
Cred_9226 vref.P0.GatPoly vss.$489.Metal2 0.00121706f
Cred_9227 vref.P0.GatPoly vss.$493.Metal2 0.000977193f
Cred_9228 vref.P0.GatPoly vss.$495.Metal2 0.000312068f
Cred_9229 vref.P0.GatPoly vss.$821.Metal3 1.95718e-06f
Cred_9230 vref.P0.GatPoly vss.$825.Metal3 2.79248e-05f
Cred_9231 vref.P0.GatPoly vss.P0.GatPoly 3.6778e-06f
Cred_9232 vref.P0.GatPoly vss.P0.nSD 5.34259e-06f
Cred_9233 vref.P0.GatPoly vss.P0.pSD 0.00263797f
Cred_9234 vref.P0.GatPoly vss.P11.nSD 0.000613526f
Cred_9235 vref.P0.GatPoly vss.P13.nSD 0.000562402f
Cred_9236 vref.P0.nSD vss.$1033.Metal4 0.00011596f
Cred_9237 vref.P0.nSD vss.$1037.Metal4 0.00011596f
Cred_9238 vref.P0.nSD vss.$1247.Metal5 0.0304379f
Cred_9239 vref.P0.nSD vss.$127.Metal1 0.000162385f
Cred_9240 vref.P0.nSD vss.$1282.Metal5 0.107986f
Cred_9241 vref.P0.nSD vss.$1300.Metal5 0.0748164f
Cred_9242 vref.P0.nSD vss.$141.Metal1 0.000184526f
Cred_9243 vref.P0.nSD vss.$143.Metal1 0.00315153f
Cred_9244 vref.P0.nSD vss.$406.Metal1 0.00027598f
Cred_9245 vref.P0.nSD vss.$457.Metal2 2.37162e-06f
Cred_9246 vref.P0.nSD vss.$461.Metal2 0.000152705f
Cred_9247 vref.P0.nSD vss.$463.Metal2 1.20557e-05f
Cred_9248 vref.P0.nSD vss.$485.Metal2 0.01565f
Cred_9249 vref.P0.nSD vss.$489.Metal2 0.116872f
Cred_9250 vref.P0.nSD vss.$493.Metal2 0.0940711f
Cred_9251 vref.P0.nSD vss.$495.Metal2 0.0293621f
Cred_9252 vref.P0.nSD vss.$821.Metal3 0.000184526f
Cred_9253 vref.P0.nSD vss.$825.Metal3 0.00413324f
Cred_9254 vref.P0.nSD vss.P0.GatPoly 1.78425e-05f
Cred_9255 vref.P0.nSD vss.P0.nSD 4.3801e-05f
Cred_9256 vref.P0.nSD vss.P0.pSD 0.00250267f
Cred_9257 vref.P0.nSD vss.P11.nSD 0.0796844f
Cred_9258 vref.P0.nSD vss.P13.nSD 0.072744f
Cred_9259 vref.P0.pSD vss.$1033.Metal4 0.000238809f
Cred_9260 vref.P0.pSD vss.$1037.Metal4 0.000238809f
Cred_9261 vref.P0.pSD vss.$1247.Metal5 0.0626842f
Cred_9262 vref.P0.pSD vss.$127.Metal1 0.000202737f
Cred_9263 vref.P0.pSD vss.$1282.Metal5 0.207708f
Cred_9264 vref.P0.pSD vss.$1300.Metal5 0.144915f
Cred_9265 vref.P0.pSD vss.$141.Metal1 1.96655e-05f
Cred_9266 vref.P0.pSD vss.$143.Metal1 6.81932e-05f
Cred_9267 vref.P0.pSD vss.$406.Metal1 0.000418751f
Cred_9268 vref.P0.pSD vss.$457.Metal2 2.96095e-06f
Cred_9269 vref.P0.pSD vss.$461.Metal2 0.000187152f
Cred_9270 vref.P0.pSD vss.$463.Metal2 1.47752e-05f
Cred_9271 vref.P0.pSD vss.$485.Metal2 0.00166786f
Cred_9272 vref.P0.pSD vss.$489.Metal2 0.0122288f
Cred_9273 vref.P0.pSD vss.$493.Metal2 0.00981871f
Cred_9274 vref.P0.pSD vss.$495.Metal2 0.00313562f
Cred_9275 vref.P0.pSD vss.$821.Metal3 1.96655e-05f
Cred_9276 vref.P0.pSD vss.$825.Metal3 0.000281361f
Cred_9277 vref.P0.pSD vss.P0.GatPoly 2.20005e-05f
Cred_9278 vref.P0.pSD vss.P0.nSD 5.36817e-05f
Cred_9279 vref.P0.pSD vss.P0.pSD 0.00335181f
Cred_9280 vref.P0.pSD vss.P11.nSD 0.00616463f
Cred_9281 vref.P0.pSD vss.P13.nSD 0.00565094f
Rred_1 \$I17 \$I17.$692.Metal3 16.8159425828
Rred_2 \$I17 \$I17.$748.Metal3 10.9208544722
Rred_3 \$I17.$689.Metal3 \$I17.$692.Metal3 0.121358489314
Rred_4 \$I17.$689.Metal3 \$I17.P21.GatPoly 106.99383009
Rred_5 \$I17.$689.Metal3 \$I17.P22.GatPoly 106.95336707
Rred_6 \$I17.$689.Metal3 \$I17.P23.GatPoly 106.872517496
Rred_7 \$I17.$689.Metal3 \$I17.P24.GatPoly 160.359314873
Rred_8 \$I17.$689.Metal3 \$I17.P25.GatPoly 320.779297515
Rred_9 \$I17.$692.Metal3 \$I17.$696.Metal3 0.161882730028
Rred_10 \$I17.$692.Metal3 \$I17.$748.Metal3 0.769505538787
Rred_11 \$I17.$692.Metal3 \$I17.P24.GatPoly 320.779297515
Rred_12 \$I17.$692.Metal3 \$I17.P25.GatPoly 160.359314873
Rred_13 \$I17.$692.Metal3 \$I17.P26.GatPoly 106.872517496
Rred_14 \$I17.$692.Metal3 \$I17.P27.GatPoly 142.559576961
Rred_15 \$I17.$692.Metal3 \$I17.P28.GatPoly 213.906780019
Rred_16 \$I17.$692.Metal3 \$I17.P29.GatPoly 427.894486094
Rred_17 \$I17.$696.Metal3 \$I17.$700.Metal3 0.242931211455
Rred_18 \$I17.$696.Metal3 \$I17.P27.GatPoly 427.894486094
Rred_19 \$I17.$696.Metal3 \$I17.P28.GatPoly 213.906780019
Rred_20 \$I17.$696.Metal3 \$I17.P29.GatPoly 142.559576961
Rred_21 \$I17.$696.Metal3 \$I17.P30.GatPoly 106.872517496
Rred_22 \$I17.$696.Metal3 \$I17.P31.GatPoly 213.933695891
Rred_23 \$I17.$696.Metal3 \$I17.P32.GatPoly 321.00171031
Rred_24 \$I17.$696.Metal3 \$I17.P33.GatPoly 642.124863253
Rred_25 \$I17.$700.Metal3 \$I17.$704.Metal3 0.161882730028
Rred_26 \$I17.$700.Metal3 \$I17.P31.GatPoly 214.041621085
Rred_27 \$I17.$700.Metal3 \$I17.P32.GatPoly 160.485679132
Rred_28 \$I17.$700.Metal3 \$I17.P33.GatPoly 128.327862624
Rred_29 \$I17.$700.Metal3 \$I17.P34.GatPoly 106.872517496
Rred_30 \$I17.$700.Metal3 \$I17.P35.GatPoly 142.559576961
Rred_31 \$I17.$700.Metal3 \$I17.P36.GatPoly 213.906780019
Rred_32 \$I17.$700.Metal3 \$I17.P37.GatPoly 427.894486094
Rred_33 \$I17.$704.Metal3 \$I17.P35.GatPoly 427.894486094
Rred_34 \$I17.$704.Metal3 \$I17.P36.GatPoly 213.906780019
Rred_35 \$I17.$704.Metal3 \$I17.P37.GatPoly 142.559576961
Rred_36 \$I17.$704.Metal3 \$I17.P38.GatPoly 106.872517496
Rred_37 \$I17.$704.Metal3 \$I17.P39.GatPoly 106.95336707
Rred_38 \$I17.$704.Metal3 \$I17.P40.GatPoly 106.99383009
Rred_39 \$I17.$748.Metal3 \$I17.$758.Metal3 0.945466142238
Rred_40 \$I17.$748.Metal3 \$I17.$760.Metal3 0.945466142238
Rred_41 \$I17.$748.Metal3 \$I17.P0.GatPoly 11.5223057025
Rred_42 \$I17.$748.Metal3 \$I17.P6.GatPoly 4261.87439027
Rred_43 \$I17.$758.Metal3 \$I17.$760.Metal3 0.0844868776627
Rred_44 \$I17.$758.Metal3 \$I17.P1.GatPoly 182.661591764
Rred_45 \$I17.$758.Metal3 \$I17.P2.GatPoly 182.621078592
Rred_46 \$I17.$758.Metal3 \$I17.P3.GatPoly 182.540097162
Rred_47 \$I17.$758.Metal3 \$I17.P4.GatPoly 182.418737174
Rred_48 \$I17.$758.Metal3 \$I17.P5.GatPoly 182.257132881
Rred_49 \$I17.$758.Metal3 \$I17.P6.GatPoly 380.841200059
Rred_50 \$I17.$760.Metal3 \$I17.$763.Metal3 0.121333177863
Rred_51 \$I17.$760.Metal3 \$I17.P6.GatPoly 380.841200059
Rred_52 \$I17.$760.Metal3 \$I17.P7.GatPoly 182.257132881
Rred_53 \$I17.$760.Metal3 \$I17.P8.GatPoly 273.43623874
Rred_54 \$I17.$760.Metal3 \$I17.P9.GatPoly 546.933137341
Rred_55 \$I17.$763.Metal3 \$I17.$765.Metal3 0.161756638661
Rred_56 \$I17.$763.Metal3 \$I17.P10.GatPoly 182.257132881
Rred_57 \$I17.$763.Metal3 \$I17.P11.GatPoly 729.149828819
Rred_58 \$I17.$763.Metal3 \$I17.P8.GatPoly 546.933137341
Rred_59 \$I17.$763.Metal3 \$I17.P9.GatPoly 273.43623874
Rred_60 \$I17.$765.Metal3 \$I17.$769.Metal3 0.161819438109
Rred_61 \$I17.$765.Metal3 \$I17.P11.GatPoly 243.04994294
Rred_62 \$I17.$765.Metal3 \$I17.P12.GatPoly 182.257132881
Rred_63 \$I17.$765.Metal3 \$I17.P13.GatPoly 243.072400752
Rred_64 \$I17.$765.Metal3 \$I17.P14.GatPoly 364.676004461
Rred_65 \$I17.$765.Metal3 \$I17.P15.GatPoly 729.432909667
Rred_66 \$I17.$769.Metal3 \$I17.P13.GatPoly 729.432909667
Rred_67 \$I17.$769.Metal3 \$I17.P14.GatPoly 364.676004461
Rred_68 \$I17.$769.Metal3 \$I17.P15.GatPoly 243.072400752
Rred_69 \$I17.$769.Metal3 \$I17.P16.GatPoly 182.257132881
Rred_70 \$I17.$769.Metal3 \$I17.P17.GatPoly 182.418737174
Rred_71 \$I17.$769.Metal3 \$I17.P18.GatPoly 182.540097162
Rred_72 \$I17.$769.Metal3 \$I17.P19.GatPoly 182.621078592
Rred_73 \$I17.$769.Metal3 \$I17.P20.GatPoly 182.661591764
Rred_74 \$I17.P1.GatPoly \$I17.P2.GatPoly 274379.840606
Rred_75 \$I17.P1.GatPoly \$I17.P3.GatPoly 411645.845711
Rred_76 \$I17.P1.GatPoly \$I17.P4.GatPoly 823383.012088
Rred_77 \$I17.P13.GatPoly \$I17.P14.GatPoly 1643848.73738
Rred_78 \$I17.P13.GatPoly \$I17.P15.GatPoly 3288062.15077
Rred_79 \$I17.P14.GatPoly \$I17.P15.GatPoly 1643848.73738
Rred_80 \$I17.P17.GatPoly \$I17.P18.GatPoly 822835.351301
Rred_81 \$I17.P17.GatPoly \$I17.P19.GatPoly 823200.391009
Rred_82 \$I17.P17.GatPoly \$I17.P20.GatPoly 823383.012088
Rred_83 \$I17.P18.GatPoly \$I17.P19.GatPoly 411554.545299
Rred_84 \$I17.P18.GatPoly \$I17.P20.GatPoly 411645.845711
Rred_85 \$I17.P19.GatPoly \$I17.P20.GatPoly 274379.840606
Rred_86 \$I17.P2.GatPoly \$I17.P3.GatPoly 411554.545299
Rred_87 \$I17.P2.GatPoly \$I17.P4.GatPoly 823200.391009
Rred_88 \$I17.P21.GatPoly \$I17.P22.GatPoly 282810.093046
Rred_89 \$I17.P24.GatPoly \$I17.P25.GatPoly 847895.835686
Rred_90 \$I17.P27.GatPoly \$I17.P28.GatPoly 565406.400625
Rred_91 \$I17.P27.GatPoly \$I17.P29.GatPoly 1131026.70803
Rred_92 \$I17.P28.GatPoly \$I17.P29.GatPoly 565406.400625
Rred_93 \$I17.P3.GatPoly \$I17.P4.GatPoly 822835.351301
Rred_94 \$I17.P31.GatPoly \$I17.P32.GatPoly 282827.908501
Rred_95 \$I17.P31.GatPoly \$I17.P33.GatPoly 565762.817573
Rred_96 \$I17.P32.GatPoly \$I17.P33.GatPoly 424201.74892
Rred_97 \$I17.P35.GatPoly \$I17.P36.GatPoly 565406.400625
Rred_98 \$I17.P35.GatPoly \$I17.P37.GatPoly 1131026.70803
Rred_99 \$I17.P36.GatPoly \$I17.P37.GatPoly 565406.400625
Rred_100 \$I17.P39.GatPoly \$I17.P40.GatPoly 282810.093046
Rred_101 \$I17.P8.GatPoly \$I17.P9.GatPoly 2465408.57159
Rred_102 \$I26 \$I26.$2169.TopMetal1 16.1204977046
Rred_103 \$I26 \$I26.P1.GatPoly 62.5890291186
Rred_104 \$I26 \$I26.P2.GatPoly 72.9611197484
Rred_105 \$I26.$2169.TopMetal1 \$I26.P1.GatPoly 32.2449650287
Rred_106 \$I26.$2169.TopMetal1 \$I26.P2.GatPoly 37.588516516
Rred_107 \$I26.P1.GatPoly \$I26.P2.GatPoly 21.0243075013
Rred_108 \$I28 \$I28.P0.Metal5 9.26754456851
Rred_109 \$I30 \$I30.P0.Metal1 9.55014819844
Rred_110 \$I33 \$I33.$82.Metal2 6.1504951628
Rred_111 \$I33.$82.Metal2 \$I33.P0.GatPoly 10.4419915525
Rred_112 \$I33.$82.Metal2 \$I33.P1.GatPoly 181.785367693
Rred_113 \$I33.$82.Metal2 \$I33.P2.GatPoly 181.785367693
Rred_114 \$I33.$82.Metal2 \$I33.P3.GatPoly 114.663376941
Rred_115 \$I33.$82.Metal2 \$I33.P4.GatPoly 114.663376941
Rred_116 \$I33.P0.GatPoly \$I33.P3.GatPoly 1423.6300523
Rred_117 \$I33.P0.GatPoly \$I33.P4.GatPoly 1423.6300523
Rred_118 \$I33.P1.GatPoly \$I33.P2.GatPoly 26556.3298354
Rred_119 \$I33.P3.GatPoly \$I33.P4.GatPoly 10161.4324816
Rred_120 vdd vdd.$4071.TopMetal1 0.00599424228649
Rred_121 vdd vdd.$4456.TopMetal1 111.778994692
Rred_122 vdd vdd.$4841.TopMetal1 2084424.19529
Rred_123 vdd vdd.$5226.TopMetal1 38867689368
Rred_124 vdd.$2365.Metal1 vdd.$2367.Metal1 0.0883995609059
Rred_125 vdd.$2365.Metal1 vdd.$2399.Metal1 11187.3619533
Rred_126 vdd.$2365.Metal1 vdd.$2745.Metal2 2.03704056652
Rred_127 vdd.$2365.Metal1 vdd.$2979.Metal3 266.50533199
Rred_128 vdd.$2365.Metal1 vdd.$3213.Metal4 23133.8332313
Rred_129 vdd.$2365.Metal1 vdd.$3480.Metal5 1976121.78544
Rred_130 vdd.$2365.Metal1 vdd.P0.nSD 1.31005351693
Rred_131 vdd.$2365.Metal1 vdd.P1.GatPoly 2022.22030307
Rred_132 vdd.$2365.Metal1 vdd.P2.GatPoly 251522.998504
Rred_133 vdd.$2367.Metal1 vdd.$2370.Metal1 0.134559428923
Rred_134 vdd.$2367.Metal1 vdd.$2745.Metal2 6.05286004003
Rred_135 vdd.$2367.Metal1 vdd.$2747.Metal2 3
Rred_136 vdd.$2367.Metal1 vdd.$2749.Metal2 4.56688030678
Rred_137 vdd.$2367.Metal1 vdd.$2751.Metal2 9.21460098846
Rred_138 vdd.$2367.Metal1 vdd.P0.nSD 5.68980792238
Rred_139 vdd.$2370.Metal1 vdd.$2372.Metal1 0.0883994246216
Rred_140 vdd.$2370.Metal1 vdd.$2749.Metal2 9.21488323132
Rred_141 vdd.$2370.Metal1 vdd.$2751.Metal2 2.60648259286
Rred_142 vdd.$2370.Metal1 vdd.$2755.Metal2 3.03408531623
Rred_143 vdd.$2370.Metal1 vdd.$2987.Metal3 514.984633507
Rred_144 vdd.$2370.Metal1 vdd.P0.nSD 5.70533930584
Rred_145 vdd.$2370.Metal1 vdd.P3.pSD 2611.03699336
Rred_146 vdd.$2372.Metal1 vdd.$2375.Metal1 0.134558869576
Rred_147 vdd.$2372.Metal1 vdd.$2755.Metal2 3.03087840479
Rred_148 vdd.$2372.Metal1 vdd.$2759.Metal2 2.60627932701
Rred_149 vdd.$2372.Metal1 vdd.$2761.Metal2 9.21430868178
Rred_150 vdd.$2372.Metal1 vdd.$2991.Metal3 514.869179601
Rred_151 vdd.$2372.Metal1 vdd.P0.nSD 5.67433925472
Rred_152 vdd.$2375.Metal1 vdd.$2377.Metal1 0.0883990157686
Rred_153 vdd.$2375.Metal1 vdd.$2759.Metal2 9.21515541204
Rred_154 vdd.$2375.Metal1 vdd.$2761.Metal2 4.56673851275
Rred_155 vdd.$2375.Metal1 vdd.$2763.Metal2 3
Rred_156 vdd.$2375.Metal1 vdd.$2765.Metal2 6.05298955111
Rred_157 vdd.$2375.Metal1 vdd.P0.nSD 5.72093407817
Rred_158 vdd.$2377.Metal1 vdd.$2379.Metal1 0.0883955211654
Rred_159 vdd.$2377.Metal1 vdd.$2765.Metal2 6.05273003007
Rred_160 vdd.$2377.Metal1 vdd.$2767.Metal2 3
Rred_161 vdd.$2377.Metal1 vdd.$2769.Metal2 6.05404803237
Rred_162 vdd.$2377.Metal1 vdd.P0.nSD 7.07550195699
Rred_163 vdd.$2379.Metal1 vdd.$2382.Metal1 0.134538560711
Rred_164 vdd.$2379.Metal1 vdd.$2769.Metal2 6.05391833738
Rred_165 vdd.$2379.Metal1 vdd.$2771.Metal2 3
Rred_166 vdd.$2379.Metal1 vdd.$2773.Metal2 4.56587429068
Rred_167 vdd.$2379.Metal1 vdd.$2775.Metal2 9.21249473047
Rred_168 vdd.$2379.Metal1 vdd.P0.nSD 5.67230583869
Rred_169 vdd.$2382.Metal1 vdd.$2385.Metal1 0.134538560711
Rred_170 vdd.$2382.Metal1 vdd.$2773.Metal2 9.21269223899
Rred_171 vdd.$2382.Metal1 vdd.$2775.Metal2 2.60594355069
Rred_172 vdd.$2382.Metal1 vdd.$2779.Metal2 2.60594355069
Rred_173 vdd.$2382.Metal1 vdd.$2781.Metal2 9.21269223899
Rred_174 vdd.$2382.Metal1 vdd.$3011.Metal3 514.869179601
Rred_175 vdd.$2382.Metal1 vdd.P0.nSD 5.70077198117
Rred_176 vdd.$2385.Metal1 vdd.$2387.Metal1 0.0883955211654
Rred_177 vdd.$2385.Metal1 vdd.$2779.Metal2 9.21249473047
Rred_178 vdd.$2385.Metal1 vdd.$2781.Metal2 4.56587429068
Rred_179 vdd.$2385.Metal1 vdd.$2783.Metal2 3
Rred_180 vdd.$2385.Metal1 vdd.$2785.Metal2 6.05391833738
Rred_181 vdd.$2385.Metal1 vdd.P0.nSD 5.67230583869
Rred_182 vdd.$2387.Metal1 vdd.$2389.Metal1 0.0883990157686
Rred_183 vdd.$2387.Metal1 vdd.$2785.Metal2 6.05404803237
Rred_184 vdd.$2387.Metal1 vdd.$2787.Metal2 3
Rred_185 vdd.$2387.Metal1 vdd.$2789.Metal2 6.05273003007
Rred_186 vdd.$2387.Metal1 vdd.P0.nSD 7.07550195699
Rred_187 vdd.$2389.Metal1 vdd.$2392.Metal1 0.134558869576
Rred_188 vdd.$2389.Metal1 vdd.$2789.Metal2 6.05298955111
Rred_189 vdd.$2389.Metal1 vdd.$2791.Metal2 3
Rred_190 vdd.$2389.Metal1 vdd.$2793.Metal2 4.56673851275
Rred_191 vdd.$2389.Metal1 vdd.$2795.Metal2 9.21515541204
Rred_192 vdd.$2389.Metal1 vdd.P0.nSD 5.72093407817
Rred_193 vdd.$2392.Metal1 vdd.$2394.Metal1 0.0883994246216
Rred_194 vdd.$2392.Metal1 vdd.$2793.Metal2 9.21430868178
Rred_195 vdd.$2392.Metal1 vdd.$2795.Metal2 2.60627932701
Rred_196 vdd.$2392.Metal1 vdd.$2799.Metal2 3.03087840479
Rred_197 vdd.$2392.Metal1 vdd.$3031.Metal3 514.869179601
Rred_198 vdd.$2392.Metal1 vdd.P0.nSD 5.67433925472
Rred_199 vdd.$2394.Metal1 vdd.$2397.Metal1 0.134559428923
Rred_200 vdd.$2394.Metal1 vdd.$2799.Metal2 3.03408531623
Rred_201 vdd.$2394.Metal1 vdd.$2803.Metal2 2.60648259286
Rred_202 vdd.$2394.Metal1 vdd.$2805.Metal2 9.21488323132
Rred_203 vdd.$2394.Metal1 vdd.$3035.Metal3 514.984633507
Rred_204 vdd.$2394.Metal1 vdd.P0.nSD 5.70533930584
Rred_205 vdd.$2394.Metal1 vdd.P21.pSD 2611.03699336
Rred_206 vdd.$2397.Metal1 vdd.$2399.Metal1 0.0883995609059
Rred_207 vdd.$2397.Metal1 vdd.$2803.Metal2 9.21460098846
Rred_208 vdd.$2397.Metal1 vdd.$2805.Metal2 4.56688030678
Rred_209 vdd.$2397.Metal1 vdd.$2807.Metal2 3
Rred_210 vdd.$2397.Metal1 vdd.$2809.Metal2 6.05286004003
Rred_211 vdd.$2397.Metal1 vdd.P0.nSD 5.68980792238
Rred_212 vdd.$2399.Metal1 vdd.$2809.Metal2 2.03704056652
Rred_213 vdd.$2399.Metal1 vdd.$3043.Metal3 266.50533199
Rred_214 vdd.$2399.Metal1 vdd.$3277.Metal4 23133.8332313
Rred_215 vdd.$2399.Metal1 vdd.$3496.Metal5 1976121.78544
Rred_216 vdd.$2399.Metal1 vdd.P0.nSD 1.31005351693
Rred_217 vdd.$2399.Metal1 vdd.P1.GatPoly 251522.998504
Rred_218 vdd.$2399.Metal1 vdd.P2.GatPoly 2022.22030307
Rred_219 vdd.$2745.Metal2 vdd.$2747.Metal2 0.0353725490196
Rred_220 vdd.$2745.Metal2 vdd.$2979.Metal3 1.53475662457
Rred_221 vdd.$2745.Metal2 vdd.$3213.Metal4 272.767549995
Rred_222 vdd.$2745.Metal2 vdd.$3480.Metal5 23300.1549081
Rred_223 vdd.$2745.Metal2 vdd.P0.nSD 2007.30263827
Rred_224 vdd.$2747.Metal2 vdd.$2749.Metal2 0.0354011932647
Rred_225 vdd.$2747.Metal2 vdd.$2979.Metal3 6.07074509804
Rred_226 vdd.$2747.Metal2 vdd.$2983.Metal3 6.07074509804
Rred_227 vdd.$2747.Metal2 vdd.$3215.Metal4 514.869179601
Rred_228 vdd.$2747.Metal2 vdd.P0.pSD 3.19877928581
Rred_229 vdd.$2749.Metal2 vdd.$2751.Metal2 0.0354620166296
Rred_230 vdd.$2749.Metal2 vdd.$2983.Metal3 3
Rred_231 vdd.$2749.Metal2 vdd.P0.nSD 940.538103734
Rred_232 vdd.$2749.Metal2 vdd.P0.pSD 40.5178709535
Rred_233 vdd.$2749.Metal2 vdd.P1.pSD 4.34890354054
Rred_234 vdd.$2751.Metal2 vdd.$2755.Metal2 0.071729556187
Rred_235 vdd.$2751.Metal2 vdd.$2983.Metal3 6.07074509804
Rred_236 vdd.$2751.Metal2 vdd.$2987.Metal3 3.03571283578
Rred_237 vdd.$2751.Metal2 vdd.$3219.Metal4 514.869179601
Rred_238 vdd.$2751.Metal2 vdd.P0.nSD 946.703200702
Rred_239 vdd.$2751.Metal2 vdd.P1.pSD 9.36686916425
Rred_240 vdd.$2751.Metal2 vdd.P3.pSD 30.7863446799
Rred_241 vdd.$2755.Metal2 vdd.$2759.Metal2 0.0715792428553
Rred_242 vdd.$2755.Metal2 vdd.$2987.Metal3 3.03855628208
Rred_243 vdd.$2755.Metal2 vdd.$2991.Metal3 3.03537254902
Rred_244 vdd.$2755.Metal2 vdd.$3223.Metal4 514.869179601
Rred_245 vdd.$2755.Metal2 vdd.P0.nSD 2007.30172086
Rred_246 vdd.$2755.Metal2 vdd.P3.pSD 3.29361726219
Rred_247 vdd.$2759.Metal2 vdd.$2761.Metal2 0.0354579968404
Rred_248 vdd.$2759.Metal2 vdd.$2991.Metal3 3.03537254902
Rred_249 vdd.$2759.Metal2 vdd.$2995.Metal3 6.07074509804
Rred_250 vdd.$2759.Metal2 vdd.$3227.Metal4 514.869179601
Rred_251 vdd.$2759.Metal2 vdd.P0.nSD 934.452661509
Rred_252 vdd.$2759.Metal2 vdd.P5.pSD 4.1984653522
Rred_253 vdd.$2761.Metal2 vdd.$2763.Metal2 0.0353725490196
Rred_254 vdd.$2761.Metal2 vdd.$2995.Metal3 3
Rred_255 vdd.$2761.Metal2 vdd.P0.nSD 952.94960424
Rred_256 vdd.$2761.Metal2 vdd.P5.pSD 10.1462912678
Rred_257 vdd.$2763.Metal2 vdd.$2765.Metal2 0.0354449134283
Rred_258 vdd.$2763.Metal2 vdd.$2995.Metal3 6.07074509804
Rred_259 vdd.$2763.Metal2 vdd.$2999.Metal3 6.07074509804
Rred_260 vdd.$2763.Metal2 vdd.$3231.Metal4 514.869179601
Rred_261 vdd.$2763.Metal2 vdd.P7.pSD 13.5226367231
Rred_262 vdd.$2765.Metal2 vdd.$2767.Metal2 0.0353725490196
Rred_263 vdd.$2765.Metal2 vdd.$2999.Metal3 3
Rred_264 vdd.$2765.Metal2 vdd.P0.nSD 2007.29896861
Rred_265 vdd.$2765.Metal2 vdd.P7.pSD 3.80324157836
Rred_266 vdd.$2767.Metal2 vdd.$2769.Metal2 0.0353725490196
Rred_267 vdd.$2767.Metal2 vdd.$2999.Metal3 6.07074509804
Rred_268 vdd.$2767.Metal2 vdd.$3003.Metal3 6.07074509804
Rred_269 vdd.$2767.Metal2 vdd.$3235.Metal4 514.869179601
Rred_270 vdd.$2769.Metal2 vdd.$2771.Metal2 0.0354554665712
Rred_271 vdd.$2769.Metal2 vdd.$3003.Metal3 3
Rred_272 vdd.$2769.Metal2 vdd.P0.nSD 1784.1632144
Rred_273 vdd.$2769.Metal2 vdd.P10.pSD 4.05799886006
Rred_274 vdd.$2771.Metal2 vdd.$2773.Metal2 0.0353725490196
Rred_275 vdd.$2771.Metal2 vdd.$3003.Metal3 6.07074509804
Rred_276 vdd.$2771.Metal2 vdd.$3007.Metal3 6.07074509804
Rred_277 vdd.$2771.Metal2 vdd.$3239.Metal4 514.869179601
Rred_278 vdd.$2771.Metal2 vdd.P10.pSD 11.0672696184
Rred_279 vdd.$2773.Metal2 vdd.$2775.Metal2 0.0354484492076
Rred_280 vdd.$2773.Metal2 vdd.$3007.Metal3 3
Rred_281 vdd.$2773.Metal2 vdd.P0.nSD 1012.44892572
Rred_282 vdd.$2773.Metal2 vdd.P11.pSD 12.17227109
Rred_283 vdd.$2775.Metal2 vdd.$2779.Metal2 0.0715792428553
Rred_284 vdd.$2775.Metal2 vdd.$3007.Metal3 6.07074509804
Rred_285 vdd.$2775.Metal2 vdd.$3011.Metal3 3.03537254902
Rred_286 vdd.$2775.Metal2 vdd.$3243.Metal4 514.869179601
Rred_287 vdd.$2775.Metal2 vdd.P0.nSD 1012.44644602
Rred_288 vdd.$2775.Metal2 vdd.P11.pSD 3.92653906129
Rred_289 vdd.$2779.Metal2 vdd.$2781.Metal2 0.0354484492076
Rred_290 vdd.$2779.Metal2 vdd.$3011.Metal3 3.03537254902
Rred_291 vdd.$2779.Metal2 vdd.$3015.Metal3 6.07074509804
Rred_292 vdd.$2779.Metal2 vdd.$3247.Metal4 514.869179601
Rred_293 vdd.$2779.Metal2 vdd.P0.nSD 1012.44644602
Rred_294 vdd.$2779.Metal2 vdd.P13.pSD 3.92653906129
Rred_295 vdd.$2781.Metal2 vdd.$2783.Metal2 0.0353725490196
Rred_296 vdd.$2781.Metal2 vdd.$3015.Metal3 3
Rred_297 vdd.$2781.Metal2 vdd.P0.nSD 1012.44892572
Rred_298 vdd.$2781.Metal2 vdd.P13.pSD 12.17227109
Rred_299 vdd.$2783.Metal2 vdd.$2785.Metal2 0.0354554665712
Rred_300 vdd.$2783.Metal2 vdd.$3015.Metal3 6.07074509804
Rred_301 vdd.$2783.Metal2 vdd.$3019.Metal3 6.07074509804
Rred_302 vdd.$2783.Metal2 vdd.$3251.Metal4 514.869179601
Rred_303 vdd.$2783.Metal2 vdd.P15.pSD 11.0672696184
Rred_304 vdd.$2785.Metal2 vdd.$2787.Metal2 0.0353725490196
Rred_305 vdd.$2785.Metal2 vdd.$3019.Metal3 3
Rred_306 vdd.$2785.Metal2 vdd.P0.nSD 1784.1632144
Rred_307 vdd.$2785.Metal2 vdd.P15.pSD 4.05799886006
Rred_308 vdd.$2787.Metal2 vdd.$2789.Metal2 0.0353725490196
Rred_309 vdd.$2787.Metal2 vdd.$3019.Metal3 6.07074509804
Rred_310 vdd.$2787.Metal2 vdd.$3023.Metal3 6.07074509804
Rred_311 vdd.$2787.Metal2 vdd.$3255.Metal4 514.869179601
Rred_312 vdd.$2789.Metal2 vdd.$2791.Metal2 0.0354449134283
Rred_313 vdd.$2789.Metal2 vdd.$3023.Metal3 3
Rred_314 vdd.$2789.Metal2 vdd.P0.nSD 2007.29896861
Rred_315 vdd.$2789.Metal2 vdd.P17.pSD 3.80324157836
Rred_316 vdd.$2791.Metal2 vdd.$2793.Metal2 0.0353725490196
Rred_317 vdd.$2791.Metal2 vdd.$3023.Metal3 6.07074509804
Rred_318 vdd.$2791.Metal2 vdd.$3027.Metal3 6.07074509804
Rred_319 vdd.$2791.Metal2 vdd.$3259.Metal4 514.869179601
Rred_320 vdd.$2791.Metal2 vdd.P17.pSD 13.5226367231
Rred_321 vdd.$2793.Metal2 vdd.$2795.Metal2 0.0354579968404
Rred_322 vdd.$2793.Metal2 vdd.$3027.Metal3 3
Rred_323 vdd.$2793.Metal2 vdd.P0.nSD 952.94960424
Rred_324 vdd.$2793.Metal2 vdd.P19.pSD 10.1462912678
Rred_325 vdd.$2795.Metal2 vdd.$2799.Metal2 0.0715792428553
Rred_326 vdd.$2795.Metal2 vdd.$3027.Metal3 6.07074509804
Rred_327 vdd.$2795.Metal2 vdd.$3031.Metal3 3.03537254902
Rred_328 vdd.$2795.Metal2 vdd.$3263.Metal4 514.869179601
Rred_329 vdd.$2795.Metal2 vdd.P0.nSD 934.452661509
Rred_330 vdd.$2795.Metal2 vdd.P19.pSD 4.1984653522
Rred_331 vdd.$2799.Metal2 vdd.$2803.Metal2 0.071729556187
Rred_332 vdd.$2799.Metal2 vdd.$3031.Metal3 3.03537254902
Rred_333 vdd.$2799.Metal2 vdd.$3035.Metal3 3.03855628208
Rred_334 vdd.$2799.Metal2 vdd.$3267.Metal4 514.869179601
Rred_335 vdd.$2799.Metal2 vdd.P0.nSD 2007.30172086
Rred_336 vdd.$2799.Metal2 vdd.P21.pSD 3.29361726219
Rred_337 vdd.$2803.Metal2 vdd.$2805.Metal2 0.0354620166296
Rred_338 vdd.$2803.Metal2 vdd.$3035.Metal3 3.03571283578
Rred_339 vdd.$2803.Metal2 vdd.$3039.Metal3 6.07074509804
Rred_340 vdd.$2803.Metal2 vdd.$3271.Metal4 514.869179601
Rred_341 vdd.$2803.Metal2 vdd.P0.nSD 946.703200702
Rred_342 vdd.$2803.Metal2 vdd.P21.pSD 30.7863446799
Rred_343 vdd.$2803.Metal2 vdd.P23.pSD 9.36686916425
Rred_344 vdd.$2805.Metal2 vdd.$2807.Metal2 0.0354011932647
Rred_345 vdd.$2805.Metal2 vdd.$3039.Metal3 3
Rred_346 vdd.$2805.Metal2 vdd.P0.nSD 940.538103734
Rred_347 vdd.$2805.Metal2 vdd.P23.pSD 4.34890354054
Rred_348 vdd.$2805.Metal2 vdd.P25.pSD 40.5178709535
Rred_349 vdd.$2807.Metal2 vdd.$2809.Metal2 0.0353725490196
Rred_350 vdd.$2807.Metal2 vdd.$3039.Metal3 6.07074509804
Rred_351 vdd.$2807.Metal2 vdd.$3043.Metal3 6.07074509804
Rred_352 vdd.$2807.Metal2 vdd.$3275.Metal4 514.869179601
Rred_353 vdd.$2807.Metal2 vdd.P25.pSD 3.19877928581
Rred_354 vdd.$2809.Metal2 vdd.$3043.Metal3 1.53475662457
Rred_355 vdd.$2809.Metal2 vdd.$3277.Metal4 272.767549995
Rred_356 vdd.$2809.Metal2 vdd.$3496.Metal5 23300.1549081
Rred_357 vdd.$2809.Metal2 vdd.P0.nSD 2007.30263827
Rred_358 vdd.$2979.Metal3 vdd.$2983.Metal3 0.0715792428553
Rred_359 vdd.$2979.Metal3 vdd.$3213.Metal4 1.53469498509
Rred_360 vdd.$2979.Metal3 vdd.$3215.Metal4 6.07074509804
Rred_361 vdd.$2979.Metal3 vdd.$3480.Metal5 268.399312003
Rred_362 vdd.$2983.Metal3 vdd.$2987.Metal3 0.0715792428553
Rred_363 vdd.$2983.Metal3 vdd.$3215.Metal4 3.03537254902
Rred_364 vdd.$2983.Metal3 vdd.$3219.Metal4 3.03537254902
Rred_365 vdd.$2983.Metal3 vdd.$3448.Metal5 514.869179601
Rred_366 vdd.$2987.Metal3 vdd.$2991.Metal3 0.0715792428553
Rred_367 vdd.$2987.Metal3 vdd.$3219.Metal4 3.03537254902
Rred_368 vdd.$2987.Metal3 vdd.$3223.Metal4 3.03537254902
Rred_369 vdd.$2987.Metal3 vdd.$3450.Metal5 514.869179601
Rred_370 vdd.$2987.Metal3 vdd.P3.pSD 2611.03699336
Rred_371 vdd.$2991.Metal3 vdd.$2995.Metal3 0.0715792428553
Rred_372 vdd.$2991.Metal3 vdd.$3223.Metal4 3.03537254902
Rred_373 vdd.$2991.Metal3 vdd.$3227.Metal4 3.03537254902
Rred_374 vdd.$2991.Metal3 vdd.$3452.Metal5 514.869179601
Rred_375 vdd.$2995.Metal3 vdd.$2999.Metal3 0.0715792428553
Rred_376 vdd.$2995.Metal3 vdd.$3227.Metal4 3.03537254902
Rred_377 vdd.$2995.Metal3 vdd.$3231.Metal4 3.03537254902
Rred_378 vdd.$2995.Metal3 vdd.$3454.Metal5 514.869179601
Rred_379 vdd.$2999.Metal3 vdd.$3003.Metal3 0.0715792428553
Rred_380 vdd.$2999.Metal3 vdd.$3231.Metal4 3.03537254902
Rred_381 vdd.$2999.Metal3 vdd.$3235.Metal4 3.03537254902
Rred_382 vdd.$2999.Metal3 vdd.$3456.Metal5 514.869179601
Rred_383 vdd.$3003.Metal3 vdd.$3007.Metal3 0.0715792428553
Rred_384 vdd.$3003.Metal3 vdd.$3235.Metal4 6.07074509804
Rred_385 vdd.$3003.Metal3 vdd.$3237.Metal4 3
Rred_386 vdd.$3003.Metal3 vdd.$3239.Metal4 6.07074509804
Rred_387 vdd.$3007.Metal3 vdd.$3011.Metal3 0.0715792428553
Rred_388 vdd.$3007.Metal3 vdd.$3239.Metal4 3.03537254902
Rred_389 vdd.$3007.Metal3 vdd.$3243.Metal4 3.03537254902
Rred_390 vdd.$3007.Metal3 vdd.$3460.Metal5 514.869179601
Rred_391 vdd.$3011.Metal3 vdd.$3015.Metal3 0.0715792428553
Rred_392 vdd.$3011.Metal3 vdd.$3243.Metal4 3.03537254902
Rred_393 vdd.$3011.Metal3 vdd.$3247.Metal4 3.03537254902
Rred_394 vdd.$3011.Metal3 vdd.$3462.Metal5 514.869179601
Rred_395 vdd.$3015.Metal3 vdd.$3019.Metal3 0.0715792428553
Rred_396 vdd.$3015.Metal3 vdd.$3247.Metal4 3.03537254902
Rred_397 vdd.$3015.Metal3 vdd.$3251.Metal4 3.03537254902
Rred_398 vdd.$3015.Metal3 vdd.$3464.Metal5 514.869179601
Rred_399 vdd.$3019.Metal3 vdd.$3023.Metal3 0.0715792428553
Rred_400 vdd.$3019.Metal3 vdd.$3251.Metal4 6.07074509804
Rred_401 vdd.$3019.Metal3 vdd.$3253.Metal4 3
Rred_402 vdd.$3019.Metal3 vdd.$3255.Metal4 6.07074509804
Rred_403 vdd.$3023.Metal3 vdd.$3027.Metal3 0.0715792428553
Rred_404 vdd.$3023.Metal3 vdd.$3255.Metal4 3.03537254902
Rred_405 vdd.$3023.Metal3 vdd.$3259.Metal4 3.03537254902
Rred_406 vdd.$3023.Metal3 vdd.$3468.Metal5 514.869179601
Rred_407 vdd.$3027.Metal3 vdd.$3031.Metal3 0.0715792428553
Rred_408 vdd.$3027.Metal3 vdd.$3259.Metal4 3.03537254902
Rred_409 vdd.$3027.Metal3 vdd.$3263.Metal4 3.03537254902
Rred_410 vdd.$3027.Metal3 vdd.$3470.Metal5 514.869179601
Rred_411 vdd.$3031.Metal3 vdd.$3035.Metal3 0.0715792428553
Rred_412 vdd.$3031.Metal3 vdd.$3263.Metal4 3.03537254902
Rred_413 vdd.$3031.Metal3 vdd.$3267.Metal4 3.03537254902
Rred_414 vdd.$3031.Metal3 vdd.$3472.Metal5 514.869179601
Rred_415 vdd.$3035.Metal3 vdd.$3039.Metal3 0.0715792428553
Rred_416 vdd.$3035.Metal3 vdd.$3267.Metal4 3.03537254902
Rred_417 vdd.$3035.Metal3 vdd.$3271.Metal4 3.03537254902
Rred_418 vdd.$3035.Metal3 vdd.$3474.Metal5 514.869179601
Rred_419 vdd.$3035.Metal3 vdd.P21.pSD 2611.03699336
Rred_420 vdd.$3039.Metal3 vdd.$3043.Metal3 0.0715792428553
Rred_421 vdd.$3039.Metal3 vdd.$3271.Metal4 3.03537254902
Rred_422 vdd.$3039.Metal3 vdd.$3275.Metal4 3.03537254902
Rred_423 vdd.$3039.Metal3 vdd.$3476.Metal5 514.869179601
Rred_424 vdd.$3043.Metal3 vdd.$3275.Metal4 6.07074509804
Rred_425 vdd.$3043.Metal3 vdd.$3277.Metal4 1.53469498509
Rred_426 vdd.$3043.Metal3 vdd.$3496.Metal5 268.399312003
Rred_427 vdd.$3213.Metal4 vdd.$3215.Metal4 0.0353717555374
Rred_428 vdd.$3213.Metal4 vdd.$3448.Metal5 18.6594179657
Rred_429 vdd.$3213.Metal4 vdd.$3480.Metal5 1.66407488816
Rred_430 vdd.$3213.Metal4 vdd.$3700.TopMetal1 3399.35651447
Rred_431 vdd.$3215.Metal4 vdd.$3219.Metal4 0.0715792428553
Rred_432 vdd.$3215.Metal4 vdd.$3448.Metal5 2.80679160091
Rred_433 vdd.$3215.Metal4 vdd.$3480.Metal5 7.25548899731
Rred_434 vdd.$3215.Metal4 vdd.$3700.TopMetal1 951.057610429
Rred_435 vdd.$3219.Metal4 vdd.$3223.Metal4 0.0715792428553
Rred_436 vdd.$3219.Metal4 vdd.$3448.Metal5 3.02753881799
Rred_437 vdd.$3219.Metal4 vdd.$3450.Metal5 3.03258210865
Rred_438 vdd.$3219.Metal4 vdd.$3615.TopMetal1 1287.66363749
Rred_439 vdd.$3223.Metal4 vdd.$3227.Metal4 0.0715792428553
Rred_440 vdd.$3223.Metal4 vdd.$3450.Metal5 3.02722132926
Rred_441 vdd.$3223.Metal4 vdd.$3452.Metal5 3.03170534544
Rred_442 vdd.$3223.Metal4 vdd.$3615.TopMetal1 3095.07962723
Rred_443 vdd.$3223.Metal4 vdd.$3617.TopMetal1 3095.07962723
Rred_444 vdd.$3227.Metal4 vdd.$3231.Metal4 0.0715792428553
Rred_445 vdd.$3227.Metal4 vdd.$3452.Metal5 3.02696413771
Rred_446 vdd.$3227.Metal4 vdd.$3454.Metal5 3.03079161045
Rred_447 vdd.$3227.Metal4 vdd.$3617.TopMetal1 1929.21810474
Rred_448 vdd.$3231.Metal4 vdd.$3235.Metal4 0.0715792428553
Rred_449 vdd.$3231.Metal4 vdd.$3454.Metal5 3.02676225055
Rred_450 vdd.$3231.Metal4 vdd.$3456.Metal5 3.02980125213
Rred_451 vdd.$3231.Metal4 vdd.$3617.TopMetal1 5151.99826281
Rred_452 vdd.$3231.Metal4 vdd.$3619.TopMetal1 5151.99826281
Rred_453 vdd.$3235.Metal4 vdd.$3237.Metal4 0.0353709530249
Rred_454 vdd.$3235.Metal4 vdd.$3456.Metal5 2.60350335287
Rred_455 vdd.$3235.Metal4 vdd.$3459.Metal5 9.24329410021
Rred_456 vdd.$3235.Metal4 vdd.$3619.TopMetal1 523.238272451
Rred_457 vdd.$3237.Metal4 vdd.$3239.Metal4 0.0353725490196
Rred_458 vdd.$3237.Metal4 vdd.$3456.Metal5 9.24329410021
Rred_459 vdd.$3237.Metal4 vdd.$3459.Metal5 4.58771684964
Rred_460 vdd.$3237.Metal4 vdd.$3619.TopMetal1 300.503868025
Rred_461 vdd.$3239.Metal4 vdd.$3243.Metal4 0.0715792428553
Rred_462 vdd.$3239.Metal4 vdd.$3459.Metal5 3
Rred_463 vdd.$3239.Metal4 vdd.$3460.Metal5 6.07074509804
Rred_464 vdd.$3243.Metal4 vdd.$3247.Metal4 0.0715792428553
Rred_465 vdd.$3243.Metal4 vdd.$3460.Metal5 3.02650357323
Rred_466 vdd.$3243.Metal4 vdd.$3462.Metal5 3.02650357323
Rred_467 vdd.$3247.Metal4 vdd.$3251.Metal4 0.0715792428553
Rred_468 vdd.$3247.Metal4 vdd.$3462.Metal5 3.02650357323
Rred_469 vdd.$3247.Metal4 vdd.$3464.Metal5 3.02650357323
Rred_470 vdd.$3251.Metal4 vdd.$3253.Metal4 0.0353725490196
Rred_471 vdd.$3251.Metal4 vdd.$3464.Metal5 6.07074509804
Rred_472 vdd.$3251.Metal4 vdd.$3465.Metal5 3
Rred_473 vdd.$3253.Metal4 vdd.$3255.Metal4 0.0353709530249
Rred_474 vdd.$3253.Metal4 vdd.$3465.Metal5 4.58771684964
Rred_475 vdd.$3253.Metal4 vdd.$3468.Metal5 9.24329410021
Rred_476 vdd.$3253.Metal4 vdd.$3623.TopMetal1 300.503868025
Rred_477 vdd.$3255.Metal4 vdd.$3259.Metal4 0.0715792428553
Rred_478 vdd.$3255.Metal4 vdd.$3465.Metal5 9.24329410021
Rred_479 vdd.$3255.Metal4 vdd.$3468.Metal5 2.60350335287
Rred_480 vdd.$3255.Metal4 vdd.$3623.TopMetal1 523.238272451
Rred_481 vdd.$3259.Metal4 vdd.$3263.Metal4 0.0715792428553
Rred_482 vdd.$3259.Metal4 vdd.$3468.Metal5 3.02980125213
Rred_483 vdd.$3259.Metal4 vdd.$3470.Metal5 3.02676225055
Rred_484 vdd.$3259.Metal4 vdd.$3623.TopMetal1 5151.99826281
Rred_485 vdd.$3259.Metal4 vdd.$3625.TopMetal1 5151.99826281
Rred_486 vdd.$3263.Metal4 vdd.$3267.Metal4 0.0715792428553
Rred_487 vdd.$3263.Metal4 vdd.$3470.Metal5 3.03079161045
Rred_488 vdd.$3263.Metal4 vdd.$3472.Metal5 3.02696413771
Rred_489 vdd.$3263.Metal4 vdd.$3625.TopMetal1 1929.21810474
Rred_490 vdd.$3267.Metal4 vdd.$3271.Metal4 0.0715792428553
Rred_491 vdd.$3267.Metal4 vdd.$3472.Metal5 3.03170534544
Rred_492 vdd.$3267.Metal4 vdd.$3474.Metal5 3.02722132926
Rred_493 vdd.$3267.Metal4 vdd.$3625.TopMetal1 3095.07962723
Rred_494 vdd.$3267.Metal4 vdd.$3627.TopMetal1 3095.07962723
Rred_495 vdd.$3271.Metal4 vdd.$3275.Metal4 0.0715792428553
Rred_496 vdd.$3271.Metal4 vdd.$3474.Metal5 3.03258210865
Rred_497 vdd.$3271.Metal4 vdd.$3476.Metal5 3.02753881799
Rred_498 vdd.$3271.Metal4 vdd.$3627.TopMetal1 1287.66363749
Rred_499 vdd.$3275.Metal4 vdd.$3277.Metal4 0.0353717555374
Rred_500 vdd.$3275.Metal4 vdd.$3476.Metal5 2.80679160091
Rred_501 vdd.$3275.Metal4 vdd.$3496.Metal5 7.25548899731
Rred_502 vdd.$3275.Metal4 vdd.$3707.TopMetal1 951.057610429
Rred_503 vdd.$3277.Metal4 vdd.$3476.Metal5 18.6594179657
Rred_504 vdd.$3277.Metal4 vdd.$3496.Metal5 1.66407488816
Rred_505 vdd.$3277.Metal4 vdd.$3707.TopMetal1 3399.35651447
Rred_506 vdd.$3448.Metal5 vdd.$3450.Metal5 0.0714477570792
Rred_507 vdd.$3448.Metal5 vdd.$3480.Metal5 0.0858574305423
Rred_508 vdd.$3448.Metal5 vdd.$3615.TopMetal1 15.1826483793
Rred_509 vdd.$3448.Metal5 vdd.$3700.TopMetal1 2.58363226543
Rred_510 vdd.$3450.Metal5 vdd.$3452.Metal5 0.0714064937784
Rred_511 vdd.$3450.Metal5 vdd.$3615.TopMetal1 2.41844190391
Rred_512 vdd.$3450.Metal5 vdd.$3617.TopMetal1 36.4936186112
Rred_513 vdd.$3452.Metal5 vdd.$3454.Metal5 0.0713635157953
Rred_514 vdd.$3452.Metal5 vdd.$3615.TopMetal1 5.04295698518
Rred_515 vdd.$3452.Metal5 vdd.$3617.TopMetal1 4.12783125292
Rred_516 vdd.$3454.Metal5 vdd.$3456.Metal5 0.0713169629623
Rred_517 vdd.$3454.Metal5 vdd.$3617.TopMetal1 2.35158602039
Rred_518 vdd.$3454.Metal5 vdd.$3619.TopMetal1 60.7464370334
Rred_519 vdd.$3456.Metal5 vdd.$3459.Metal5 0.108986291221
Rred_520 vdd.$3456.Metal5 vdd.$3617.TopMetal1 4.76987096183
Rred_521 vdd.$3456.Metal5 vdd.$3619.TopMetal1 2.6900596523
Rred_522 vdd.$3459.Metal5 vdd.$3460.Metal5 0.0353988653984
Rred_523 vdd.$3459.Metal5 vdd.$3462.Metal5 32490.6163314
Rred_524 vdd.$3459.Metal5 vdd.$3619.TopMetal1 3.36756270435
Rred_525 vdd.$3459.Metal5 vdd.$3622.TopMetal1 136.158015225
Rred_526 vdd.$3460.Metal5 vdd.$3462.Metal5 0.0711591312668
Rred_527 vdd.$3460.Metal5 vdd.$3619.TopMetal1 3.48393112655
Rred_528 vdd.$3460.Metal5 vdd.$3622.TopMetal1 6.98246231923
Rred_529 vdd.$3462.Metal5 vdd.$3464.Metal5 0.0711621704472
Rred_530 vdd.$3462.Metal5 vdd.$3619.TopMetal1 6.63690290981
Rred_531 vdd.$3462.Metal5 vdd.$3622.TopMetal1 3.31151785972
Rred_532 vdd.$3464.Metal5 vdd.$3465.Metal5 0.0353989388696
Rred_533 vdd.$3464.Metal5 vdd.$3622.TopMetal1 2.31454600302
Rred_534 vdd.$3465.Metal5 vdd.$3468.Metal5 0.108986291221
Rred_535 vdd.$3465.Metal5 vdd.$3622.TopMetal1 45.1336470587
Rred_536 vdd.$3465.Metal5 vdd.$3623.TopMetal1 3.5431959341
Rred_537 vdd.$3468.Metal5 vdd.$3470.Metal5 0.0713169629623
Rred_538 vdd.$3468.Metal5 vdd.$3623.TopMetal1 2.6900596523
Rred_539 vdd.$3468.Metal5 vdd.$3625.TopMetal1 4.76987096183
Rred_540 vdd.$3470.Metal5 vdd.$3472.Metal5 0.0713635157953
Rred_541 vdd.$3470.Metal5 vdd.$3623.TopMetal1 60.7464370334
Rred_542 vdd.$3470.Metal5 vdd.$3625.TopMetal1 2.35158602039
Rred_543 vdd.$3472.Metal5 vdd.$3474.Metal5 0.0714064937784
Rred_544 vdd.$3472.Metal5 vdd.$3625.TopMetal1 4.12783125292
Rred_545 vdd.$3472.Metal5 vdd.$3627.TopMetal1 5.04295698518
Rred_546 vdd.$3474.Metal5 vdd.$3476.Metal5 0.0714477570792
Rred_547 vdd.$3474.Metal5 vdd.$3625.TopMetal1 36.4936186112
Rred_548 vdd.$3474.Metal5 vdd.$3627.TopMetal1 2.41844190391
Rred_549 vdd.$3476.Metal5 vdd.$3496.Metal5 0.0858574305423
Rred_550 vdd.$3476.Metal5 vdd.$3627.TopMetal1 15.1826483793
Rred_551 vdd.$3476.Metal5 vdd.$3707.TopMetal1 2.58363226543
Rred_552 vdd.$3480.Metal5 vdd.$3700.TopMetal1 1.93614145079
Rred_553 vdd.$3496.Metal5 vdd.$3707.TopMetal1 1.93614145079
Rred_554 vdd.$3615.TopMetal1 vdd.$3617.TopMetal1 0.0184775280108
Rred_555 vdd.$3615.TopMetal1 vdd.$3700.TopMetal1 0.009
Rred_556 vdd.$3617.TopMetal1 vdd.$3619.TopMetal1 0.018477576449
Rred_557 vdd.$3619.TopMetal1 vdd.$3622.TopMetal1 0.0278131851431
Rred_558 vdd.$3622.TopMetal1 vdd.$3623.TopMetal1 0.00921951219512
Rred_559 vdd.$3623.TopMetal1 vdd.$3625.TopMetal1 0.018477576449
Rred_560 vdd.$3625.TopMetal1 vdd.$3627.TopMetal1 0.0184775280108
Rred_561 vdd.$3627.TopMetal1 vdd.$3707.TopMetal1 0.009
Rred_562 vdd.$3700.TopMetal1 vdd.$4071.TopMetal1 0.00899136340388
Rred_563 vdd.$3700.TopMetal1 vdd.$4456.TopMetal1 167.668491556
Rred_564 vdd.$3700.TopMetal1 vdd.$4841.TopMetal1 3126636.28394
Rred_565 vdd.$3700.TopMetal1 vdd.$5226.TopMetal1 58301533884.3
Rred_566 vdd.$3707.TopMetal1 vdd.$4071.TopMetal1 0.00899136340388
Rred_567 vdd.$3707.TopMetal1 vdd.$4456.TopMetal1 167.668491556
Rred_568 vdd.$3707.TopMetal1 vdd.$4841.TopMetal1 3126636.28394
Rred_569 vdd.$3707.TopMetal1 vdd.$5226.TopMetal1 58301533884.3
Rred_570 vdd.$4071.TopMetal1 vdd.$4456.TopMetal1 0.00299730869958
Rred_571 vdd.$4071.TopMetal1 vdd.$4841.TopMetal1 55.8929948454
Rred_572 vdd.$4071.TopMetal1 vdd.$5226.TopMetal1 1042221.42806
Rred_573 vdd.$4071.TopMetal1 vdd.P0.GatPoly 10.8655515784
Rred_574 vdd.$4456.TopMetal1 vdd.$4841.TopMetal1 0.00299728186638
Rred_575 vdd.$4456.TopMetal1 vdd.$5226.TopMetal1 55.8894973461
Rred_576 vdd.$4456.TopMetal1 vdd.P0.GatPoly 202617.841281
Rred_577 vdd.$4841.TopMetal1 vdd.$5226.TopMetal1 0.00299712114325
Rred_578 vdd.$4841.TopMetal1 vdd.P0.GatPoly 3778362222.05
Rred_579 vdd.$5226.TopMetal1 vdd.P0.GatPoly 7.04540896705e+13
Rred_580 vdd.P0.nSD vdd.P1.GatPoly 201.533027723
Rred_581 vdd.P0.nSD vdd.P2.GatPoly 201.533027723
Rred_582 vdd.P1.GatPoly vdd.P2.GatPoly 5654936.26119
Rred_583 vout vout.$1299.Metal4 0.135310918038
Rred_584 vout vout.$1313.Metal4 0.0972664728524
Rred_585 vout vout.P0.GatPoly 13.9567379693
Rred_586 vout.$1002.Metal3 vout.$1042.Metal3 0.368032035556
Rred_587 vout.$1002.Metal3 vout.$1313.Metal4 9.3573229307
Rred_588 vout.$1002.Metal3 vout.$1323.Metal4 9
Rred_589 vout.$1002.Metal3 vout.$1333.Metal4 18.3608
Rred_590 vout.$1002.Metal3 vout.$161.Metal1 488.591993839
Rred_591 vout.$1002.Metal3 vout.$594.Metal2 4.67567670365
Rred_592 vout.$1002.Metal3 vout.$614.Metal2 18.3608
Rred_593 vout.$1004.Metal3 vout.$1044.Metal3 0.368032035556
Rred_594 vout.$1004.Metal3 vout.$1313.Metal4 9.3573229307
Rred_595 vout.$1004.Metal3 vout.$1323.Metal4 9
Rred_596 vout.$1004.Metal3 vout.$1333.Metal4 18.3608
Rred_597 vout.$1004.Metal3 vout.$162.Metal1 488.591993839
Rred_598 vout.$1004.Metal3 vout.$596.Metal2 4.67567670365
Rred_599 vout.$1004.Metal3 vout.$616.Metal2 18.3608
Rred_600 vout.$1006.Metal3 vout.$1046.Metal3 0.368032035556
Rred_601 vout.$1006.Metal3 vout.$1313.Metal4 9.3573229307
Rred_602 vout.$1006.Metal3 vout.$1323.Metal4 9
Rred_603 vout.$1006.Metal3 vout.$1333.Metal4 18.3608
Rred_604 vout.$1006.Metal3 vout.$163.Metal1 488.591993839
Rred_605 vout.$1006.Metal3 vout.$598.Metal2 4.67567670365
Rred_606 vout.$1006.Metal3 vout.$618.Metal2 18.3608
Rred_607 vout.$1008.Metal3 vout.$1048.Metal3 0.368032035556
Rred_608 vout.$1008.Metal3 vout.$1313.Metal4 9.3573229307
Rred_609 vout.$1008.Metal3 vout.$1323.Metal4 9
Rred_610 vout.$1008.Metal3 vout.$1333.Metal4 18.3608
Rred_611 vout.$1008.Metal3 vout.$164.Metal1 488.591993839
Rred_612 vout.$1008.Metal3 vout.$600.Metal2 4.67567670365
Rred_613 vout.$1008.Metal3 vout.$620.Metal2 18.3608
Rred_614 vout.$1010.Metal3 vout.$1050.Metal3 0.368032035556
Rred_615 vout.$1010.Metal3 vout.$1313.Metal4 9.3573229307
Rred_616 vout.$1010.Metal3 vout.$1323.Metal4 9
Rred_617 vout.$1010.Metal3 vout.$1333.Metal4 18.3608
Rred_618 vout.$1010.Metal3 vout.$165.Metal1 488.591993839
Rred_619 vout.$1010.Metal3 vout.$602.Metal2 4.67567670365
Rred_620 vout.$1010.Metal3 vout.$622.Metal2 18.3608
Rred_621 vout.$1032.Metal3 vout.$1072.Metal3 0.367747910173
Rred_622 vout.$1032.Metal3 vout.$1328.Metal4 2.62243923231
Rred_623 vout.$1032.Metal3 vout.$1368.Metal4 19.0026802939
Rred_624 vout.$1032.Metal3 vout.$156.Metal1 583.731950859
Rred_625 vout.$1032.Metal3 vout.$206.Metal1 1015.0040217
Rred_626 vout.$1032.Metal3 vout.$226.Metal1 9570.03791892
Rred_627 vout.$1032.Metal3 vout.$584.Metal2 5.58937337602
Rred_628 vout.$1032.Metal3 vout.$604.Metal2 6.47396180006
Rred_629 vout.$1032.Metal3 vout.$644.Metal2 9.17855300614
Rred_630 vout.$1034.Metal3 vout.$1074.Metal3 0.367749602447
Rred_631 vout.$1034.Metal3 vout.$1329.Metal4 2.62349441415
Rred_632 vout.$1034.Metal3 vout.$1369.Metal4 18.9407505429
Rred_633 vout.$1034.Metal3 vout.$157.Metal1 583.731950859
Rred_634 vout.$1034.Metal3 vout.$207.Metal1 1015.0040217
Rred_635 vout.$1034.Metal3 vout.$227.Metal1 9570.03791892
Rred_636 vout.$1034.Metal3 vout.$586.Metal2 5.58937337602
Rred_637 vout.$1034.Metal3 vout.$606.Metal2 6.47396180006
Rred_638 vout.$1034.Metal3 vout.$646.Metal2 9.17855814646
Rred_639 vout.$1036.Metal3 vout.$1076.Metal3 0.367749602447
Rred_640 vout.$1036.Metal3 vout.$1330.Metal4 2.62349441415
Rred_641 vout.$1036.Metal3 vout.$1370.Metal4 18.9407505429
Rred_642 vout.$1036.Metal3 vout.$158.Metal1 583.731950859
Rred_643 vout.$1036.Metal3 vout.$208.Metal1 1015.0040217
Rred_644 vout.$1036.Metal3 vout.$228.Metal1 9570.03791892
Rred_645 vout.$1036.Metal3 vout.$588.Metal2 5.58937337602
Rred_646 vout.$1036.Metal3 vout.$608.Metal2 6.47396180006
Rred_647 vout.$1036.Metal3 vout.$648.Metal2 9.17855814646
Rred_648 vout.$1038.Metal3 vout.$1078.Metal3 0.367749602447
Rred_649 vout.$1038.Metal3 vout.$1331.Metal4 2.62349441415
Rred_650 vout.$1038.Metal3 vout.$1371.Metal4 18.9407505429
Rred_651 vout.$1038.Metal3 vout.$159.Metal1 583.731950859
Rred_652 vout.$1038.Metal3 vout.$209.Metal1 1015.0040217
Rred_653 vout.$1038.Metal3 vout.$229.Metal1 9570.03791892
Rred_654 vout.$1038.Metal3 vout.$590.Metal2 5.58937337602
Rred_655 vout.$1038.Metal3 vout.$610.Metal2 6.47396180006
Rred_656 vout.$1038.Metal3 vout.$650.Metal2 9.17855814646
Rred_657 vout.$1040.Metal3 vout.$1080.Metal3 0.367749602447
Rred_658 vout.$1040.Metal3 vout.$1332.Metal4 2.62349441415
Rred_659 vout.$1040.Metal3 vout.$1372.Metal4 18.9407505429
Rred_660 vout.$1040.Metal3 vout.$160.Metal1 583.731950859
Rred_661 vout.$1040.Metal3 vout.$210.Metal1 1015.0040217
Rred_662 vout.$1040.Metal3 vout.$230.Metal1 9570.03791892
Rred_663 vout.$1040.Metal3 vout.$592.Metal2 5.58937337602
Rred_664 vout.$1040.Metal3 vout.$612.Metal2 6.47396180006
Rred_665 vout.$1040.Metal3 vout.$652.Metal2 9.17855814646
Rred_666 vout.$1042.Metal3 vout.$1082.Metal3 0.368032035556
Rred_667 vout.$1042.Metal3 vout.$1333.Metal4 18.3608
Rred_668 vout.$1042.Metal3 vout.$1343.Metal4 9
Rred_669 vout.$1042.Metal3 vout.$1353.Metal4 18.3608
Rred_670 vout.$1042.Metal3 vout.$614.Metal2 18.3608
Rred_671 vout.$1042.Metal3 vout.$634.Metal2 9
Rred_672 vout.$1042.Metal3 vout.$654.Metal2 18.3608
Rred_673 vout.$1044.Metal3 vout.$1084.Metal3 0.368032035556
Rred_674 vout.$1044.Metal3 vout.$1333.Metal4 18.3608
Rred_675 vout.$1044.Metal3 vout.$1343.Metal4 9
Rred_676 vout.$1044.Metal3 vout.$1353.Metal4 18.3608
Rred_677 vout.$1044.Metal3 vout.$212.Metal1 1015.0040217
Rred_678 vout.$1044.Metal3 vout.$232.Metal1 9570.03791892
Rred_679 vout.$1044.Metal3 vout.$616.Metal2 9.18031709106
Rred_680 vout.$1044.Metal3 vout.$656.Metal2 9.18031709106
Rred_681 vout.$1046.Metal3 vout.$1086.Metal3 0.368032035556
Rred_682 vout.$1046.Metal3 vout.$1333.Metal4 18.3608
Rred_683 vout.$1046.Metal3 vout.$1343.Metal4 9
Rred_684 vout.$1046.Metal3 vout.$1353.Metal4 18.3608
Rred_685 vout.$1046.Metal3 vout.$213.Metal1 1015.0040217
Rred_686 vout.$1046.Metal3 vout.$233.Metal1 9570.03791892
Rred_687 vout.$1046.Metal3 vout.$618.Metal2 9.18031709106
Rred_688 vout.$1046.Metal3 vout.$658.Metal2 9.18031709106
Rred_689 vout.$1048.Metal3 vout.$1088.Metal3 0.368032035556
Rred_690 vout.$1048.Metal3 vout.$1333.Metal4 18.3608
Rred_691 vout.$1048.Metal3 vout.$1343.Metal4 9
Rred_692 vout.$1048.Metal3 vout.$1353.Metal4 18.3608
Rred_693 vout.$1048.Metal3 vout.$214.Metal1 1015.0040217
Rred_694 vout.$1048.Metal3 vout.$234.Metal1 9570.03791892
Rred_695 vout.$1048.Metal3 vout.$620.Metal2 9.18031709106
Rred_696 vout.$1048.Metal3 vout.$660.Metal2 9.18031709106
Rred_697 vout.$1050.Metal3 vout.$1070.Metal3 0.1804
Rred_698 vout.$1050.Metal3 vout.$1333.Metal4 18.3608
Rred_699 vout.$1050.Metal3 vout.$1343.Metal4 9
Rred_700 vout.$1050.Metal3 vout.$215.Metal1 1015.0040217
Rred_701 vout.$1050.Metal3 vout.$235.Metal1 9570.03791892
Rred_702 vout.$1050.Metal3 vout.$622.Metal2 9.18031709106
Rred_703 vout.$1050.Metal3 vout.$662.Metal2 18.3604683672
Rred_704 vout.$1070.Metal3 vout.$1110.Metal3 0.368032035556
Rred_705 vout.$1070.Metal3 vout.$1353.Metal4 9
Rred_706 vout.$1070.Metal3 vout.$1363.Metal4 18.3608
Rred_707 vout.$1070.Metal3 vout.$662.Metal2 9
Rred_708 vout.$1070.Metal3 vout.$682.Metal2 18.3608
Rred_709 vout.$1072.Metal3 vout.$1112.Metal3 0.368032035556
Rred_710 vout.$1072.Metal3 vout.$1328.Metal4 19.0025127797
Rred_711 vout.$1072.Metal3 vout.$1368.Metal4 6.16933091943
Rred_712 vout.$1072.Metal3 vout.$644.Metal2 18.3537448681
Rred_713 vout.$1072.Metal3 vout.$664.Metal2 9
Rred_714 vout.$1072.Metal3 vout.$684.Metal2 18.3608
Rred_715 vout.$1074.Metal3 vout.$1114.Metal3 0.368032035556
Rred_716 vout.$1074.Metal3 vout.$1329.Metal4 19.1164594026
Rred_717 vout.$1074.Metal3 vout.$1369.Metal4 6.15596610874
Rred_718 vout.$1074.Metal3 vout.$646.Metal2 18.3537869052
Rred_719 vout.$1074.Metal3 vout.$666.Metal2 9
Rred_720 vout.$1074.Metal3 vout.$686.Metal2 18.3608
Rred_721 vout.$1076.Metal3 vout.$1096.Metal3 0.1804
Rred_722 vout.$1076.Metal3 vout.$1330.Metal4 19.1164594026
Rred_723 vout.$1076.Metal3 vout.$1370.Metal4 9.26095869361
Rred_724 vout.$1076.Metal3 vout.$648.Metal2 18.3537869052
Rred_725 vout.$1076.Metal3 vout.$668.Metal2 9
Rred_726 vout.$1078.Metal3 vout.$1118.Metal3 0.368032035556
Rred_727 vout.$1078.Metal3 vout.$1331.Metal4 19.1164594026
Rred_728 vout.$1078.Metal3 vout.$1371.Metal4 6.15596610874
Rred_729 vout.$1078.Metal3 vout.$650.Metal2 18.3537869052
Rred_730 vout.$1078.Metal3 vout.$670.Metal2 9
Rred_731 vout.$1078.Metal3 vout.$690.Metal2 18.3608
Rred_732 vout.$1080.Metal3 vout.$1140.Metal3 0.570418066492
Rred_733 vout.$1080.Metal3 vout.$1332.Metal4 19.1164594026
Rred_734 vout.$1080.Metal3 vout.$1372.Metal4 4.65530584761
Rred_735 vout.$1080.Metal3 vout.$652.Metal2 18.3537869052
Rred_736 vout.$1080.Metal3 vout.$672.Metal2 9
Rred_737 vout.$1080.Metal3 vout.$692.Metal2 13.9492275195
Rred_738 vout.$1080.Metal3 vout.$712.Metal2 28.4576640711
Rred_739 vout.$1082.Metal3 vout.$1122.Metal3 0.368032035556
Rred_740 vout.$1082.Metal3 vout.$1353.Metal4 18.3608
Rred_741 vout.$1082.Metal3 vout.$1363.Metal4 9
Rred_742 vout.$1082.Metal3 vout.$1373.Metal4 18.3608
Rred_743 vout.$1082.Metal3 vout.$654.Metal2 18.3608
Rred_744 vout.$1082.Metal3 vout.$674.Metal2 9
Rred_745 vout.$1082.Metal3 vout.$694.Metal2 18.3608
Rred_746 vout.$1084.Metal3 vout.$1124.Metal3 0.368032035556
Rred_747 vout.$1084.Metal3 vout.$1353.Metal4 18.3608
Rred_748 vout.$1084.Metal3 vout.$1363.Metal4 9
Rred_749 vout.$1084.Metal3 vout.$1373.Metal4 18.3608
Rred_750 vout.$1084.Metal3 vout.$656.Metal2 18.3608
Rred_751 vout.$1084.Metal3 vout.$676.Metal2 9
Rred_752 vout.$1084.Metal3 vout.$696.Metal2 18.3608
Rred_753 vout.$1086.Metal3 vout.$1126.Metal3 0.368032035556
Rred_754 vout.$1086.Metal3 vout.$1353.Metal4 18.3608
Rred_755 vout.$1086.Metal3 vout.$1363.Metal4 9
Rred_756 vout.$1086.Metal3 vout.$1373.Metal4 18.3608
Rred_757 vout.$1086.Metal3 vout.$658.Metal2 18.3608
Rred_758 vout.$1086.Metal3 vout.$678.Metal2 9
Rred_759 vout.$1086.Metal3 vout.$698.Metal2 18.3608
Rred_760 vout.$1088.Metal3 vout.$1128.Metal3 0.368032035556
Rred_761 vout.$1088.Metal3 vout.$1353.Metal4 18.3608
Rred_762 vout.$1088.Metal3 vout.$1363.Metal4 9
Rred_763 vout.$1088.Metal3 vout.$1373.Metal4 18.3608
Rred_764 vout.$1088.Metal3 vout.$660.Metal2 18.3608
Rred_765 vout.$1088.Metal3 vout.$680.Metal2 9
Rred_766 vout.$1088.Metal3 vout.$700.Metal2 18.3608
Rred_767 vout.$1096.Metal3 vout.$1156.Metal3 0.570418066492
Rred_768 vout.$1096.Metal3 vout.$1370.Metal4 4.5884275195
Rred_769 vout.$1096.Metal3 vout.$268.Metal1 1816.75394379
Rred_770 vout.$1096.Metal3 vout.$288.Metal1 1867.21933112
Rred_771 vout.$1096.Metal3 vout.$668.Metal2 18.3598471625
Rred_772 vout.$1096.Metal3 vout.$708.Metal2 7.92674156761
Rred_773 vout.$1096.Metal3 vout.$728.Metal2 28.4576640711
Rred_774 vout.$11.Metal1 vout.$1235.Metal4 10183.3879352
Rred_775 vout.$11.Metal1 vout.$1264.Metal4 82954.0323074
Rred_776 vout.$11.Metal1 vout.$436.Metal2 5.34064323046
Rred_777 vout.$11.Metal1 vout.$456.Metal2 25.1436636536
Rred_778 vout.$11.Metal1 vout.$61.Metal1 0.600729620506
Rred_779 vout.$11.Metal1 vout.$864.Metal3 526.040795624
Rred_780 vout.$11.Metal1 vout.P0.nSD 8.65123602902
Rred_781 vout.$1110.Metal3 vout.$1150.Metal3 0.368032035556
Rred_782 vout.$1110.Metal3 vout.$1363.Metal4 18.3608
Rred_783 vout.$1110.Metal3 vout.$1373.Metal4 9
Rred_784 vout.$1110.Metal3 vout.$1384.Metal4 18.3608
Rred_785 vout.$1110.Metal3 vout.$275.Metal1 1816.75394379
Rred_786 vout.$1110.Metal3 vout.$295.Metal1 1867.21933112
Rred_787 vout.$1110.Metal3 vout.$682.Metal2 9.18016178444
Rred_788 vout.$1110.Metal3 vout.$722.Metal2 9.18016178444
Rred_789 vout.$1112.Metal3 vout.$1152.Metal3 0.367835007877
Rred_790 vout.$1112.Metal3 vout.$1368.Metal4 6.25120781147
Rred_791 vout.$1112.Metal3 vout.$1408.Metal4 18.11604913
Rred_792 vout.$1112.Metal3 vout.$684.Metal2 18.3608
Rred_793 vout.$1112.Metal3 vout.$704.Metal2 9
Rred_794 vout.$1112.Metal3 vout.$724.Metal2 18.3534550231
Rred_795 vout.$1114.Metal3 vout.$1154.Metal3 0.368032035556
Rred_796 vout.$1114.Metal3 vout.$1369.Metal4 4.54465248289
Rred_797 vout.$1114.Metal3 vout.$686.Metal2 18.3608
Rred_798 vout.$1114.Metal3 vout.$706.Metal2 9
Rred_799 vout.$1114.Metal3 vout.$726.Metal2 18.3608
Rred_800 vout.$1118.Metal3 vout.$1158.Metal3 0.368032035556
Rred_801 vout.$1118.Metal3 vout.$1371.Metal4 4.54465248289
Rred_802 vout.$1118.Metal3 vout.$690.Metal2 18.3608
Rred_803 vout.$1118.Metal3 vout.$710.Metal2 9
Rred_804 vout.$1118.Metal3 vout.$730.Metal2 18.3608
Rred_805 vout.$1122.Metal3 vout.$1162.Metal3 0.368032035556
Rred_806 vout.$1122.Metal3 vout.$1373.Metal4 18.3608
Rred_807 vout.$1122.Metal3 vout.$1383.Metal4 6.03956024678
Rred_808 vout.$1122.Metal3 vout.$694.Metal2 18.3608
Rred_809 vout.$1122.Metal3 vout.$714.Metal2 9
Rred_810 vout.$1122.Metal3 vout.$734.Metal2 18.3608
Rred_811 vout.$1124.Metal3 vout.$1164.Metal3 0.368032035556
Rred_812 vout.$1124.Metal3 vout.$1373.Metal4 18.3608
Rred_813 vout.$1124.Metal3 vout.$1384.Metal4 9
Rred_814 vout.$1124.Metal3 vout.$1394.Metal4 18.3608
Rred_815 vout.$1124.Metal3 vout.$696.Metal2 18.3608
Rred_816 vout.$1124.Metal3 vout.$716.Metal2 9
Rred_817 vout.$1124.Metal3 vout.$736.Metal2 18.3608
Rred_818 vout.$1126.Metal3 vout.$1166.Metal3 0.368032035556
Rred_819 vout.$1126.Metal3 vout.$1373.Metal4 18.3608
Rred_820 vout.$1126.Metal3 vout.$1384.Metal4 9
Rred_821 vout.$1126.Metal3 vout.$1395.Metal4 18.3608
Rred_822 vout.$1126.Metal3 vout.$698.Metal2 18.3608
Rred_823 vout.$1126.Metal3 vout.$718.Metal2 9
Rred_824 vout.$1126.Metal3 vout.$738.Metal2 18.3608
Rred_825 vout.$1128.Metal3 vout.$1168.Metal3 0.368032035556
Rred_826 vout.$1128.Metal3 vout.$1373.Metal4 18.3608
Rred_827 vout.$1128.Metal3 vout.$1384.Metal4 9
Rred_828 vout.$1128.Metal3 vout.$1395.Metal4 18.3608
Rred_829 vout.$1128.Metal3 vout.$700.Metal2 18.3608
Rred_830 vout.$1128.Metal3 vout.$720.Metal2 9
Rred_831 vout.$1128.Metal3 vout.$740.Metal2 18.3608
Rred_832 vout.$1140.Metal3 vout.$1180.Metal3 0.368032035556
Rred_833 vout.$1140.Metal3 vout.$1372.Metal4 3.67102552486
Rred_834 vout.$1140.Metal3 vout.$692.Metal2 28.4576640711
Rred_835 vout.$1140.Metal3 vout.$712.Metal2 13.9492275195
Rred_836 vout.$1140.Metal3 vout.$732.Metal2 9
Rred_837 vout.$1140.Metal3 vout.$752.Metal2 18.3608
Rred_838 vout.$1150.Metal3 vout.$1190.Metal3 0.368032035556
Rred_839 vout.$1150.Metal3 vout.$1384.Metal4 18.3608
Rred_840 vout.$1150.Metal3 vout.$1395.Metal4 9
Rred_841 vout.$1150.Metal3 vout.$1405.Metal4 18.3608
Rred_842 vout.$1150.Metal3 vout.$722.Metal2 18.3608
Rred_843 vout.$1150.Metal3 vout.$742.Metal2 9
Rred_844 vout.$1150.Metal3 vout.$762.Metal2 18.3608
Rred_845 vout.$1152.Metal3 vout.$1368.Metal4 31.4531473001
Rred_846 vout.$1152.Metal3 vout.$1408.Metal4 2.42588356797
Rred_847 vout.$1152.Metal3 vout.$326.Metal1 8375.69676643
Rred_848 vout.$1152.Metal3 vout.$346.Metal1 1030.85498664
Rred_849 vout.$1152.Metal3 vout.$396.Metal1 586.201698029
Rred_850 vout.$1152.Metal3 vout.$724.Metal2 9.17902185147
Rred_851 vout.$1152.Metal3 vout.$764.Metal2 6.47988248301
Rred_852 vout.$1152.Metal3 vout.$784.Metal2 5.60977187034
Rred_853 vout.$1154.Metal3 vout.$1369.Metal4 2.23655168381
Rred_854 vout.$1154.Metal3 vout.$327.Metal1 8375.69676643
Rred_855 vout.$1154.Metal3 vout.$347.Metal1 1030.85498664
Rred_856 vout.$1154.Metal3 vout.$397.Metal1 586.201698029
Rred_857 vout.$1154.Metal3 vout.$726.Metal2 9.18030670401
Rred_858 vout.$1154.Metal3 vout.$766.Metal2 6.47988248301
Rred_859 vout.$1154.Metal3 vout.$786.Metal2 5.60977187034
Rred_860 vout.$1156.Metal3 vout.$1370.Metal4 2.00207617872
Rred_861 vout.$1156.Metal3 vout.$328.Metal1 8375.69676643
Rred_862 vout.$1156.Metal3 vout.$348.Metal1 1030.85498664
Rred_863 vout.$1156.Metal3 vout.$398.Metal1 586.201698029
Rred_864 vout.$1156.Metal3 vout.$708.Metal2 28.4576640711
Rred_865 vout.$1156.Metal3 vout.$728.Metal2 7.92684961513
Rred_866 vout.$1156.Metal3 vout.$768.Metal2 6.47988248301
Rred_867 vout.$1156.Metal3 vout.$788.Metal2 5.60977187034
Rred_868 vout.$1158.Metal3 vout.$1371.Metal4 2.23655168381
Rred_869 vout.$1158.Metal3 vout.$329.Metal1 8375.69676643
Rred_870 vout.$1158.Metal3 vout.$349.Metal1 1030.85498664
Rred_871 vout.$1158.Metal3 vout.$399.Metal1 586.201698029
Rred_872 vout.$1158.Metal3 vout.$730.Metal2 9.18030670401
Rred_873 vout.$1158.Metal3 vout.$770.Metal2 6.47988248301
Rred_874 vout.$1158.Metal3 vout.$790.Metal2 5.60977187034
Rred_875 vout.$1162.Metal3 vout.$1383.Metal4 2.23655168381
Rred_876 vout.$1162.Metal3 vout.$331.Metal1 8375.69676643
Rred_877 vout.$1162.Metal3 vout.$351.Metal1 1030.85498664
Rred_878 vout.$1162.Metal3 vout.$401.Metal1 586.201698029
Rred_879 vout.$1162.Metal3 vout.$734.Metal2 9.18030670401
Rred_880 vout.$1162.Metal3 vout.$774.Metal2 6.47988248301
Rred_881 vout.$1162.Metal3 vout.$794.Metal2 5.60977187034
Rred_882 vout.$1164.Metal3 vout.$1394.Metal4 2.23655168381
Rred_883 vout.$1164.Metal3 vout.$332.Metal1 8375.69676643
Rred_884 vout.$1164.Metal3 vout.$352.Metal1 1030.85498664
Rred_885 vout.$1164.Metal3 vout.$402.Metal1 586.201698029
Rred_886 vout.$1164.Metal3 vout.$736.Metal2 9.18030670401
Rred_887 vout.$1164.Metal3 vout.$776.Metal2 6.47988248301
Rred_888 vout.$1164.Metal3 vout.$796.Metal2 5.60977187034
Rred_889 vout.$1166.Metal3 vout.$1395.Metal4 18.3608
Rred_890 vout.$1166.Metal3 vout.$1405.Metal4 9
Rred_891 vout.$1166.Metal3 vout.$1415.Metal4 3.55186910988
Rred_892 vout.$1166.Metal3 vout.$333.Metal1 8375.69676643
Rred_893 vout.$1166.Metal3 vout.$353.Metal1 1030.85498664
Rred_894 vout.$1166.Metal3 vout.$403.Metal1 586.201698029
Rred_895 vout.$1166.Metal3 vout.$738.Metal2 9.18030670401
Rred_896 vout.$1166.Metal3 vout.$778.Metal2 6.47988248301
Rred_897 vout.$1166.Metal3 vout.$798.Metal2 5.60977187034
Rred_898 vout.$1168.Metal3 vout.$1208.Metal3 0.368032035556
Rred_899 vout.$1168.Metal3 vout.$1395.Metal4 18.3608
Rred_900 vout.$1168.Metal3 vout.$1405.Metal4 9
Rred_901 vout.$1168.Metal3 vout.$1416.Metal4 18.3608
Rred_902 vout.$1168.Metal3 vout.$334.Metal1 8375.69676643
Rred_903 vout.$1168.Metal3 vout.$354.Metal1 1030.85498664
Rred_904 vout.$1168.Metal3 vout.$740.Metal2 9.18030670401
Rred_905 vout.$1168.Metal3 vout.$780.Metal2 9.18030670401
Rred_906 vout.$1180.Metal3 vout.$1372.Metal4 2.71938308337
Rred_907 vout.$1180.Metal3 vout.$400.Metal1 526.83669703
Rred_908 vout.$1180.Metal3 vout.$752.Metal2 18.3608
Rred_909 vout.$1180.Metal3 vout.$772.Metal2 9
Rred_910 vout.$1180.Metal3 vout.$792.Metal2 5.0416668754
Rred_911 vout.$1190.Metal3 vout.$1405.Metal4 18.3608
Rred_912 vout.$1190.Metal3 vout.$1416.Metal4 3.21268039995
Rred_913 vout.$1190.Metal3 vout.$405.Metal1 526.494516111
Rred_914 vout.$1190.Metal3 vout.$762.Metal2 18.3608
Rred_915 vout.$1190.Metal3 vout.$782.Metal2 9
Rred_916 vout.$1190.Metal3 vout.$802.Metal2 5.03912633155
Rred_917 vout.$12.Metal1 vout.$1235.Metal4 4720.73997004
Rred_918 vout.$12.Metal1 vout.$438.Metal2 5.33891199389
Rred_919 vout.$12.Metal1 vout.$458.Metal2 25.1220892469
Rred_920 vout.$12.Metal1 vout.$62.Metal1 0.600729620506
Rred_921 vout.$12.Metal1 vout.$886.Metal3 586.866710802
Rred_922 vout.$12.Metal1 vout.P2.nSD 8.65123602902
Rred_923 vout.$1208.Metal3 vout.$1415.Metal4 4.68192759355
Rred_924 vout.$1208.Metal3 vout.$1416.Metal4 18.3608
Rred_925 vout.$1208.Metal3 vout.$404.Metal1 488.39662632
Rred_926 vout.$1208.Metal3 vout.$780.Metal2 18.3608
Rred_927 vout.$1208.Metal3 vout.$800.Metal2 4.6747782072
Rred_928 vout.$121.Metal1 vout.$1264.Metal4 9611.79131121
Rred_929 vout.$121.Metal1 vout.$496.Metal2 25.1466584076
Rred_930 vout.$121.Metal1 vout.$516.Metal2 5.34087644342
Rred_931 vout.$121.Metal1 vout.$61.Metal1 0.600727890243
Rred_932 vout.$121.Metal1 vout.$904.Metal3 524.380994006
Rred_933 vout.$121.Metal1 vout.P0.nSD 8.61233997275
Rred_934 vout.$122.Metal1 vout.$1235.Metal4 5171.05310945
Rred_935 vout.$122.Metal1 vout.$498.Metal2 25.1248668228
Rred_936 vout.$122.Metal1 vout.$518.Metal2 5.33911247084
Rred_937 vout.$122.Metal1 vout.$62.Metal1 0.600727890243
Rred_938 vout.$122.Metal1 vout.$886.Metal3 581.151359205
Rred_939 vout.$122.Metal1 vout.P2.nSD 8.61233997275
Rred_940 vout.$123.Metal1 vout.$1236.Metal4 5171.05310945
Rred_941 vout.$123.Metal1 vout.$500.Metal2 25.1248668228
Rred_942 vout.$123.Metal1 vout.$520.Metal2 5.33911247084
Rred_943 vout.$123.Metal1 vout.$63.Metal1 0.600727890243
Rred_944 vout.$123.Metal1 vout.$888.Metal3 581.151359205
Rred_945 vout.$123.Metal1 vout.P4.nSD 8.61233997275
Rred_946 vout.$1235.Metal4 vout.$1236.Metal4 0.04488
Rred_947 vout.$1235.Metal4 vout.$1264.Metal4 0.398945437197
Rred_948 vout.$1235.Metal4 vout.$436.Metal2 119.062607855
Rred_949 vout.$1235.Metal4 vout.$438.Metal2 50.1660186734
Rred_950 vout.$1235.Metal4 vout.$458.Metal2 177.199676048
Rred_951 vout.$1235.Metal4 vout.$498.Metal2 192.098391112
Rred_952 vout.$1235.Metal4 vout.$518.Metal2 54.8622650604
Rred_953 vout.$1235.Metal4 vout.$864.Metal3 4.40208808094
Rred_954 vout.$1235.Metal4 vout.$886.Metal3 1.53289787408
Rred_955 vout.$1236.Metal4 vout.$1237.Metal4 0.04488
Rred_956 vout.$1236.Metal4 vout.$13.Metal1 4720.73997004
Rred_957 vout.$1236.Metal4 vout.$440.Metal2 50.1660186734
Rred_958 vout.$1236.Metal4 vout.$460.Metal2 177.199676048
Rred_959 vout.$1236.Metal4 vout.$500.Metal2 192.098391112
Rred_960 vout.$1236.Metal4 vout.$520.Metal2 54.8622650604
Rred_961 vout.$1236.Metal4 vout.$888.Metal3 1.53289787408
Rred_962 vout.$1237.Metal4 vout.$1238.Metal4 0.04488
Rred_963 vout.$1237.Metal4 vout.$124.Metal1 5171.05310945
Rred_964 vout.$1237.Metal4 vout.$14.Metal1 4720.73997004
Rred_965 vout.$1237.Metal4 vout.$442.Metal2 50.1660186734
Rred_966 vout.$1237.Metal4 vout.$462.Metal2 177.199676048
Rred_967 vout.$1237.Metal4 vout.$502.Metal2 192.098391112
Rred_968 vout.$1237.Metal4 vout.$522.Metal2 54.8622650604
Rred_969 vout.$1237.Metal4 vout.$890.Metal3 1.53289787408
Rred_970 vout.$1238.Metal4 vout.$1239.Metal4 0.0897965859267
Rred_971 vout.$1238.Metal4 vout.$125.Metal1 5171.05310945
Rred_972 vout.$1238.Metal4 vout.$15.Metal1 4720.73997004
Rred_973 vout.$1238.Metal4 vout.$444.Metal2 50.1660186734
Rred_974 vout.$1238.Metal4 vout.$464.Metal2 177.199676048
Rred_975 vout.$1238.Metal4 vout.$504.Metal2 192.098391112
Rred_976 vout.$1238.Metal4 vout.$524.Metal2 54.8622650604
Rred_977 vout.$1238.Metal4 vout.$892.Metal3 1.53289787408
Rred_978 vout.$1239.Metal4 vout.$1240.Metal4 0.0500302065794
Rred_979 vout.$1239.Metal4 vout.$16.Metal1 4720.73997004
Rred_980 vout.$1239.Metal4 vout.$446.Metal2 50.1660186734
Rred_981 vout.$1239.Metal4 vout.$466.Metal2 177.199676048
Rred_982 vout.$1239.Metal4 vout.$894.Metal3 3.55186906212
Rred_983 vout.$124.Metal1 vout.$502.Metal2 25.1248668228
Rred_984 vout.$124.Metal1 vout.$522.Metal2 5.33911247084
Rred_985 vout.$124.Metal1 vout.$64.Metal1 0.600727890243
Rred_986 vout.$124.Metal1 vout.$890.Metal3 581.151359205
Rred_987 vout.$124.Metal1 vout.P6.nSD 8.61233997275
Rred_988 vout.$1240.Metal4 vout.$1241.Metal4 0.115861562631
Rred_989 vout.$1240.Metal4 vout.$1252.Metal4 0.201375714667
Rred_990 vout.$1240.Metal4 vout.$1261.Metal4 0.324638296655
Rred_991 vout.$1240.Metal4 vout.$17.Metal1 4720.73997004
Rred_992 vout.$1240.Metal4 vout.$448.Metal2 50.1660186734
Rred_993 vout.$1240.Metal4 vout.$468.Metal2 177.199676048
Rred_994 vout.$1240.Metal4 vout.$896.Metal3 3.55186906212
Rred_995 vout.$1241.Metal4 vout.$1252.Metal4 0.0116694883101
Rred_996 vout.$1241.Metal4 vout.$1261.Metal4 0.0188124114871
Rred_997 vout.$1241.Metal4 vout.$18.Metal1 24403.0849465
Rred_998 vout.$1241.Metal4 vout.$19.Metal1 24616.2134621
Rred_999 vout.$1241.Metal4 vout.$450.Metal2 485.473124043
Rred_1000 vout.$1241.Metal4 vout.$452.Metal2 489.713086593
Rred_1001 vout.$1241.Metal4 vout.$858.Metal3 4.58759190296
Rred_1002 vout.$1241.Metal4 vout.$860.Metal3 9.43904663312
Rred_1003 vout.$125.Metal1 vout.$504.Metal2 25.1248668228
Rred_1004 vout.$125.Metal1 vout.$524.Metal2 5.33911247084
Rred_1005 vout.$125.Metal1 vout.$65.Metal1 0.600727890243
Rred_1006 vout.$125.Metal1 vout.$892.Metal3 581.151359205
Rred_1007 vout.$125.Metal1 vout.P8.nSD 8.61233997275
Rred_1008 vout.$1252.Metal4 vout.$1261.Metal4 0.0326973218882
Rred_1009 vout.$1252.Metal4 vout.$20.Metal1 24495.0989672
Rred_1010 vout.$1252.Metal4 vout.$454.Metal2 487.303644003
Rred_1011 vout.$1252.Metal4 vout.$860.Metal3 9
Rred_1012 vout.$1252.Metal4 vout.$862.Metal3 4.59605624702
Rred_1013 vout.$126.Metal1 vout.$1299.Metal4 24403.0849465
Rred_1014 vout.$126.Metal1 vout.$506.Metal2 25.1466584076
Rred_1015 vout.$126.Metal1 vout.$526.Metal2 5.34297678449
Rred_1016 vout.$126.Metal1 vout.$66.Metal1 0.600727890243
Rred_1017 vout.$126.Metal1 vout.$934.Metal3 489.146280484
Rred_1018 vout.$126.Metal1 vout.P10.nSD 8.61233997275
Rred_1019 vout.$1261.Metal4 vout.$1269.Metal4 0.00996377037281
Rred_1020 vout.$1261.Metal4 vout.$470.Metal2 916.00443459
Rred_1021 vout.$1261.Metal4 vout.$472.Metal2 916.00443459
Rred_1022 vout.$1261.Metal4 vout.$474.Metal2 916.00443459
Rred_1023 vout.$1261.Metal4 vout.$858.Metal3 18.3608
Rred_1024 vout.$1261.Metal4 vout.$860.Metal3 18.3608
Rred_1025 vout.$1261.Metal4 vout.$862.Metal3 18.3608
Rred_1026 vout.$1261.Metal4 vout.$898.Metal3 18.3608
Rred_1027 vout.$1261.Metal4 vout.$900.Metal3 18.3608
Rred_1028 vout.$1261.Metal4 vout.$902.Metal3 18.3608
Rred_1029 vout.$1264.Metal4 vout.$436.Metal2 969.885806319
Rred_1030 vout.$1264.Metal4 vout.$476.Metal2 916.00443459
Rred_1031 vout.$1264.Metal4 vout.$516.Metal2 112.473090269
Rred_1032 vout.$1264.Metal4 vout.$864.Metal3 7.65131382908
Rred_1033 vout.$1264.Metal4 vout.$904.Metal3 2.92153140177
Rred_1034 vout.$1269.Metal4 vout.$1279.Metal4 0.00842990654206
Rred_1035 vout.$1269.Metal4 vout.$894.Metal3 9
Rred_1036 vout.$1269.Metal4 vout.$896.Metal3 9
Rred_1037 vout.$1269.Metal4 vout.$898.Metal3 9
Rred_1038 vout.$1269.Metal4 vout.$900.Metal3 9
Rred_1039 vout.$1269.Metal4 vout.$902.Metal3 9
Rred_1040 vout.$127.Metal1 vout.$1299.Metal4 24403.0849465
Rred_1041 vout.$127.Metal1 vout.$508.Metal2 25.1466584076
Rred_1042 vout.$127.Metal1 vout.$528.Metal2 5.34297678449
Rred_1043 vout.$127.Metal1 vout.$67.Metal1 0.600727890243
Rred_1044 vout.$127.Metal1 vout.$936.Metal3 489.146280484
Rred_1045 vout.$127.Metal1 vout.P12.nSD 8.61233997275
Rred_1046 vout.$1279.Metal4 vout.$1289.Metal4 0.00842990654206
Rred_1047 vout.$1279.Metal4 vout.$506.Metal2 916.00443459
Rred_1048 vout.$1279.Metal4 vout.$508.Metal2 916.00443459
Rred_1049 vout.$1279.Metal4 vout.$510.Metal2 916.00443459
Rred_1050 vout.$1279.Metal4 vout.$512.Metal2 916.00443459
Rred_1051 vout.$1279.Metal4 vout.$514.Metal2 916.00443459
Rred_1052 vout.$1279.Metal4 vout.$894.Metal3 18.3608
Rred_1053 vout.$1279.Metal4 vout.$896.Metal3 18.3608
Rred_1054 vout.$1279.Metal4 vout.$898.Metal3 18.3608
Rred_1055 vout.$1279.Metal4 vout.$900.Metal3 18.3608
Rred_1056 vout.$1279.Metal4 vout.$902.Metal3 18.3608
Rred_1057 vout.$1279.Metal4 vout.$934.Metal3 18.3608
Rred_1058 vout.$1279.Metal4 vout.$936.Metal3 18.3608
Rred_1059 vout.$1279.Metal4 vout.$938.Metal3 18.3608
Rred_1060 vout.$1279.Metal4 vout.$940.Metal3 18.3608
Rred_1061 vout.$1279.Metal4 vout.$942.Metal3 18.3608
Rred_1062 vout.$128.Metal1 vout.$1299.Metal4 24403.0849465
Rred_1063 vout.$128.Metal1 vout.$510.Metal2 25.1466584076
Rred_1064 vout.$128.Metal1 vout.$530.Metal2 5.34297678449
Rred_1065 vout.$128.Metal1 vout.$68.Metal1 0.600727890243
Rred_1066 vout.$128.Metal1 vout.$938.Metal3 489.146280484
Rred_1067 vout.$128.Metal1 vout.P14.nSD 8.61233997275
Rred_1068 vout.$1289.Metal4 vout.$1299.Metal4 0.00842990654206
Rred_1069 vout.$1289.Metal4 vout.$934.Metal3 9
Rred_1070 vout.$1289.Metal4 vout.$936.Metal3 9
Rred_1071 vout.$1289.Metal4 vout.$938.Metal3 9
Rred_1072 vout.$1289.Metal4 vout.$940.Metal3 9
Rred_1073 vout.$1289.Metal4 vout.$942.Metal3 9
Rred_1074 vout.$129.Metal1 vout.$1299.Metal4 24403.0849465
Rred_1075 vout.$129.Metal1 vout.$512.Metal2 25.1466584076
Rred_1076 vout.$129.Metal1 vout.$532.Metal2 5.34297678449
Rred_1077 vout.$129.Metal1 vout.$69.Metal1 0.600727890243
Rred_1078 vout.$129.Metal1 vout.$940.Metal3 489.146280484
Rred_1079 vout.$129.Metal1 vout.P16.nSD 8.61233997275
Rred_1080 vout.$1299.Metal4 vout.$130.Metal1 24403.0849465
Rred_1081 vout.$1299.Metal4 vout.$1313.Metal4 8077.4858128
Rred_1082 vout.$1299.Metal4 vout.$526.Metal2 485.473124043
Rred_1083 vout.$1299.Metal4 vout.$528.Metal2 485.473124043
Rred_1084 vout.$1299.Metal4 vout.$530.Metal2 485.473124043
Rred_1085 vout.$1299.Metal4 vout.$532.Metal2 485.473124043
Rred_1086 vout.$1299.Metal4 vout.$534.Metal2 485.473124043
Rred_1087 vout.$1299.Metal4 vout.$934.Metal3 9.35732285377
Rred_1088 vout.$1299.Metal4 vout.$936.Metal3 9.35732285377
Rred_1089 vout.$1299.Metal4 vout.$938.Metal3 9.35732285377
Rred_1090 vout.$1299.Metal4 vout.$940.Metal3 9.35732285377
Rred_1091 vout.$1299.Metal4 vout.$942.Metal3 9.35732285377
Rred_1092 vout.$1299.Metal4 vout.P0.GatPoly 862.587108942
Rred_1093 vout.$13.Metal1 vout.$440.Metal2 5.33891199389
Rred_1094 vout.$13.Metal1 vout.$460.Metal2 25.1220892469
Rred_1095 vout.$13.Metal1 vout.$63.Metal1 0.600729620506
Rred_1096 vout.$13.Metal1 vout.$888.Metal3 586.866710802
Rred_1097 vout.$13.Metal1 vout.P4.nSD 8.65123602902
Rred_1098 vout.$130.Metal1 vout.$514.Metal2 25.1466584076
Rred_1099 vout.$130.Metal1 vout.$534.Metal2 5.34297678449
Rred_1100 vout.$130.Metal1 vout.$70.Metal1 0.600727890243
Rred_1101 vout.$130.Metal1 vout.$942.Metal3 489.146280484
Rred_1102 vout.$130.Metal1 vout.P18.nSD 8.61233997275
Rred_1103 vout.$1313.Metal4 vout.$1323.Metal4 0.00842990654206
Rred_1104 vout.$1313.Metal4 vout.$161.Metal1 24375.4320652
Rred_1105 vout.$1313.Metal4 vout.$162.Metal1 24375.4320652
Rred_1106 vout.$1313.Metal4 vout.$163.Metal1 24375.4320652
Rred_1107 vout.$1313.Metal4 vout.$164.Metal1 24375.4320652
Rred_1108 vout.$1313.Metal4 vout.$165.Metal1 24375.4320652
Rred_1109 vout.$1313.Metal4 vout.$594.Metal2 485.483869595
Rred_1110 vout.$1313.Metal4 vout.$596.Metal2 485.483869595
Rred_1111 vout.$1313.Metal4 vout.$598.Metal2 485.483869595
Rred_1112 vout.$1313.Metal4 vout.$600.Metal2 485.483869595
Rred_1113 vout.$1313.Metal4 vout.$602.Metal2 485.483869595
Rred_1114 vout.$1313.Metal4 vout.P0.GatPoly 620.059392334
Rred_1115 vout.$1323.Metal4 vout.$1333.Metal4 0.00842990654206
Rred_1116 vout.$1328.Metal4 vout.$1368.Metal4 0.75805390775
Rred_1117 vout.$1328.Metal4 vout.$156.Metal1 4901.18384755
Rred_1118 vout.$1328.Metal4 vout.$584.Metal2 52.0586936315
Rred_1119 vout.$1328.Metal4 vout.$604.Metal2 182.279627323
Rred_1120 vout.$1328.Metal4 vout.$644.Metal2 1905.45038155
Rred_1121 vout.$1329.Metal4 vout.$1369.Metal4 0.755583409428
Rred_1122 vout.$1329.Metal4 vout.$157.Metal1 4901.18384755
Rred_1123 vout.$1329.Metal4 vout.$586.Metal2 52.0586936315
Rred_1124 vout.$1329.Metal4 vout.$606.Metal2 182.279627323
Rred_1125 vout.$1329.Metal4 vout.$646.Metal2 1911.01992043
Rred_1126 vout.$1330.Metal4 vout.$1370.Metal4 0.755583409428
Rred_1127 vout.$1330.Metal4 vout.$158.Metal1 4901.18384755
Rred_1128 vout.$1330.Metal4 vout.$588.Metal2 52.0586936315
Rred_1129 vout.$1330.Metal4 vout.$608.Metal2 182.279627323
Rred_1130 vout.$1330.Metal4 vout.$648.Metal2 1911.01992043
Rred_1131 vout.$1331.Metal4 vout.$1371.Metal4 0.755583409428
Rred_1132 vout.$1331.Metal4 vout.$159.Metal1 4901.18384755
Rred_1133 vout.$1331.Metal4 vout.$590.Metal2 52.0586936315
Rred_1134 vout.$1331.Metal4 vout.$610.Metal2 182.279627323
Rred_1135 vout.$1331.Metal4 vout.$650.Metal2 1911.01992043
Rred_1136 vout.$1332.Metal4 vout.$1372.Metal4 0.755583409428
Rred_1137 vout.$1332.Metal4 vout.$160.Metal1 4901.18384755
Rred_1138 vout.$1332.Metal4 vout.$592.Metal2 52.0586936315
Rred_1139 vout.$1332.Metal4 vout.$612.Metal2 182.279627323
Rred_1140 vout.$1332.Metal4 vout.$652.Metal2 1911.01992043
Rred_1141 vout.$1333.Metal4 vout.$1343.Metal4 0.00842990654206
Rred_1142 vout.$1333.Metal4 vout.$614.Metal2 916.00443459
Rred_1143 vout.$1333.Metal4 vout.$616.Metal2 916.00443459
Rred_1144 vout.$1333.Metal4 vout.$618.Metal2 916.00443459
Rred_1145 vout.$1333.Metal4 vout.$620.Metal2 916.00443459
Rred_1146 vout.$1333.Metal4 vout.$622.Metal2 916.00443459
Rred_1147 vout.$1343.Metal4 vout.$1353.Metal4 0.00842990654206
Rred_1148 vout.$1353.Metal4 vout.$1363.Metal4 0.00842990654206
Rred_1149 vout.$1353.Metal4 vout.$654.Metal2 916.00443459
Rred_1150 vout.$1353.Metal4 vout.$656.Metal2 916.00443459
Rred_1151 vout.$1353.Metal4 vout.$658.Metal2 916.00443459
Rred_1152 vout.$1353.Metal4 vout.$660.Metal2 916.00443459
Rred_1153 vout.$1363.Metal4 vout.$1373.Metal4 0.00843000513901
Rred_1154 vout.$1363.Metal4 vout.$682.Metal2 916.00443459
Rred_1155 vout.$1368.Metal4 vout.$1408.Metal4 0.829308571898
Rred_1156 vout.$1368.Metal4 vout.$644.Metal2 1905.46163528
Rred_1157 vout.$1368.Metal4 vout.$684.Metal2 916.00443459
Rred_1158 vout.$1368.Metal4 vout.$724.Metal2 2100.25322434
Rred_1159 vout.$1369.Metal4 vout.$1370.Metal4 0.0343908045977
Rred_1160 vout.$1369.Metal4 vout.$1408.Metal4 0.0356932530183
Rred_1161 vout.$1369.Metal4 vout.$397.Metal1 4715.39062526
Rred_1162 vout.$1369.Metal4 vout.$646.Metal2 1899.25173421
Rred_1163 vout.$1369.Metal4 vout.$686.Metal2 916.00443459
Rred_1164 vout.$1369.Metal4 vout.$726.Metal2 916.00443459
Rred_1165 vout.$1369.Metal4 vout.$766.Metal2 177.199678431
Rred_1166 vout.$1369.Metal4 vout.$786.Metal2 50.1666125505
Rred_1167 vout.$1370.Metal4 vout.$1371.Metal4 0.0343908045977
Rred_1168 vout.$1370.Metal4 vout.$398.Metal1 4715.39062526
Rred_1169 vout.$1370.Metal4 vout.$648.Metal2 1899.25173421
Rred_1170 vout.$1370.Metal4 vout.$708.Metal2 467.002217295
Rred_1171 vout.$1370.Metal4 vout.$728.Metal2 467.002217295
Rred_1172 vout.$1370.Metal4 vout.$768.Metal2 177.199678431
Rred_1173 vout.$1370.Metal4 vout.$788.Metal2 50.1666125505
Rred_1174 vout.$1371.Metal4 vout.$1372.Metal4 0.0343908045977
Rred_1175 vout.$1371.Metal4 vout.$399.Metal1 4715.39062526
Rred_1176 vout.$1371.Metal4 vout.$650.Metal2 1899.25173421
Rred_1177 vout.$1371.Metal4 vout.$690.Metal2 916.00443459
Rred_1178 vout.$1371.Metal4 vout.$730.Metal2 916.00443459
Rred_1179 vout.$1371.Metal4 vout.$770.Metal2 177.199678431
Rred_1180 vout.$1371.Metal4 vout.$790.Metal2 50.1666125505
Rred_1181 vout.$1372.Metal4 vout.$1383.Metal4 0.0688216220834
Rred_1182 vout.$1372.Metal4 vout.$400.Metal1 8645.61142651
Rred_1183 vout.$1372.Metal4 vout.$652.Metal2 1899.25173421
Rred_1184 vout.$1372.Metal4 vout.$692.Metal2 467.002217295
Rred_1185 vout.$1372.Metal4 vout.$712.Metal2 467.002217295
Rred_1186 vout.$1372.Metal4 vout.$752.Metal2 916.00443459
Rred_1187 vout.$1372.Metal4 vout.$792.Metal2 101.425068495
Rred_1188 vout.$1373.Metal4 vout.$1384.Metal4 0.00918991691467
Rred_1189 vout.$1373.Metal4 vout.$694.Metal2 916.00443459
Rred_1190 vout.$1373.Metal4 vout.$696.Metal2 916.00443459
Rred_1191 vout.$1373.Metal4 vout.$698.Metal2 916.00443459
Rred_1192 vout.$1373.Metal4 vout.$700.Metal2 916.00443459
Rred_1193 vout.$1383.Metal4 vout.$1394.Metal4 0.0403681913489
Rred_1194 vout.$1383.Metal4 vout.$401.Metal1 4715.39062526
Rred_1195 vout.$1383.Metal4 vout.$734.Metal2 916.00443459
Rred_1196 vout.$1383.Metal4 vout.$774.Metal2 177.199678431
Rred_1197 vout.$1383.Metal4 vout.$794.Metal2 50.1666125505
Rred_1198 vout.$1384.Metal4 vout.$1395.Metal4 0.0110956707561
Rred_1199 vout.$1384.Metal4 vout.$722.Metal2 916.00443459
Rred_1200 vout.$1394.Metal4 vout.$1415.Metal4 0.05624580116
Rred_1201 vout.$1394.Metal4 vout.$402.Metal1 4715.39062526
Rred_1202 vout.$1394.Metal4 vout.$736.Metal2 916.00443459
Rred_1203 vout.$1394.Metal4 vout.$776.Metal2 177.199678431
Rred_1204 vout.$1394.Metal4 vout.$796.Metal2 50.1666125505
Rred_1205 vout.$1395.Metal4 vout.$1405.Metal4 0.01400429174
Rred_1206 vout.$1395.Metal4 vout.$738.Metal2 916.00443459
Rred_1207 vout.$1395.Metal4 vout.$740.Metal2 916.00443459
Rred_1208 vout.$14.Metal1 vout.$442.Metal2 5.33891199389
Rred_1209 vout.$14.Metal1 vout.$462.Metal2 25.1220892469
Rred_1210 vout.$14.Metal1 vout.$64.Metal1 0.600729620506
Rred_1211 vout.$14.Metal1 vout.$890.Metal3 586.866710802
Rred_1212 vout.$14.Metal1 vout.P6.nSD 8.65123602902
Rred_1213 vout.$1405.Metal4 vout.$1415.Metal4 0.00280395760705
Rred_1214 vout.$1405.Metal4 vout.$762.Metal2 916.00443459
Rred_1215 vout.$1408.Metal4 vout.$396.Metal1 4715.39062526
Rred_1216 vout.$1408.Metal4 vout.$724.Metal2 1729.2283748
Rred_1217 vout.$1408.Metal4 vout.$764.Metal2 177.199678431
Rred_1218 vout.$1408.Metal4 vout.$784.Metal2 50.1666125505
Rred_1219 vout.$1415.Metal4 vout.$1416.Metal4 0.0161972814407
Rred_1220 vout.$1415.Metal4 vout.$403.Metal1 4715.39062526
Rred_1221 vout.$1415.Metal4 vout.$404.Metal1 24876.6694912
Rred_1222 vout.$1415.Metal4 vout.$778.Metal2 177.199678431
Rred_1223 vout.$1415.Metal4 vout.$798.Metal2 50.1666125505
Rred_1224 vout.$1415.Metal4 vout.$800.Metal2 495.466982286
Rred_1225 vout.$1416.Metal4 vout.$405.Metal1 8743.9185852
Rred_1226 vout.$1416.Metal4 vout.$780.Metal2 916.00443459
Rred_1227 vout.$1416.Metal4 vout.$802.Metal2 102.520847603
Rred_1228 vout.$15.Metal1 vout.$444.Metal2 5.33891199389
Rred_1229 vout.$15.Metal1 vout.$464.Metal2 25.1220892469
Rred_1230 vout.$15.Metal1 vout.$65.Metal1 0.600729620506
Rred_1231 vout.$15.Metal1 vout.$892.Metal3 586.866710802
Rred_1232 vout.$15.Metal1 vout.P8.nSD 8.65123602902
Rred_1233 vout.$156.Metal1 vout.$206.Metal1 0.59229373722
Rred_1234 vout.$156.Metal1 vout.$584.Metal2 5.40656480397
Rred_1235 vout.$156.Metal1 vout.$604.Metal2 27.1005435027
Rred_1236 vout.$156.Metal1 vout.P0.pSD 8.64999884435
Rred_1237 vout.$157.Metal1 vout.$207.Metal1 0.59229373722
Rred_1238 vout.$157.Metal1 vout.$586.Metal2 5.40656480397
Rred_1239 vout.$157.Metal1 vout.$606.Metal2 27.1005435027
Rred_1240 vout.$157.Metal1 vout.P2.pSD 8.64999884435
Rred_1241 vout.$158.Metal1 vout.$208.Metal1 0.59229373722
Rred_1242 vout.$158.Metal1 vout.$588.Metal2 5.40656480397
Rred_1243 vout.$158.Metal1 vout.$608.Metal2 27.1005435027
Rred_1244 vout.$158.Metal1 vout.P4.pSD 8.64999884435
Rred_1245 vout.$159.Metal1 vout.$209.Metal1 0.59229373722
Rred_1246 vout.$159.Metal1 vout.$590.Metal2 5.40656480397
Rred_1247 vout.$159.Metal1 vout.$610.Metal2 27.1005435027
Rred_1248 vout.$159.Metal1 vout.P6.pSD 8.64999884435
Rred_1249 vout.$16.Metal1 vout.$446.Metal2 5.33891199389
Rred_1250 vout.$16.Metal1 vout.$466.Metal2 25.1220892469
Rred_1251 vout.$16.Metal1 vout.$66.Metal1 0.600729620506
Rred_1252 vout.$16.Metal1 vout.$894.Metal3 586.866710802
Rred_1253 vout.$16.Metal1 vout.P10.nSD 8.65123602902
Rred_1254 vout.$160.Metal1 vout.$210.Metal1 0.59229373722
Rred_1255 vout.$160.Metal1 vout.$592.Metal2 5.40656480397
Rred_1256 vout.$160.Metal1 vout.$612.Metal2 27.1005435027
Rred_1257 vout.$160.Metal1 vout.P8.pSD 8.64999884435
Rred_1258 vout.$161.Metal1 vout.$201.Metal1 0.386105998812
Rred_1259 vout.$161.Metal1 vout.$594.Metal2 5.86758130045
Rred_1260 vout.$161.Metal1 vout.$614.Metal2 442.266871367
Rred_1261 vout.$161.Metal1 vout.P10.pSD 11.4185805781
Rred_1262 vout.$162.Metal1 vout.$212.Metal1 0.59229373722
Rred_1263 vout.$162.Metal1 vout.$596.Metal2 5.41051222785
Rred_1264 vout.$162.Metal1 vout.$616.Metal2 27.1257864987
Rred_1265 vout.$162.Metal1 vout.P12.pSD 8.64999884435
Rred_1266 vout.$163.Metal1 vout.$213.Metal1 0.59229373722
Rred_1267 vout.$163.Metal1 vout.$598.Metal2 5.41051222785
Rred_1268 vout.$163.Metal1 vout.$618.Metal2 27.1257864987
Rred_1269 vout.$163.Metal1 vout.P14.pSD 8.64999884435
Rred_1270 vout.$164.Metal1 vout.$214.Metal1 0.59229373722
Rred_1271 vout.$164.Metal1 vout.$600.Metal2 5.41051222785
Rred_1272 vout.$164.Metal1 vout.$620.Metal2 27.1257864987
Rred_1273 vout.$164.Metal1 vout.P16.pSD 8.64999884435
Rred_1274 vout.$165.Metal1 vout.$215.Metal1 0.59229373722
Rred_1275 vout.$165.Metal1 vout.$602.Metal2 5.41051222785
Rred_1276 vout.$165.Metal1 vout.$622.Metal2 27.1257864987
Rred_1277 vout.$165.Metal1 vout.P18.pSD 8.64999884435
Rred_1278 vout.$17.Metal1 vout.$448.Metal2 5.33891199389
Rred_1279 vout.$17.Metal1 vout.$468.Metal2 25.1220892469
Rred_1280 vout.$17.Metal1 vout.$67.Metal1 0.600729620506
Rred_1281 vout.$17.Metal1 vout.$896.Metal3 586.866710802
Rred_1282 vout.$17.Metal1 vout.P12.nSD 8.65123602902
Rred_1283 vout.$18.Metal1 vout.$450.Metal2 5.34273779964
Rred_1284 vout.$18.Metal1 vout.$470.Metal2 25.1436636536
Rred_1285 vout.$18.Metal1 vout.$68.Metal1 0.600729620506
Rred_1286 vout.$18.Metal1 vout.$858.Metal3 489.146280484
Rred_1287 vout.$18.Metal1 vout.P14.nSD 8.65123602902
Rred_1288 vout.$19.Metal1 vout.$452.Metal2 5.3427376082
Rred_1289 vout.$19.Metal1 vout.$472.Metal2 25.1436636536
Rred_1290 vout.$19.Metal1 vout.$69.Metal1 0.600729620506
Rred_1291 vout.$19.Metal1 vout.$860.Metal3 489.063041914
Rred_1292 vout.$19.Metal1 vout.P16.nSD 8.65123602902
Rred_1293 vout.$20.Metal1 vout.$454.Metal2 5.34273771658
Rred_1294 vout.$20.Metal1 vout.$474.Metal2 25.1436636536
Rred_1295 vout.$20.Metal1 vout.$70.Metal1 0.600729620506
Rred_1296 vout.$20.Metal1 vout.$862.Metal3 489.110162712
Rred_1297 vout.$20.Metal1 vout.P18.nSD 8.65123602902
Rred_1298 vout.$201.Metal1 vout.$231.Metal1 0.385860464007
Rred_1299 vout.$201.Metal1 vout.$594.Metal2 22.1133435683
Rred_1300 vout.$201.Metal1 vout.$614.Metal2 9.20046511721
Rred_1301 vout.$201.Metal1 vout.$634.Metal2 20.090255564
Rred_1302 vout.$201.Metal1 vout.P10.pSD 8.52934264093
Rred_1303 vout.$206.Metal1 vout.$226.Metal1 0.19153913295
Rred_1304 vout.$206.Metal1 vout.$584.Metal2 33.9222776771
Rred_1305 vout.$206.Metal1 vout.$604.Metal2 8.33299389457
Rred_1306 vout.$206.Metal1 vout.$644.Metal2 20.3451917239
Rred_1307 vout.$206.Metal1 vout.P0.pSD 8.60461906604
Rred_1308 vout.$207.Metal1 vout.$227.Metal1 0.19153913295
Rred_1309 vout.$207.Metal1 vout.$586.Metal2 33.9222776771
Rred_1310 vout.$207.Metal1 vout.$606.Metal2 8.33299389457
Rred_1311 vout.$207.Metal1 vout.$646.Metal2 20.3451917239
Rred_1312 vout.$207.Metal1 vout.P2.pSD 8.60461906604
Rred_1313 vout.$208.Metal1 vout.$228.Metal1 0.19153913295
Rred_1314 vout.$208.Metal1 vout.$588.Metal2 33.9222776771
Rred_1315 vout.$208.Metal1 vout.$608.Metal2 8.33299389457
Rred_1316 vout.$208.Metal1 vout.$648.Metal2 20.3451917239
Rred_1317 vout.$208.Metal1 vout.P4.pSD 8.60461906604
Rred_1318 vout.$209.Metal1 vout.$229.Metal1 0.19153913295
Rred_1319 vout.$209.Metal1 vout.$590.Metal2 33.9222776771
Rred_1320 vout.$209.Metal1 vout.$610.Metal2 8.33299389457
Rred_1321 vout.$209.Metal1 vout.$650.Metal2 20.3451917239
Rred_1322 vout.$209.Metal1 vout.P6.pSD 8.60461906604
Rred_1323 vout.$210.Metal1 vout.$230.Metal1 0.19153913295
Rred_1324 vout.$210.Metal1 vout.$592.Metal2 33.9222776771
Rred_1325 vout.$210.Metal1 vout.$612.Metal2 8.33299389457
Rred_1326 vout.$210.Metal1 vout.$652.Metal2 20.3451917239
Rred_1327 vout.$210.Metal1 vout.P8.pSD 8.60461906604
Rred_1328 vout.$212.Metal1 vout.$232.Metal1 0.19153913295
Rred_1329 vout.$212.Metal1 vout.$596.Metal2 33.9222776771
Rred_1330 vout.$212.Metal1 vout.$616.Metal2 8.33299389457
Rred_1331 vout.$212.Metal1 vout.$656.Metal2 20.3451917239
Rred_1332 vout.$212.Metal1 vout.P12.pSD 8.60461906604
Rred_1333 vout.$213.Metal1 vout.$233.Metal1 0.19153913295
Rred_1334 vout.$213.Metal1 vout.$598.Metal2 33.9222776771
Rred_1335 vout.$213.Metal1 vout.$618.Metal2 8.33299389457
Rred_1336 vout.$213.Metal1 vout.$658.Metal2 20.3451917239
Rred_1337 vout.$213.Metal1 vout.P14.pSD 8.60461906604
Rred_1338 vout.$214.Metal1 vout.$234.Metal1 0.19153913295
Rred_1339 vout.$214.Metal1 vout.$600.Metal2 33.9222776771
Rred_1340 vout.$214.Metal1 vout.$620.Metal2 8.33299389457
Rred_1341 vout.$214.Metal1 vout.$660.Metal2 20.3451917239
Rred_1342 vout.$214.Metal1 vout.P16.pSD 8.60461906604
Rred_1343 vout.$215.Metal1 vout.$235.Metal1 0.19153913295
Rred_1344 vout.$215.Metal1 vout.$602.Metal2 33.9222776771
Rred_1345 vout.$215.Metal1 vout.$622.Metal2 8.33299389457
Rred_1346 vout.$215.Metal1 vout.$662.Metal2 20.3451917239
Rred_1347 vout.$215.Metal1 vout.P18.pSD 8.60461906604
Rred_1348 vout.$226.Metal1 vout.$266.Metal1 0.38426238157
Rred_1349 vout.$226.Metal1 vout.$604.Metal2 191.826093397
Rred_1350 vout.$226.Metal1 vout.$644.Metal2 9.66626661297
Rred_1351 vout.$226.Metal1 vout.$664.Metal2 28.7057668446
Rred_1352 vout.$226.Metal1 vout.P0.pSD 11.3856443308
Rred_1353 vout.$227.Metal1 vout.$267.Metal1 0.38426238157
Rred_1354 vout.$227.Metal1 vout.$606.Metal2 191.826093397
Rred_1355 vout.$227.Metal1 vout.$646.Metal2 9.66626661297
Rred_1356 vout.$227.Metal1 vout.$666.Metal2 28.7057668446
Rred_1357 vout.$227.Metal1 vout.P2.pSD 11.3856443308
Rred_1358 vout.$228.Metal1 vout.$268.Metal1 0.38426238157
Rred_1359 vout.$228.Metal1 vout.$608.Metal2 191.826093397
Rred_1360 vout.$228.Metal1 vout.$648.Metal2 9.66626661297
Rred_1361 vout.$228.Metal1 vout.$668.Metal2 28.7057668446
Rred_1362 vout.$228.Metal1 vout.P4.pSD 11.3856443308
Rred_1363 vout.$229.Metal1 vout.$269.Metal1 0.38426238157
Rred_1364 vout.$229.Metal1 vout.$610.Metal2 191.826093397
Rred_1365 vout.$229.Metal1 vout.$650.Metal2 9.66626661297
Rred_1366 vout.$229.Metal1 vout.$670.Metal2 28.7057668446
Rred_1367 vout.$229.Metal1 vout.P6.pSD 11.3856443308
Rred_1368 vout.$230.Metal1 vout.$270.Metal1 0.38426238157
Rred_1369 vout.$230.Metal1 vout.$612.Metal2 191.826093397
Rred_1370 vout.$230.Metal1 vout.$652.Metal2 9.66626661297
Rred_1371 vout.$230.Metal1 vout.$672.Metal2 28.7057668446
Rred_1372 vout.$230.Metal1 vout.P8.pSD 11.3856443308
Rred_1373 vout.$231.Metal1 vout.$271.Metal1 0.38426238157
Rred_1374 vout.$231.Metal1 vout.$634.Metal2 16.7677835209
Rred_1375 vout.$231.Metal1 vout.$654.Metal2 10.1792046843
Rred_1376 vout.$231.Metal1 vout.$674.Metal2 28.7057668446
Rred_1377 vout.$231.Metal1 vout.P10.pSD 8.57800851625
Rred_1378 vout.$232.Metal1 vout.$272.Metal1 0.38426238157
Rred_1379 vout.$232.Metal1 vout.$616.Metal2 191.826093397
Rred_1380 vout.$232.Metal1 vout.$656.Metal2 9.66626661297
Rred_1381 vout.$232.Metal1 vout.$676.Metal2 28.7057668446
Rred_1382 vout.$232.Metal1 vout.P12.pSD 11.3856443308
Rred_1383 vout.$233.Metal1 vout.$273.Metal1 0.38426238157
Rred_1384 vout.$233.Metal1 vout.$618.Metal2 191.826093397
Rred_1385 vout.$233.Metal1 vout.$658.Metal2 9.66626661297
Rred_1386 vout.$233.Metal1 vout.$678.Metal2 28.7057668446
Rred_1387 vout.$233.Metal1 vout.P14.pSD 11.3856443308
Rred_1388 vout.$234.Metal1 vout.$274.Metal1 0.38426238157
Rred_1389 vout.$234.Metal1 vout.$620.Metal2 191.826093397
Rred_1390 vout.$234.Metal1 vout.$660.Metal2 9.66626661297
Rred_1391 vout.$234.Metal1 vout.$680.Metal2 28.7057668446
Rred_1392 vout.$234.Metal1 vout.P16.pSD 11.3856443308
Rred_1393 vout.$235.Metal1 vout.$275.Metal1 0.38426238157
Rred_1394 vout.$235.Metal1 vout.$622.Metal2 191.826093397
Rred_1395 vout.$235.Metal1 vout.$662.Metal2 9.66626661297
Rred_1396 vout.$235.Metal1 vout.$682.Metal2 28.7057668446
Rred_1397 vout.$235.Metal1 vout.P18.pSD 11.3856443308
Rred_1398 vout.$266.Metal1 vout.$286.Metal1 0.192205668934
Rred_1399 vout.$266.Metal1 vout.$644.Metal2 82.5290796781
Rred_1400 vout.$266.Metal1 vout.$664.Metal2 13.3824727938
Rred_1401 vout.$266.Metal1 vout.$684.Metal2 17.851042471
Rred_1402 vout.$266.Metal1 vout.P0.pSD 11.3901835074
Rred_1403 vout.$267.Metal1 vout.$287.Metal1 0.192205668934
Rred_1404 vout.$267.Metal1 vout.$646.Metal2 82.5290796781
Rred_1405 vout.$267.Metal1 vout.$666.Metal2 13.3824727938
Rred_1406 vout.$267.Metal1 vout.$686.Metal2 17.851042471
Rred_1407 vout.$267.Metal1 vout.P2.pSD 11.3901835074
Rred_1408 vout.$268.Metal1 vout.$288.Metal1 0.192195694381
Rred_1409 vout.$268.Metal1 vout.$648.Metal2 82.5290796781
Rred_1410 vout.$268.Metal1 vout.$668.Metal2 9.78615341297
Rred_1411 vout.$268.Metal1 vout.$708.Metal2 36.4158234955
Rred_1412 vout.$268.Metal1 vout.P4.pSD 11.3901835074
Rred_1413 vout.$269.Metal1 vout.$289.Metal1 0.192205668934
Rred_1414 vout.$269.Metal1 vout.$650.Metal2 82.5290796781
Rred_1415 vout.$269.Metal1 vout.$670.Metal2 13.3824727938
Rred_1416 vout.$269.Metal1 vout.$690.Metal2 17.851042471
Rred_1417 vout.$269.Metal1 vout.P6.pSD 11.3901835074
Rred_1418 vout.$270.Metal1 vout.$290.Metal1 0.192205668934
Rred_1419 vout.$270.Metal1 vout.$652.Metal2 82.5290796781
Rred_1420 vout.$270.Metal1 vout.$672.Metal2 13.3824727938
Rred_1421 vout.$270.Metal1 vout.$692.Metal2 17.851042471
Rred_1422 vout.$270.Metal1 vout.P8.pSD 11.3901835074
Rred_1423 vout.$271.Metal1 vout.$291.Metal1 0.192205668934
Rred_1424 vout.$271.Metal1 vout.$654.Metal2 82.5290796781
Rred_1425 vout.$271.Metal1 vout.$674.Metal2 13.3824727938
Rred_1426 vout.$271.Metal1 vout.$694.Metal2 17.851042471
Rred_1427 vout.$271.Metal1 vout.P10.pSD 11.3901835074
Rred_1428 vout.$272.Metal1 vout.$292.Metal1 0.192205668934
Rred_1429 vout.$272.Metal1 vout.$656.Metal2 82.5290796781
Rred_1430 vout.$272.Metal1 vout.$676.Metal2 13.3824727938
Rred_1431 vout.$272.Metal1 vout.$696.Metal2 17.851042471
Rred_1432 vout.$272.Metal1 vout.P12.pSD 11.3901835074
Rred_1433 vout.$273.Metal1 vout.$293.Metal1 0.192205668934
Rred_1434 vout.$273.Metal1 vout.$658.Metal2 82.5290796781
Rred_1435 vout.$273.Metal1 vout.$678.Metal2 13.3824727938
Rred_1436 vout.$273.Metal1 vout.$698.Metal2 17.851042471
Rred_1437 vout.$273.Metal1 vout.P14.pSD 11.3901835074
Rred_1438 vout.$274.Metal1 vout.$294.Metal1 0.192205668934
Rred_1439 vout.$274.Metal1 vout.$660.Metal2 82.5290796781
Rred_1440 vout.$274.Metal1 vout.$680.Metal2 13.3824727938
Rred_1441 vout.$274.Metal1 vout.$700.Metal2 17.851042471
Rred_1442 vout.$274.Metal1 vout.P16.pSD 11.3901835074
Rred_1443 vout.$275.Metal1 vout.$295.Metal1 0.192195694381
Rred_1444 vout.$275.Metal1 vout.$662.Metal2 82.5290796781
Rred_1445 vout.$275.Metal1 vout.$682.Metal2 9.78615341297
Rred_1446 vout.$275.Metal1 vout.$722.Metal2 36.4158234955
Rred_1447 vout.$275.Metal1 vout.P18.pSD 11.3901835074
Rred_1448 vout.$286.Metal1 vout.$326.Metal1 0.384307606624
Rred_1449 vout.$286.Metal1 vout.$684.Metal2 18.3469047619
Rred_1450 vout.$286.Metal1 vout.$704.Metal2 13.2451091915
Rred_1451 vout.$286.Metal1 vout.$724.Metal2 77.6835696811
Rred_1452 vout.$286.Metal1 vout.P0.pSD 11.3900355644
Rred_1453 vout.$287.Metal1 vout.$327.Metal1 0.384307606624
Rred_1454 vout.$287.Metal1 vout.$686.Metal2 18.3469047619
Rred_1455 vout.$287.Metal1 vout.$706.Metal2 13.2451091915
Rred_1456 vout.$287.Metal1 vout.$726.Metal2 77.6835696811
Rred_1457 vout.$287.Metal1 vout.P2.pSD 11.3900355644
Rred_1458 vout.$288.Metal1 vout.$328.Metal1 0.384307606624
Rred_1459 vout.$288.Metal1 vout.$668.Metal2 37.4273741482
Rred_1460 vout.$288.Metal1 vout.$708.Metal2 9.78301485682
Rred_1461 vout.$288.Metal1 vout.$728.Metal2 77.6835696811
Rred_1462 vout.$288.Metal1 vout.P4.pSD 11.3900355644
Rred_1463 vout.$289.Metal1 vout.$329.Metal1 0.384307606624
Rred_1464 vout.$289.Metal1 vout.$690.Metal2 18.3469047619
Rred_1465 vout.$289.Metal1 vout.$710.Metal2 13.2451091915
Rred_1466 vout.$289.Metal1 vout.$730.Metal2 77.6835696811
Rred_1467 vout.$289.Metal1 vout.P6.pSD 11.3900355644
Rred_1468 vout.$290.Metal1 vout.$330.Metal1 0.384307606624
Rred_1469 vout.$290.Metal1 vout.$692.Metal2 18.3469047619
Rred_1470 vout.$290.Metal1 vout.$712.Metal2 13.2451091915
Rred_1471 vout.$290.Metal1 vout.$732.Metal2 77.6835696811
Rred_1472 vout.$290.Metal1 vout.P8.pSD 11.3900355644
Rred_1473 vout.$291.Metal1 vout.$331.Metal1 0.384307606624
Rred_1474 vout.$291.Metal1 vout.$694.Metal2 18.3469047619
Rred_1475 vout.$291.Metal1 vout.$714.Metal2 13.2451091915
Rred_1476 vout.$291.Metal1 vout.$734.Metal2 77.6835696811
Rred_1477 vout.$291.Metal1 vout.P10.pSD 11.3900355644
Rred_1478 vout.$292.Metal1 vout.$332.Metal1 0.384307606624
Rred_1479 vout.$292.Metal1 vout.$696.Metal2 18.3469047619
Rred_1480 vout.$292.Metal1 vout.$716.Metal2 13.2451091915
Rred_1481 vout.$292.Metal1 vout.$736.Metal2 77.6835696811
Rred_1482 vout.$292.Metal1 vout.P12.pSD 11.3900355644
Rred_1483 vout.$293.Metal1 vout.$333.Metal1 0.384307606624
Rred_1484 vout.$293.Metal1 vout.$698.Metal2 18.3469047619
Rred_1485 vout.$293.Metal1 vout.$718.Metal2 13.2451091915
Rred_1486 vout.$293.Metal1 vout.$738.Metal2 77.6835696811
Rred_1487 vout.$293.Metal1 vout.P14.pSD 11.3900355644
Rred_1488 vout.$294.Metal1 vout.$334.Metal1 0.384307606624
Rred_1489 vout.$294.Metal1 vout.$700.Metal2 18.3469047619
Rred_1490 vout.$294.Metal1 vout.$720.Metal2 13.2451091915
Rred_1491 vout.$294.Metal1 vout.$740.Metal2 77.6835696811
Rred_1492 vout.$294.Metal1 vout.P16.pSD 11.3900355644
Rred_1493 vout.$295.Metal1 vout.$335.Metal1 0.384307606624
Rred_1494 vout.$295.Metal1 vout.$682.Metal2 37.4273741482
Rred_1495 vout.$295.Metal1 vout.$722.Metal2 9.78301485682
Rred_1496 vout.$295.Metal1 vout.$742.Metal2 77.6835696811
Rred_1497 vout.$295.Metal1 vout.P18.pSD 11.3900355644
Rred_1498 vout.$326.Metal1 vout.$346.Metal1 0.191582903712
Rred_1499 vout.$326.Metal1 vout.$704.Metal2 29.347126324
Rred_1500 vout.$326.Metal1 vout.$724.Metal2 9.67111776757
Rred_1501 vout.$326.Metal1 vout.$764.Metal2 167.886188518
Rred_1502 vout.$326.Metal1 vout.P0.pSD 11.3857994955
Rred_1503 vout.$327.Metal1 vout.$347.Metal1 0.191582903712
Rred_1504 vout.$327.Metal1 vout.$706.Metal2 29.347126324
Rred_1505 vout.$327.Metal1 vout.$726.Metal2 9.67111776757
Rred_1506 vout.$327.Metal1 vout.$766.Metal2 167.886188518
Rred_1507 vout.$327.Metal1 vout.P2.pSD 11.3857994955
Rred_1508 vout.$328.Metal1 vout.$348.Metal1 0.191582903712
Rred_1509 vout.$328.Metal1 vout.$708.Metal2 29.347126324
Rred_1510 vout.$328.Metal1 vout.$728.Metal2 9.67111776757
Rred_1511 vout.$328.Metal1 vout.$768.Metal2 167.886188518
Rred_1512 vout.$328.Metal1 vout.P4.pSD 11.3857994955
Rred_1513 vout.$329.Metal1 vout.$349.Metal1 0.191582903712
Rred_1514 vout.$329.Metal1 vout.$710.Metal2 29.347126324
Rred_1515 vout.$329.Metal1 vout.$730.Metal2 9.67111776757
Rred_1516 vout.$329.Metal1 vout.$770.Metal2 167.886188518
Rred_1517 vout.$329.Metal1 vout.P6.pSD 11.3857994955
Rred_1518 vout.$330.Metal1 vout.$350.Metal1 0.191586797682
Rred_1519 vout.$330.Metal1 vout.$712.Metal2 29.347126324
Rred_1520 vout.$330.Metal1 vout.$732.Metal2 10.2622783848
Rred_1521 vout.$330.Metal1 vout.$752.Metal2 82.2952380951
Rred_1522 vout.$330.Metal1 vout.P8.pSD 11.3857994955
Rred_1523 vout.$331.Metal1 vout.$351.Metal1 0.191582903712
Rred_1524 vout.$331.Metal1 vout.$714.Metal2 29.347126324
Rred_1525 vout.$331.Metal1 vout.$734.Metal2 9.67111776757
Rred_1526 vout.$331.Metal1 vout.$774.Metal2 167.886188518
Rred_1527 vout.$331.Metal1 vout.P10.pSD 11.3857994955
Rred_1528 vout.$332.Metal1 vout.$352.Metal1 0.191582903712
Rred_1529 vout.$332.Metal1 vout.$716.Metal2 29.347126324
Rred_1530 vout.$332.Metal1 vout.$736.Metal2 9.67111776757
Rred_1531 vout.$332.Metal1 vout.$776.Metal2 167.886188518
Rred_1532 vout.$332.Metal1 vout.P12.pSD 11.3857994955
Rred_1533 vout.$333.Metal1 vout.$353.Metal1 0.191582903712
Rred_1534 vout.$333.Metal1 vout.$718.Metal2 29.347126324
Rred_1535 vout.$333.Metal1 vout.$738.Metal2 9.67111776757
Rred_1536 vout.$333.Metal1 vout.$778.Metal2 167.886188518
Rred_1537 vout.$333.Metal1 vout.P14.pSD 11.3857994955
Rred_1538 vout.$334.Metal1 vout.$354.Metal1 0.191582903712
Rred_1539 vout.$334.Metal1 vout.$720.Metal2 29.347126324
Rred_1540 vout.$334.Metal1 vout.$740.Metal2 9.67111776757
Rred_1541 vout.$334.Metal1 vout.$780.Metal2 167.886188518
Rred_1542 vout.$334.Metal1 vout.P16.pSD 11.3857994955
Rred_1543 vout.$335.Metal1 vout.$355.Metal1 0.191586797682
Rred_1544 vout.$335.Metal1 vout.$722.Metal2 29.347126324
Rred_1545 vout.$335.Metal1 vout.$742.Metal2 10.2622783848
Rred_1546 vout.$335.Metal1 vout.$762.Metal2 82.2952380951
Rred_1547 vout.$335.Metal1 vout.P18.pSD 11.3857994955
Rred_1548 vout.$346.Metal1 vout.$396.Metal1 0.589428843203
Rred_1549 vout.$346.Metal1 vout.$724.Metal2 20.66291551
Rred_1550 vout.$346.Metal1 vout.$764.Metal2 8.36164879815
Rred_1551 vout.$346.Metal1 vout.$784.Metal2 33.7581973834
Rred_1552 vout.$346.Metal1 vout.P0.pSD 8.62442107941
Rred_1553 vout.$347.Metal1 vout.$397.Metal1 0.589428843203
Rred_1554 vout.$347.Metal1 vout.$726.Metal2 20.66291551
Rred_1555 vout.$347.Metal1 vout.$766.Metal2 8.36164879815
Rred_1556 vout.$347.Metal1 vout.$786.Metal2 33.7581973834
Rred_1557 vout.$347.Metal1 vout.P2.pSD 8.62442107941
Rred_1558 vout.$348.Metal1 vout.$398.Metal1 0.589428843203
Rred_1559 vout.$348.Metal1 vout.$728.Metal2 20.66291551
Rred_1560 vout.$348.Metal1 vout.$768.Metal2 8.36164879815
Rred_1561 vout.$348.Metal1 vout.$788.Metal2 33.7581973834
Rred_1562 vout.$348.Metal1 vout.P4.pSD 8.62442107941
Rred_1563 vout.$349.Metal1 vout.$399.Metal1 0.589428843203
Rred_1564 vout.$349.Metal1 vout.$730.Metal2 20.66291551
Rred_1565 vout.$349.Metal1 vout.$770.Metal2 8.36164879815
Rred_1566 vout.$349.Metal1 vout.$790.Metal2 33.7581973834
Rred_1567 vout.$349.Metal1 vout.P6.pSD 8.62442107941
Rred_1568 vout.$350.Metal1 vout.$400.Metal1 0.589428843203
Rred_1569 vout.$350.Metal1 vout.$752.Metal2 10.1286446886
Rred_1570 vout.$350.Metal1 vout.$772.Metal2 14.0453862751
Rred_1571 vout.$350.Metal1 vout.$792.Metal2 33.7581973834
Rred_1572 vout.$350.Metal1 vout.P8.pSD 8.62442107941
Rred_1573 vout.$351.Metal1 vout.$401.Metal1 0.589428843203
Rred_1574 vout.$351.Metal1 vout.$734.Metal2 20.66291551
Rred_1575 vout.$351.Metal1 vout.$774.Metal2 8.36164879815
Rred_1576 vout.$351.Metal1 vout.$794.Metal2 33.7581973834
Rred_1577 vout.$351.Metal1 vout.P10.pSD 8.62442107941
Rred_1578 vout.$352.Metal1 vout.$402.Metal1 0.589428843203
Rred_1579 vout.$352.Metal1 vout.$736.Metal2 20.66291551
Rred_1580 vout.$352.Metal1 vout.$776.Metal2 8.36164879815
Rred_1581 vout.$352.Metal1 vout.$796.Metal2 33.7581973834
Rred_1582 vout.$352.Metal1 vout.P12.pSD 8.62442107941
Rred_1583 vout.$353.Metal1 vout.$403.Metal1 0.589428843203
Rred_1584 vout.$353.Metal1 vout.$738.Metal2 20.66291551
Rred_1585 vout.$353.Metal1 vout.$778.Metal2 8.36164879815
Rred_1586 vout.$353.Metal1 vout.$798.Metal2 33.7581973834
Rred_1587 vout.$353.Metal1 vout.P14.pSD 8.62442107941
Rred_1588 vout.$354.Metal1 vout.$404.Metal1 0.589428843203
Rred_1589 vout.$354.Metal1 vout.$740.Metal2 20.66291551
Rred_1590 vout.$354.Metal1 vout.$780.Metal2 8.36164879815
Rred_1591 vout.$354.Metal1 vout.$800.Metal2 33.7581973834
Rred_1592 vout.$354.Metal1 vout.P16.pSD 8.62442107941
Rred_1593 vout.$355.Metal1 vout.$405.Metal1 0.589428843203
Rred_1594 vout.$355.Metal1 vout.$762.Metal2 10.1286446886
Rred_1595 vout.$355.Metal1 vout.$782.Metal2 14.0453862751
Rred_1596 vout.$355.Metal1 vout.$802.Metal2 33.7581973834
Rred_1597 vout.$355.Metal1 vout.P18.pSD 8.62442107941
Rred_1598 vout.$396.Metal1 vout.$764.Metal2 27.3377293211
Rred_1599 vout.$396.Metal1 vout.$784.Metal2 5.4106819922
Rred_1600 vout.$396.Metal1 vout.P0.pSD 8.62937340344
Rred_1601 vout.$397.Metal1 vout.$766.Metal2 27.3377293211
Rred_1602 vout.$397.Metal1 vout.$786.Metal2 5.4106819922
Rred_1603 vout.$397.Metal1 vout.P2.pSD 8.62937340344
Rred_1604 vout.$398.Metal1 vout.$768.Metal2 27.3377293211
Rred_1605 vout.$398.Metal1 vout.$788.Metal2 5.4106819922
Rred_1606 vout.$398.Metal1 vout.P4.pSD 8.62937340344
Rred_1607 vout.$399.Metal1 vout.$770.Metal2 27.3377293211
Rred_1608 vout.$399.Metal1 vout.$790.Metal2 5.4106819922
Rred_1609 vout.$399.Metal1 vout.P6.pSD 8.62937340344
Rred_1610 vout.$400.Metal1 vout.$772.Metal2 27.3633079929
Rred_1611 vout.$400.Metal1 vout.$792.Metal2 5.4124695611
Rred_1612 vout.$400.Metal1 vout.P8.pSD 8.62937340344
Rred_1613 vout.$401.Metal1 vout.$774.Metal2 27.3377293211
Rred_1614 vout.$401.Metal1 vout.$794.Metal2 5.4106819922
Rred_1615 vout.$401.Metal1 vout.P10.pSD 8.62937340344
Rred_1616 vout.$402.Metal1 vout.$776.Metal2 27.3377293211
Rred_1617 vout.$402.Metal1 vout.$796.Metal2 5.4106819922
Rred_1618 vout.$402.Metal1 vout.P12.pSD 8.62937340344
Rred_1619 vout.$403.Metal1 vout.$778.Metal2 27.3377293211
Rred_1620 vout.$403.Metal1 vout.$798.Metal2 5.4106819922
Rred_1621 vout.$403.Metal1 vout.P14.pSD 8.62937340344
Rred_1622 vout.$404.Metal1 vout.$780.Metal2 27.3633079929
Rred_1623 vout.$404.Metal1 vout.$800.Metal2 5.41461557858
Rred_1624 vout.$404.Metal1 vout.P16.pSD 8.62937340344
Rred_1625 vout.$405.Metal1 vout.$782.Metal2 27.3633079929
Rred_1626 vout.$405.Metal1 vout.$802.Metal2 5.41246762867
Rred_1627 vout.$405.Metal1 vout.P18.pSD 8.62937340344
Rred_1628 vout.$436.Metal2 vout.$456.Metal2 0.180378909705
Rred_1629 vout.$436.Metal2 vout.$61.Metal1 36.8629539855
Rred_1630 vout.$436.Metal2 vout.$864.Metal3 5.03124294697
Rred_1631 vout.$436.Metal2 vout.P0.nSD 1080.97583806
Rred_1632 vout.$438.Metal2 vout.$458.Metal2 0.180262726022
Rred_1633 vout.$438.Metal2 vout.$62.Metal1 36.8629539855
Rred_1634 vout.$438.Metal2 vout.$886.Metal3 5.60971213539
Rred_1635 vout.$438.Metal2 vout.P2.nSD 1080.97583806
Rred_1636 vout.$440.Metal2 vout.$460.Metal2 0.180262726022
Rred_1637 vout.$440.Metal2 vout.$63.Metal1 36.8629539855
Rred_1638 vout.$440.Metal2 vout.$888.Metal3 5.60971213539
Rred_1639 vout.$440.Metal2 vout.P4.nSD 1080.97583806
Rred_1640 vout.$442.Metal2 vout.$462.Metal2 0.180262726022
Rred_1641 vout.$442.Metal2 vout.$64.Metal1 36.8629539855
Rred_1642 vout.$442.Metal2 vout.$890.Metal3 5.60971213539
Rred_1643 vout.$442.Metal2 vout.P6.nSD 1080.97583806
Rred_1644 vout.$444.Metal2 vout.$464.Metal2 0.180262726022
Rred_1645 vout.$444.Metal2 vout.$65.Metal1 36.8629539855
Rred_1646 vout.$444.Metal2 vout.$892.Metal3 5.60971213539
Rred_1647 vout.$444.Metal2 vout.P8.nSD 1080.97583806
Rred_1648 vout.$446.Metal2 vout.$466.Metal2 0.180262726022
Rred_1649 vout.$446.Metal2 vout.$66.Metal1 36.8629539855
Rred_1650 vout.$446.Metal2 vout.$894.Metal3 5.60971213539
Rred_1651 vout.$446.Metal2 vout.P10.nSD 1080.97583806
Rred_1652 vout.$448.Metal2 vout.$468.Metal2 0.180262726022
Rred_1653 vout.$448.Metal2 vout.$67.Metal1 36.8629539855
Rred_1654 vout.$448.Metal2 vout.$896.Metal3 5.60971213539
Rred_1655 vout.$448.Metal2 vout.P12.nSD 1080.97583806
Rred_1656 vout.$450.Metal2 vout.$470.Metal2 0.180378909705
Rred_1657 vout.$450.Metal2 vout.$68.Metal1 36.8629539855
Rred_1658 vout.$450.Metal2 vout.$858.Metal3 4.67562697816
Rred_1659 vout.$450.Metal2 vout.P14.nSD 1080.97583806
Rred_1660 vout.$452.Metal2 vout.$472.Metal2 0.180378909705
Rred_1661 vout.$452.Metal2 vout.$69.Metal1 36.8629539855
Rred_1662 vout.$452.Metal2 vout.$860.Metal3 4.67524464256
Rred_1663 vout.$452.Metal2 vout.P16.nSD 1080.97583806
Rred_1664 vout.$454.Metal2 vout.$474.Metal2 0.180378909705
Rred_1665 vout.$454.Metal2 vout.$70.Metal1 36.8629539855
Rred_1666 vout.$454.Metal2 vout.$862.Metal3 4.67546108849
Rred_1667 vout.$454.Metal2 vout.P18.nSD 1080.97583806
Rred_1668 vout.$456.Metal2 vout.$476.Metal2 0.1804
Rred_1669 vout.$456.Metal2 vout.$61.Metal1 14.7379363825
Rred_1670 vout.$456.Metal2 vout.$864.Metal3 9
Rred_1671 vout.$456.Metal2 vout.P0.nSD 820.807297694
Rred_1672 vout.$458.Metal2 vout.$498.Metal2 0.368032035556
Rred_1673 vout.$458.Metal2 vout.$62.Metal1 8.17554782771
Rred_1674 vout.$458.Metal2 vout.$886.Metal3 6.47992893904
Rred_1675 vout.$458.Metal2 vout.P2.nSD 820.807297694
Rred_1676 vout.$460.Metal2 vout.$500.Metal2 0.368032035556
Rred_1677 vout.$460.Metal2 vout.$63.Metal1 8.17554782771
Rred_1678 vout.$460.Metal2 vout.$888.Metal3 6.47992893904
Rred_1679 vout.$460.Metal2 vout.P4.nSD 820.807297694
Rred_1680 vout.$462.Metal2 vout.$502.Metal2 0.368032035556
Rred_1681 vout.$462.Metal2 vout.$64.Metal1 8.17554782771
Rred_1682 vout.$462.Metal2 vout.$890.Metal3 6.47992893904
Rred_1683 vout.$462.Metal2 vout.P6.nSD 820.807297694
Rred_1684 vout.$464.Metal2 vout.$504.Metal2 0.368032035556
Rred_1685 vout.$464.Metal2 vout.$65.Metal1 8.17554782771
Rred_1686 vout.$464.Metal2 vout.$892.Metal3 6.47992893904
Rred_1687 vout.$464.Metal2 vout.P8.nSD 820.807297694
Rred_1688 vout.$466.Metal2 vout.$506.Metal2 0.368032035556
Rred_1689 vout.$466.Metal2 vout.$66.Metal1 8.17554782771
Rred_1690 vout.$466.Metal2 vout.$894.Metal3 6.47992893904
Rred_1691 vout.$466.Metal2 vout.P10.nSD 820.807297694
Rred_1692 vout.$468.Metal2 vout.$508.Metal2 0.368032035556
Rred_1693 vout.$468.Metal2 vout.$67.Metal1 8.17554782771
Rred_1694 vout.$468.Metal2 vout.$896.Metal3 6.47992893904
Rred_1695 vout.$468.Metal2 vout.P12.nSD 820.807297694
Rred_1696 vout.$470.Metal2 vout.$510.Metal2 0.368032035556
Rred_1697 vout.$470.Metal2 vout.$68.Metal1 8.17554782771
Rred_1698 vout.$470.Metal2 vout.$858.Metal3 18.3608
Rred_1699 vout.$470.Metal2 vout.$898.Metal3 9.1804
Rred_1700 vout.$470.Metal2 vout.P14.nSD 820.807297694
Rred_1701 vout.$472.Metal2 vout.$512.Metal2 0.368032035556
Rred_1702 vout.$472.Metal2 vout.$69.Metal1 8.17554782771
Rred_1703 vout.$472.Metal2 vout.$860.Metal3 18.3608
Rred_1704 vout.$472.Metal2 vout.$900.Metal3 9.1804
Rred_1705 vout.$472.Metal2 vout.P16.nSD 820.807297694
Rred_1706 vout.$474.Metal2 vout.$514.Metal2 0.368032035556
Rred_1707 vout.$474.Metal2 vout.$70.Metal1 8.17554782771
Rred_1708 vout.$474.Metal2 vout.$862.Metal3 18.3608
Rred_1709 vout.$474.Metal2 vout.$902.Metal3 9.1804
Rred_1710 vout.$474.Metal2 vout.P18.nSD 820.807297694
Rred_1711 vout.$476.Metal2 vout.$496.Metal2 0.1804
Rred_1712 vout.$476.Metal2 vout.$61.Metal1 9
Rred_1713 vout.$476.Metal2 vout.$864.Metal3 18.3608
Rred_1714 vout.$476.Metal2 vout.$904.Metal3 18.3608
Rred_1715 vout.$496.Metal2 vout.$516.Metal2 0.180378912217
Rred_1716 vout.$496.Metal2 vout.$61.Metal1 14.7377604585
Rred_1717 vout.$496.Metal2 vout.$904.Metal3 9
Rred_1718 vout.$496.Metal2 vout.P0.nSD 817.999377695
Rred_1719 vout.$498.Metal2 vout.$518.Metal2 0.180261718607
Rred_1720 vout.$498.Metal2 vout.$62.Metal1 8.1754936915
Rred_1721 vout.$498.Metal2 vout.$886.Metal3 6.46324815475
Rred_1722 vout.$498.Metal2 vout.P2.nSD 817.999377695
Rred_1723 vout.$500.Metal2 vout.$520.Metal2 0.180261718607
Rred_1724 vout.$500.Metal2 vout.$63.Metal1 8.1754936915
Rred_1725 vout.$500.Metal2 vout.$888.Metal3 6.46324815475
Rred_1726 vout.$500.Metal2 vout.P4.nSD 817.999377695
Rred_1727 vout.$502.Metal2 vout.$522.Metal2 0.180261718607
Rred_1728 vout.$502.Metal2 vout.$64.Metal1 8.1754936915
Rred_1729 vout.$502.Metal2 vout.$890.Metal3 6.46324815475
Rred_1730 vout.$502.Metal2 vout.P6.nSD 817.999377695
Rred_1731 vout.$504.Metal2 vout.$524.Metal2 0.180261718607
Rred_1732 vout.$504.Metal2 vout.$65.Metal1 8.1754936915
Rred_1733 vout.$504.Metal2 vout.$892.Metal3 6.46324815475
Rred_1734 vout.$504.Metal2 vout.P8.nSD 817.999377695
Rred_1735 vout.$506.Metal2 vout.$526.Metal2 0.180378912217
Rred_1736 vout.$506.Metal2 vout.$66.Metal1 8.1754936915
Rred_1737 vout.$506.Metal2 vout.$894.Metal3 9.1804
Rred_1738 vout.$506.Metal2 vout.$934.Metal3 18.3608
Rred_1739 vout.$506.Metal2 vout.P10.nSD 817.999377695
Rred_1740 vout.$508.Metal2 vout.$528.Metal2 0.180378912217
Rred_1741 vout.$508.Metal2 vout.$67.Metal1 8.1754936915
Rred_1742 vout.$508.Metal2 vout.$896.Metal3 9.1804
Rred_1743 vout.$508.Metal2 vout.$936.Metal3 18.3608
Rred_1744 vout.$508.Metal2 vout.P12.nSD 817.999377695
Rred_1745 vout.$510.Metal2 vout.$530.Metal2 0.180378912217
Rred_1746 vout.$510.Metal2 vout.$68.Metal1 8.1754936915
Rred_1747 vout.$510.Metal2 vout.$898.Metal3 9.1804
Rred_1748 vout.$510.Metal2 vout.$938.Metal3 18.3608
Rred_1749 vout.$510.Metal2 vout.P14.nSD 817.999377695
Rred_1750 vout.$512.Metal2 vout.$532.Metal2 0.180378912217
Rred_1751 vout.$512.Metal2 vout.$69.Metal1 8.1754936915
Rred_1752 vout.$512.Metal2 vout.$900.Metal3 9.1804
Rred_1753 vout.$512.Metal2 vout.$940.Metal3 18.3608
Rred_1754 vout.$512.Metal2 vout.P16.nSD 817.999377695
Rred_1755 vout.$514.Metal2 vout.$534.Metal2 0.180378912217
Rred_1756 vout.$514.Metal2 vout.$70.Metal1 8.1754936915
Rred_1757 vout.$514.Metal2 vout.$902.Metal3 9.1804
Rred_1758 vout.$514.Metal2 vout.$942.Metal3 18.3608
Rred_1759 vout.$514.Metal2 vout.P18.nSD 817.999377695
Rred_1760 vout.$516.Metal2 vout.$61.Metal1 36.8628478103
Rred_1761 vout.$516.Metal2 vout.$904.Metal3 5.01807384201
Rred_1762 vout.$516.Metal2 vout.P0.nSD 1071.12549178
Rred_1763 vout.$518.Metal2 vout.$62.Metal1 36.8628478103
Rred_1764 vout.$518.Metal2 vout.$886.Metal3 5.56133892572
Rred_1765 vout.$518.Metal2 vout.P2.nSD 1071.12549178
Rred_1766 vout.$520.Metal2 vout.$63.Metal1 36.8628478103
Rred_1767 vout.$520.Metal2 vout.$888.Metal3 5.56133892572
Rred_1768 vout.$520.Metal2 vout.P4.nSD 1071.12549178
Rred_1769 vout.$522.Metal2 vout.$64.Metal1 36.8628478103
Rred_1770 vout.$522.Metal2 vout.$890.Metal3 5.56133892572
Rred_1771 vout.$522.Metal2 vout.P6.nSD 1071.12549178
Rred_1772 vout.$524.Metal2 vout.$65.Metal1 36.8628478103
Rred_1773 vout.$524.Metal2 vout.$892.Metal3 5.56133892572
Rred_1774 vout.$524.Metal2 vout.P8.nSD 1071.12549178
Rred_1775 vout.$526.Metal2 vout.$66.Metal1 36.8628478103
Rred_1776 vout.$526.Metal2 vout.$934.Metal3 4.67562697816
Rred_1777 vout.$526.Metal2 vout.P10.nSD 1071.12549178
Rred_1778 vout.$528.Metal2 vout.$67.Metal1 36.8628478103
Rred_1779 vout.$528.Metal2 vout.$936.Metal3 4.67562697816
Rred_1780 vout.$528.Metal2 vout.P12.nSD 1071.12549178
Rred_1781 vout.$530.Metal2 vout.$68.Metal1 36.8628478103
Rred_1782 vout.$530.Metal2 vout.$938.Metal3 4.67562697816
Rred_1783 vout.$530.Metal2 vout.P14.nSD 1071.12549178
Rred_1784 vout.$532.Metal2 vout.$69.Metal1 36.8628478103
Rred_1785 vout.$532.Metal2 vout.$940.Metal3 4.67562697816
Rred_1786 vout.$532.Metal2 vout.P16.nSD 1071.12549178
Rred_1787 vout.$534.Metal2 vout.$70.Metal1 36.8628478103
Rred_1788 vout.$534.Metal2 vout.$942.Metal3 4.67562697816
Rred_1789 vout.$534.Metal2 vout.P18.nSD 1071.12549178
Rred_1790 vout.$584.Metal2 vout.$604.Metal2 0.180262448049
Rred_1791 vout.$584.Metal2 vout.P0.pSD 1008.61703649
Rred_1792 vout.$586.Metal2 vout.$606.Metal2 0.180262448049
Rred_1793 vout.$586.Metal2 vout.P2.pSD 1008.61703649
Rred_1794 vout.$588.Metal2 vout.$608.Metal2 0.180262448049
Rred_1795 vout.$588.Metal2 vout.P4.pSD 1008.61703649
Rred_1796 vout.$590.Metal2 vout.$610.Metal2 0.180262448049
Rred_1797 vout.$590.Metal2 vout.P6.pSD 1008.61703649
Rred_1798 vout.$592.Metal2 vout.$612.Metal2 0.180262448049
Rred_1799 vout.$592.Metal2 vout.P8.pSD 1008.61703649
Rred_1800 vout.$594.Metal2 vout.$614.Metal2 0.180398715194
Rred_1801 vout.$594.Metal2 vout.P10.pSD 1991.88493672
Rred_1802 vout.$596.Metal2 vout.$616.Metal2 0.180379054418
Rred_1803 vout.$596.Metal2 vout.P12.pSD 1008.61703649
Rred_1804 vout.$598.Metal2 vout.$618.Metal2 0.180379054418
Rred_1805 vout.$598.Metal2 vout.P14.pSD 1008.61703649
Rred_1806 vout.$600.Metal2 vout.$620.Metal2 0.180379054418
Rred_1807 vout.$600.Metal2 vout.P16.pSD 1008.61703649
Rred_1808 vout.$602.Metal2 vout.$622.Metal2 0.180379054418
Rred_1809 vout.$602.Metal2 vout.P18.pSD 1008.61703649
Rred_1810 vout.$604.Metal2 vout.$644.Metal2 0.368025388161
Rred_1811 vout.$604.Metal2 vout.P0.pSD 832.064754456
Rred_1812 vout.$606.Metal2 vout.$646.Metal2 0.368025388161
Rred_1813 vout.$606.Metal2 vout.P2.pSD 832.064754456
Rred_1814 vout.$608.Metal2 vout.$648.Metal2 0.368025388161
Rred_1815 vout.$608.Metal2 vout.P4.pSD 832.064754456
Rred_1816 vout.$61.Metal1 vout.P0.nSD 5.77463667393
Rred_1817 vout.$610.Metal2 vout.$650.Metal2 0.368025388161
Rred_1818 vout.$610.Metal2 vout.P6.pSD 832.064754456
Rred_1819 vout.$612.Metal2 vout.$652.Metal2 0.368025388161
Rred_1820 vout.$612.Metal2 vout.P8.pSD 832.064754456
Rred_1821 vout.$614.Metal2 vout.$634.Metal2 0.1804
Rred_1822 vout.$614.Metal2 vout.P10.pSD 39202.9535312
Rred_1823 vout.$616.Metal2 vout.$656.Metal2 0.368025388161
Rred_1824 vout.$616.Metal2 vout.P12.pSD 832.064754456
Rred_1825 vout.$618.Metal2 vout.$658.Metal2 0.368025388161
Rred_1826 vout.$618.Metal2 vout.P14.pSD 832.064754456
Rred_1827 vout.$62.Metal1 vout.$886.Metal3 916.00443459
Rred_1828 vout.$62.Metal1 vout.P2.nSD 5.77463667393
Rred_1829 vout.$620.Metal2 vout.$660.Metal2 0.368025388161
Rred_1830 vout.$620.Metal2 vout.P16.pSD 832.064754456
Rred_1831 vout.$622.Metal2 vout.$662.Metal2 0.368025388161
Rred_1832 vout.$622.Metal2 vout.P18.pSD 832.064754456
Rred_1833 vout.$63.Metal1 vout.$888.Metal3 916.00443459
Rred_1834 vout.$63.Metal1 vout.P4.nSD 5.77463667393
Rred_1835 vout.$634.Metal2 vout.$654.Metal2 0.1804
Rred_1836 vout.$634.Metal2 vout.P10.pSD 1811.16697888
Rred_1837 vout.$64.Metal1 vout.$890.Metal3 916.00443459
Rred_1838 vout.$64.Metal1 vout.P6.nSD 5.77463667393
Rred_1839 vout.$644.Metal2 vout.$664.Metal2 0.180394721481
Rred_1840 vout.$644.Metal2 vout.P0.pSD 7404.32963091
Rred_1841 vout.$646.Metal2 vout.$666.Metal2 0.180394721481
Rred_1842 vout.$646.Metal2 vout.P2.pSD 7404.32963091
Rred_1843 vout.$648.Metal2 vout.$668.Metal2 0.180394721481
Rred_1844 vout.$648.Metal2 vout.P4.pSD 7404.32963091
Rred_1845 vout.$65.Metal1 vout.$892.Metal3 916.00443459
Rred_1846 vout.$65.Metal1 vout.P8.nSD 5.77463667393
Rred_1847 vout.$650.Metal2 vout.$670.Metal2 0.180394721481
Rred_1848 vout.$650.Metal2 vout.P6.pSD 7404.32963091
Rred_1849 vout.$652.Metal2 vout.$672.Metal2 0.180394721481
Rred_1850 vout.$652.Metal2 vout.P8.pSD 7404.32963091
Rred_1851 vout.$654.Metal2 vout.$674.Metal2 0.180394721481
Rred_1852 vout.$654.Metal2 vout.P10.pSD 7404.32963091
Rred_1853 vout.$656.Metal2 vout.$676.Metal2 0.180394721481
Rred_1854 vout.$656.Metal2 vout.P12.pSD 7404.32963091
Rred_1855 vout.$658.Metal2 vout.$678.Metal2 0.180394721481
Rred_1856 vout.$658.Metal2 vout.P14.pSD 7404.32963091
Rred_1857 vout.$66.Metal1 vout.$894.Metal3 916.00443459
Rred_1858 vout.$66.Metal1 vout.P10.nSD 5.77463667393
Rred_1859 vout.$660.Metal2 vout.$680.Metal2 0.180394721481
Rred_1860 vout.$660.Metal2 vout.P16.pSD 7404.32963091
Rred_1861 vout.$662.Metal2 vout.$682.Metal2 0.180394721481
Rred_1862 vout.$662.Metal2 vout.P18.pSD 7404.32963091
Rred_1863 vout.$664.Metal2 vout.$684.Metal2 0.1804
Rred_1864 vout.$664.Metal2 vout.P0.pSD 2578.53048644
Rred_1865 vout.$666.Metal2 vout.$686.Metal2 0.1804
Rred_1866 vout.$666.Metal2 vout.P2.pSD 2578.53048644
Rred_1867 vout.$668.Metal2 vout.$708.Metal2 0.368012936457
Rred_1868 vout.$668.Metal2 vout.P4.pSD 2578.53048644
Rred_1869 vout.$67.Metal1 vout.$896.Metal3 916.00443459
Rred_1870 vout.$67.Metal1 vout.P12.nSD 5.77463667393
Rred_1871 vout.$670.Metal2 vout.$690.Metal2 0.1804
Rred_1872 vout.$670.Metal2 vout.P6.pSD 2578.53048644
Rred_1873 vout.$672.Metal2 vout.$692.Metal2 0.1804
Rred_1874 vout.$672.Metal2 vout.P8.pSD 2578.53048644
Rred_1875 vout.$674.Metal2 vout.$694.Metal2 0.1804
Rred_1876 vout.$674.Metal2 vout.P10.pSD 2578.53048644
Rred_1877 vout.$676.Metal2 vout.$696.Metal2 0.1804
Rred_1878 vout.$676.Metal2 vout.P12.pSD 2578.53048644
Rred_1879 vout.$678.Metal2 vout.$698.Metal2 0.1804
Rred_1880 vout.$678.Metal2 vout.P14.pSD 2578.53048644
Rred_1881 vout.$68.Metal1 vout.$898.Metal3 916.00443459
Rred_1882 vout.$68.Metal1 vout.P14.nSD 5.77463667393
Rred_1883 vout.$680.Metal2 vout.$700.Metal2 0.1804
Rred_1884 vout.$680.Metal2 vout.P16.pSD 2578.53048644
Rred_1885 vout.$682.Metal2 vout.$722.Metal2 0.368012936457
Rred_1886 vout.$682.Metal2 vout.P18.pSD 2578.53048644
Rred_1887 vout.$684.Metal2 vout.$704.Metal2 0.1804
Rred_1888 vout.$686.Metal2 vout.$706.Metal2 0.1804
Rred_1889 vout.$69.Metal1 vout.$900.Metal3 916.00443459
Rred_1890 vout.$69.Metal1 vout.P16.nSD 5.77463667393
Rred_1891 vout.$690.Metal2 vout.$710.Metal2 0.1804
Rred_1892 vout.$692.Metal2 vout.$712.Metal2 0.180377080103
Rred_1893 vout.$694.Metal2 vout.$714.Metal2 0.1804
Rred_1894 vout.$696.Metal2 vout.$716.Metal2 0.1804
Rred_1895 vout.$698.Metal2 vout.$718.Metal2 0.1804
Rred_1896 vout.$70.Metal1 vout.$902.Metal3 916.00443459
Rred_1897 vout.$70.Metal1 vout.P18.nSD 5.77463667393
Rred_1898 vout.$700.Metal2 vout.$720.Metal2 0.1804
Rred_1899 vout.$704.Metal2 vout.$724.Metal2 0.180394514148
Rred_1900 vout.$704.Metal2 vout.P0.pSD 2635.72741826
Rred_1901 vout.$706.Metal2 vout.$726.Metal2 0.180394514148
Rred_1902 vout.$706.Metal2 vout.P2.pSD 2635.72741826
Rred_1903 vout.$708.Metal2 vout.$728.Metal2 0.180371595645
Rred_1904 vout.$708.Metal2 vout.P4.pSD 2635.72741826
Rred_1905 vout.$710.Metal2 vout.$730.Metal2 0.180394514148
Rred_1906 vout.$710.Metal2 vout.P6.pSD 2635.72741826
Rred_1907 vout.$712.Metal2 vout.$732.Metal2 0.180394514148
Rred_1908 vout.$712.Metal2 vout.P8.pSD 2635.72741826
Rred_1909 vout.$714.Metal2 vout.$734.Metal2 0.180394514148
Rred_1910 vout.$714.Metal2 vout.P10.pSD 2635.72741826
Rred_1911 vout.$716.Metal2 vout.$736.Metal2 0.180394514148
Rred_1912 vout.$716.Metal2 vout.P12.pSD 2635.72741826
Rred_1913 vout.$718.Metal2 vout.$738.Metal2 0.180394514148
Rred_1914 vout.$718.Metal2 vout.P14.pSD 2635.72741826
Rred_1915 vout.$720.Metal2 vout.$740.Metal2 0.180394514148
Rred_1916 vout.$720.Metal2 vout.P16.pSD 2635.72741826
Rred_1917 vout.$722.Metal2 vout.$742.Metal2 0.180394514148
Rred_1918 vout.$722.Metal2 vout.P18.pSD 2635.72741826
Rred_1919 vout.$724.Metal2 vout.$764.Metal2 0.368024555366
Rred_1920 vout.$724.Metal2 vout.P0.pSD 6969.06840536
Rred_1921 vout.$726.Metal2 vout.$766.Metal2 0.368024555366
Rred_1922 vout.$726.Metal2 vout.P2.pSD 6969.06840536
Rred_1923 vout.$728.Metal2 vout.$768.Metal2 0.368024555366
Rred_1924 vout.$728.Metal2 vout.P4.pSD 6969.06840536
Rred_1925 vout.$730.Metal2 vout.$770.Metal2 0.368024555366
Rred_1926 vout.$730.Metal2 vout.P6.pSD 6969.06840536
Rred_1927 vout.$732.Metal2 vout.$752.Metal2 0.1804
Rred_1928 vout.$732.Metal2 vout.P8.pSD 6969.06840536
Rred_1929 vout.$734.Metal2 vout.$774.Metal2 0.368024555366
Rred_1930 vout.$734.Metal2 vout.P10.pSD 6969.06840536
Rred_1931 vout.$736.Metal2 vout.$776.Metal2 0.368024555366
Rred_1932 vout.$736.Metal2 vout.P12.pSD 6969.06840536
Rred_1933 vout.$738.Metal2 vout.$778.Metal2 0.368024555366
Rred_1934 vout.$738.Metal2 vout.P14.pSD 6969.06840536
Rred_1935 vout.$740.Metal2 vout.$780.Metal2 0.368024555366
Rred_1936 vout.$740.Metal2 vout.P16.pSD 6969.06840536
Rred_1937 vout.$742.Metal2 vout.$762.Metal2 0.1804
Rred_1938 vout.$742.Metal2 vout.P18.pSD 6969.06840536
Rred_1939 vout.$752.Metal2 vout.$772.Metal2 0.1804
Rred_1940 vout.$762.Metal2 vout.$782.Metal2 0.1804
Rred_1941 vout.$764.Metal2 vout.$784.Metal2 0.180263053343
Rred_1942 vout.$764.Metal2 vout.P0.pSD 835.901910051
Rred_1943 vout.$766.Metal2 vout.$786.Metal2 0.180263053343
Rred_1944 vout.$766.Metal2 vout.P2.pSD 835.901910051
Rred_1945 vout.$768.Metal2 vout.$788.Metal2 0.180263053343
Rred_1946 vout.$768.Metal2 vout.P4.pSD 835.901910051
Rred_1947 vout.$770.Metal2 vout.$790.Metal2 0.180263053343
Rred_1948 vout.$770.Metal2 vout.P6.pSD 835.901910051
Rred_1949 vout.$772.Metal2 vout.$792.Metal2 0.180379236211
Rred_1950 vout.$772.Metal2 vout.P8.pSD 835.901910051
Rred_1951 vout.$774.Metal2 vout.$794.Metal2 0.180263053343
Rred_1952 vout.$774.Metal2 vout.P10.pSD 835.901910051
Rred_1953 vout.$776.Metal2 vout.$796.Metal2 0.180263053343
Rred_1954 vout.$776.Metal2 vout.P12.pSD 835.901910051
Rred_1955 vout.$778.Metal2 vout.$798.Metal2 0.180263053343
Rred_1956 vout.$778.Metal2 vout.P14.pSD 835.901910051
Rred_1957 vout.$780.Metal2 vout.$800.Metal2 0.180379236211
Rred_1958 vout.$780.Metal2 vout.P16.pSD 835.901910051
Rred_1959 vout.$782.Metal2 vout.$802.Metal2 0.180379236211
Rred_1960 vout.$782.Metal2 vout.P18.pSD 835.901910051
Rred_1961 vout.$784.Metal2 vout.P0.pSD 1003.73271272
Rred_1962 vout.$786.Metal2 vout.P2.pSD 1003.73271272
Rred_1963 vout.$788.Metal2 vout.P4.pSD 1003.73271272
Rred_1964 vout.$790.Metal2 vout.P6.pSD 1003.73271272
Rred_1965 vout.$792.Metal2 vout.P8.pSD 1003.73271272
Rred_1966 vout.$794.Metal2 vout.P10.pSD 1003.73271272
Rred_1967 vout.$796.Metal2 vout.P12.pSD 1003.73271272
Rred_1968 vout.$798.Metal2 vout.P14.pSD 1003.73271272
Rred_1969 vout.$800.Metal2 vout.P16.pSD 1003.73271272
Rred_1970 vout.$802.Metal2 vout.P18.pSD 1003.73271272
Rred_1971 vout.$858.Metal3 vout.$898.Metal3 0.368032035556
Rred_1972 vout.$860.Metal3 vout.$900.Metal3 0.368032035556
Rred_1973 vout.$862.Metal3 vout.$902.Metal3 0.368032035556
Rred_1974 vout.$864.Metal3 vout.$904.Metal3 0.368032035556
Rred_1975 vout.$894.Metal3 vout.$934.Metal3 0.368032035556
Rred_1976 vout.$896.Metal3 vout.$936.Metal3 0.368032035556
Rred_1977 vout.$898.Metal3 vout.$938.Metal3 0.368032035556
Rred_1978 vout.$900.Metal3 vout.$940.Metal3 0.368032035556
Rred_1979 vout.$902.Metal3 vout.$942.Metal3 0.368032035556
Rred_1980 vref vref.P0.GatPoly 12.3471093024
Rred_1981 vref vref.P0.nSD 20.4154763749
Rred_1982 vref vref.P0.pSD 11.6477658208
Rred_1983 vref.P0.GatPoly vref.P0.nSD 523.549171057
Rred_1984 vref.P0.GatPoly vref.P0.pSD 298.703690679
Rred_1985 vref.P0.nSD vref.P0.pSD 52.105523185
Rred_1986 vss vss.$1212.Metal5 1.09085715005
Rred_1987 vss vss.$1230.Metal5 1.09085715005
Rred_1988 vss vss.$1282.Metal5 0.28498320179
Rred_1989 vss vss.$1300.Metal5 0.28498320179
Rred_1990 vss.$10.Metal1 vss.$127.Metal1 0.134556072844
Rred_1991 vss.$10.Metal1 vss.$13.Metal1 0.134538560711
Rred_1992 vss.$10.Metal1 vss.$461.Metal2 9.21369386944
Rred_1993 vss.$10.Metal1 vss.$463.Metal2 2.60867094883
Rred_1994 vss.$10.Metal1 vss.$467.Metal2 2.60638001377
Rred_1995 vss.$10.Metal1 vss.$469.Metal2 9.21269223899
Rred_1996 vss.$10.Metal1 vss.$799.Metal3 515.070113458
Rred_1997 vss.$10.Metal1 vss.P0.pSD 4.74580830545
Rred_1998 vss.$10.Metal1 vss.P1.nSD 2438.33841934
Rred_1999 vss.$1001.Metal4 vss.$1003.Metal4 0.0353725490196
Rred_2000 vss.$1001.Metal4 vss.$1212.Metal5 9
Rred_2001 vss.$1001.Metal4 vss.$1247.Metal5 9
Rred_2002 vss.$1001.Metal4 vss.$1282.Metal5 9
Rred_2003 vss.$1001.Metal4 vss.$457.Metal2 260.4345898
Rred_2004 vss.$1001.Metal4 vss.$793.Metal3 3.07074509804
Rred_2005 vss.$1003.Metal4 vss.$1005.Metal4 0.0353725490196
Rred_2006 vss.$1003.Metal4 vss.$1212.Metal5 9
Rred_2007 vss.$1003.Metal4 vss.$1247.Metal5 9
Rred_2008 vss.$1003.Metal4 vss.$1282.Metal5 9
Rred_2009 vss.$1003.Metal4 vss.$793.Metal3 3
Rred_2010 vss.$1005.Metal4 vss.$1007.Metal4 0.0353725490196
Rred_2011 vss.$1005.Metal4 vss.$1212.Metal5 9
Rred_2012 vss.$1005.Metal4 vss.$1247.Metal5 9
Rred_2013 vss.$1005.Metal4 vss.$1282.Metal5 9
Rred_2014 vss.$1005.Metal4 vss.$795.Metal3 3
Rred_2015 vss.$1007.Metal4 vss.$1009.Metal4 0.0353725490196
Rred_2016 vss.$1007.Metal4 vss.$1212.Metal5 9
Rred_2017 vss.$1007.Metal4 vss.$1247.Metal5 9
Rred_2018 vss.$1007.Metal4 vss.$1282.Metal5 9
Rred_2019 vss.$1007.Metal4 vss.$463.Metal2 514.869179601
Rred_2020 vss.$1007.Metal4 vss.$795.Metal3 6.07074509804
Rred_2021 vss.$1007.Metal4 vss.$799.Metal3 6.07074509804
Rred_2022 vss.$1009.Metal4 vss.$1011.Metal4 0.0353725490196
Rred_2023 vss.$1009.Metal4 vss.$1212.Metal5 9
Rred_2024 vss.$1009.Metal4 vss.$1247.Metal5 9
Rred_2025 vss.$1009.Metal4 vss.$1282.Metal5 9
Rred_2026 vss.$1009.Metal4 vss.$799.Metal3 3
Rred_2027 vss.$1011.Metal4 vss.$1013.Metal4 0.0353725490196
Rred_2028 vss.$1011.Metal4 vss.$1212.Metal5 9
Rred_2029 vss.$1011.Metal4 vss.$1247.Metal5 9
Rred_2030 vss.$1011.Metal4 vss.$1282.Metal5 9
Rred_2031 vss.$1011.Metal4 vss.$801.Metal3 3
Rred_2032 vss.$1013.Metal4 vss.$1015.Metal4 0.0353725490196
Rred_2033 vss.$1013.Metal4 vss.$1212.Metal5 9
Rred_2034 vss.$1013.Metal4 vss.$1247.Metal5 9
Rred_2035 vss.$1013.Metal4 vss.$1282.Metal5 9
Rred_2036 vss.$1013.Metal4 vss.$469.Metal2 514.869179601
Rred_2037 vss.$1013.Metal4 vss.$801.Metal3 6.07074509804
Rred_2038 vss.$1013.Metal4 vss.$805.Metal3 6.07074509804
Rred_2039 vss.$1015.Metal4 vss.$1017.Metal4 0.0353725490196
Rred_2040 vss.$1015.Metal4 vss.$1212.Metal5 9
Rred_2041 vss.$1015.Metal4 vss.$1247.Metal5 9
Rred_2042 vss.$1015.Metal4 vss.$1282.Metal5 9
Rred_2043 vss.$1015.Metal4 vss.$805.Metal3 3
Rred_2044 vss.$1017.Metal4 vss.$1019.Metal4 0.0353725490196
Rred_2045 vss.$1017.Metal4 vss.$1212.Metal5 9
Rred_2046 vss.$1017.Metal4 vss.$1247.Metal5 9
Rred_2047 vss.$1017.Metal4 vss.$1282.Metal5 9
Rred_2048 vss.$1017.Metal4 vss.$473.Metal2 514.869179601
Rred_2049 vss.$1017.Metal4 vss.$805.Metal3 6.07074509804
Rred_2050 vss.$1017.Metal4 vss.$809.Metal3 6.07074509804
Rred_2051 vss.$1019.Metal4 vss.$1021.Metal4 0.0353725490196
Rred_2052 vss.$1019.Metal4 vss.$1212.Metal5 9
Rred_2053 vss.$1019.Metal4 vss.$1247.Metal5 9
Rred_2054 vss.$1019.Metal4 vss.$1282.Metal5 9
Rred_2055 vss.$1019.Metal4 vss.$809.Metal3 3
Rred_2056 vss.$1021.Metal4 vss.$1023.Metal4 0.0353725490196
Rred_2057 vss.$1021.Metal4 vss.$1212.Metal5 9
Rred_2058 vss.$1021.Metal4 vss.$1247.Metal5 9
Rred_2059 vss.$1021.Metal4 vss.$1282.Metal5 9
Rred_2060 vss.$1021.Metal4 vss.$811.Metal3 3
Rred_2061 vss.$1023.Metal4 vss.$1025.Metal4 0.0353725490196
Rred_2062 vss.$1023.Metal4 vss.$1212.Metal5 9
Rred_2063 vss.$1023.Metal4 vss.$1247.Metal5 9
Rred_2064 vss.$1023.Metal4 vss.$1282.Metal5 9
Rred_2065 vss.$1023.Metal4 vss.$479.Metal2 514.869179601
Rred_2066 vss.$1023.Metal4 vss.$811.Metal3 6.07074509804
Rred_2067 vss.$1023.Metal4 vss.$815.Metal3 6.07074509804
Rred_2068 vss.$1025.Metal4 vss.$1027.Metal4 0.0353725490196
Rred_2069 vss.$1025.Metal4 vss.$1212.Metal5 9
Rred_2070 vss.$1025.Metal4 vss.$1247.Metal5 9
Rred_2071 vss.$1025.Metal4 vss.$1282.Metal5 9
Rred_2072 vss.$1025.Metal4 vss.$815.Metal3 3
Rred_2073 vss.$1027.Metal4 vss.$1029.Metal4 0.0353725490196
Rred_2074 vss.$1027.Metal4 vss.$1212.Metal5 9
Rred_2075 vss.$1027.Metal4 vss.$1247.Metal5 9
Rred_2076 vss.$1027.Metal4 vss.$1282.Metal5 9
Rred_2077 vss.$1027.Metal4 vss.$483.Metal2 514.869179601
Rred_2078 vss.$1027.Metal4 vss.$815.Metal3 6.07074509804
Rred_2079 vss.$1027.Metal4 vss.$819.Metal3 6.07074509804
Rred_2080 vss.$1029.Metal4 vss.$1031.Metal4 0.0353725490196
Rred_2081 vss.$1029.Metal4 vss.$1212.Metal5 9
Rred_2082 vss.$1029.Metal4 vss.$1247.Metal5 9
Rred_2083 vss.$1029.Metal4 vss.$1282.Metal5 9
Rred_2084 vss.$1029.Metal4 vss.$819.Metal3 3
Rred_2085 vss.$1031.Metal4 vss.$1033.Metal4 0.0353725490196
Rred_2086 vss.$1031.Metal4 vss.$1212.Metal5 9
Rred_2087 vss.$1031.Metal4 vss.$1247.Metal5 9
Rred_2088 vss.$1031.Metal4 vss.$1282.Metal5 9
Rred_2089 vss.$1031.Metal4 vss.$821.Metal3 3
Rred_2090 vss.$1033.Metal4 vss.$1037.Metal4 0.0715771156688
Rred_2091 vss.$1033.Metal4 vss.$1212.Metal5 9
Rred_2092 vss.$1033.Metal4 vss.$1247.Metal5 3.63636011347
Rred_2093 vss.$1033.Metal4 vss.$1282.Metal5 9
Rred_2094 vss.$1033.Metal4 vss.$489.Metal2 514.869179601
Rred_2095 vss.$1033.Metal4 vss.$821.Metal3 6.07074509804
Rred_2096 vss.$1033.Metal4 vss.$825.Metal3 3.03532744586
Rred_2097 vss.$1037.Metal4 vss.$1039.Metal4 0.0353725490196
Rred_2098 vss.$1037.Metal4 vss.$1230.Metal5 9
Rred_2099 vss.$1037.Metal4 vss.$1247.Metal5 3.63636011347
Rred_2100 vss.$1037.Metal4 vss.$1300.Metal5 9
Rred_2101 vss.$1037.Metal4 vss.$493.Metal2 514.869179601
Rred_2102 vss.$1037.Metal4 vss.$825.Metal3 3.03532744586
Rred_2103 vss.$1037.Metal4 vss.$829.Metal3 6.07074509804
Rred_2104 vss.$1039.Metal4 vss.$1041.Metal4 0.0353725490196
Rred_2105 vss.$1039.Metal4 vss.$1230.Metal5 9
Rred_2106 vss.$1039.Metal4 vss.$1247.Metal5 9
Rred_2107 vss.$1039.Metal4 vss.$1300.Metal5 9
Rred_2108 vss.$1039.Metal4 vss.$829.Metal3 3
Rred_2109 vss.$1041.Metal4 vss.$1043.Metal4 0.0353725490196
Rred_2110 vss.$1041.Metal4 vss.$1230.Metal5 9
Rred_2111 vss.$1041.Metal4 vss.$1247.Metal5 9
Rred_2112 vss.$1041.Metal4 vss.$1300.Metal5 9
Rred_2113 vss.$1041.Metal4 vss.$831.Metal3 3
Rred_2114 vss.$1043.Metal4 vss.$1045.Metal4 0.0353725490196
Rred_2115 vss.$1043.Metal4 vss.$1230.Metal5 9
Rred_2116 vss.$1043.Metal4 vss.$1247.Metal5 9
Rred_2117 vss.$1043.Metal4 vss.$1300.Metal5 9
Rred_2118 vss.$1043.Metal4 vss.$499.Metal2 514.869179601
Rred_2119 vss.$1043.Metal4 vss.$831.Metal3 6.07074509804
Rred_2120 vss.$1043.Metal4 vss.$835.Metal3 6.07074509804
Rred_2121 vss.$1045.Metal4 vss.$1047.Metal4 0.0353725490196
Rred_2122 vss.$1045.Metal4 vss.$1230.Metal5 9
Rred_2123 vss.$1045.Metal4 vss.$1247.Metal5 9
Rred_2124 vss.$1045.Metal4 vss.$1300.Metal5 9
Rred_2125 vss.$1045.Metal4 vss.$835.Metal3 3
Rred_2126 vss.$1047.Metal4 vss.$1049.Metal4 0.0353725490196
Rred_2127 vss.$1047.Metal4 vss.$1230.Metal5 9
Rred_2128 vss.$1047.Metal4 vss.$1247.Metal5 9
Rred_2129 vss.$1047.Metal4 vss.$1300.Metal5 9
Rred_2130 vss.$1047.Metal4 vss.$503.Metal2 514.869179601
Rred_2131 vss.$1047.Metal4 vss.$835.Metal3 6.07074509804
Rred_2132 vss.$1047.Metal4 vss.$839.Metal3 6.07074509804
Rred_2133 vss.$1049.Metal4 vss.$1051.Metal4 0.0353725490196
Rred_2134 vss.$1049.Metal4 vss.$1230.Metal5 9
Rred_2135 vss.$1049.Metal4 vss.$1247.Metal5 9
Rred_2136 vss.$1049.Metal4 vss.$1300.Metal5 9
Rred_2137 vss.$1049.Metal4 vss.$839.Metal3 3
Rred_2138 vss.$1051.Metal4 vss.$1053.Metal4 0.0353725490196
Rred_2139 vss.$1051.Metal4 vss.$1230.Metal5 9
Rred_2140 vss.$1051.Metal4 vss.$1247.Metal5 9
Rred_2141 vss.$1051.Metal4 vss.$1300.Metal5 9
Rred_2142 vss.$1051.Metal4 vss.$841.Metal3 3
Rred_2143 vss.$1053.Metal4 vss.$1055.Metal4 0.0353725490196
Rred_2144 vss.$1053.Metal4 vss.$1230.Metal5 9
Rred_2145 vss.$1053.Metal4 vss.$1247.Metal5 9
Rred_2146 vss.$1053.Metal4 vss.$1300.Metal5 9
Rred_2147 vss.$1053.Metal4 vss.$509.Metal2 514.869179601
Rred_2148 vss.$1053.Metal4 vss.$841.Metal3 6.07074509804
Rred_2149 vss.$1053.Metal4 vss.$845.Metal3 6.07074509804
Rred_2150 vss.$1055.Metal4 vss.$1057.Metal4 0.0353725490196
Rred_2151 vss.$1055.Metal4 vss.$1230.Metal5 9
Rred_2152 vss.$1055.Metal4 vss.$1247.Metal5 9
Rred_2153 vss.$1055.Metal4 vss.$1300.Metal5 9
Rred_2154 vss.$1055.Metal4 vss.$845.Metal3 3
Rred_2155 vss.$1057.Metal4 vss.$1059.Metal4 0.0353725490196
Rred_2156 vss.$1057.Metal4 vss.$1230.Metal5 9
Rred_2157 vss.$1057.Metal4 vss.$1247.Metal5 9
Rred_2158 vss.$1057.Metal4 vss.$1300.Metal5 9
Rred_2159 vss.$1057.Metal4 vss.$513.Metal2 514.869179601
Rred_2160 vss.$1057.Metal4 vss.$845.Metal3 6.07074509804
Rred_2161 vss.$1057.Metal4 vss.$849.Metal3 6.07074509804
Rred_2162 vss.$1059.Metal4 vss.$1061.Metal4 0.0353725490196
Rred_2163 vss.$1059.Metal4 vss.$1230.Metal5 9
Rred_2164 vss.$1059.Metal4 vss.$1247.Metal5 9
Rred_2165 vss.$1059.Metal4 vss.$1300.Metal5 9
Rred_2166 vss.$1059.Metal4 vss.$849.Metal3 3
Rred_2167 vss.$1061.Metal4 vss.$1063.Metal4 0.0353725490196
Rred_2168 vss.$1061.Metal4 vss.$1230.Metal5 9
Rred_2169 vss.$1061.Metal4 vss.$1247.Metal5 9
Rred_2170 vss.$1061.Metal4 vss.$1300.Metal5 9
Rred_2171 vss.$1061.Metal4 vss.$851.Metal3 3
Rred_2172 vss.$1063.Metal4 vss.$1065.Metal4 0.0353725490196
Rred_2173 vss.$1063.Metal4 vss.$1230.Metal5 9
Rred_2174 vss.$1063.Metal4 vss.$1247.Metal5 9
Rred_2175 vss.$1063.Metal4 vss.$1300.Metal5 9
Rred_2176 vss.$1063.Metal4 vss.$519.Metal2 514.869179601
Rred_2177 vss.$1063.Metal4 vss.$851.Metal3 6.07074509804
Rred_2178 vss.$1063.Metal4 vss.$855.Metal3 6.07074509804
Rred_2179 vss.$1065.Metal4 vss.$1067.Metal4 0.0353725490196
Rred_2180 vss.$1065.Metal4 vss.$1230.Metal5 9
Rred_2181 vss.$1065.Metal4 vss.$1247.Metal5 9
Rred_2182 vss.$1065.Metal4 vss.$1300.Metal5 9
Rred_2183 vss.$1065.Metal4 vss.$855.Metal3 3
Rred_2184 vss.$1067.Metal4 vss.$1069.Metal4 0.0353725490196
Rred_2185 vss.$1067.Metal4 vss.$1230.Metal5 9
Rred_2186 vss.$1067.Metal4 vss.$1247.Metal5 9
Rred_2187 vss.$1067.Metal4 vss.$1300.Metal5 9
Rred_2188 vss.$1067.Metal4 vss.$857.Metal3 3
Rred_2189 vss.$1069.Metal4 vss.$1230.Metal5 9
Rred_2190 vss.$1069.Metal4 vss.$1247.Metal5 9
Rred_2191 vss.$1069.Metal4 vss.$1300.Metal5 9
Rred_2192 vss.$1069.Metal4 vss.$525.Metal2 260.4345898
Rred_2193 vss.$1069.Metal4 vss.$857.Metal3 3.07074509804
Rred_2194 vss.$1212.Metal5 vss.$1230.Metal5 0.203098938424
Rred_2195 vss.$1212.Metal5 vss.$1247.Metal5 0.00322142857143
Rred_2196 vss.$1212.Metal5 vss.$1282.Metal5 0.27633192602
Rred_2197 vss.$1212.Metal5 vss.$1300.Metal5 0.27633192602
Rred_2198 vss.$1230.Metal5 vss.$1247.Metal5 0.00322142857143
Rred_2199 vss.$1230.Metal5 vss.$1282.Metal5 0.27633192602
Rred_2200 vss.$1230.Metal5 vss.$1300.Metal5 0.27633192602
Rred_2201 vss.$1247.Metal5 vss.$1282.Metal5 0.00322142857143
Rred_2202 vss.$1247.Metal5 vss.$1300.Metal5 0.00322142857143
Rred_2203 vss.$1247.Metal5 vss.$825.Metal3 517.493239709
Rred_2204 vss.$127.Metal1 vss.$406.Metal1 374.726775254
Rred_2205 vss.$127.Metal1 vss.$457.Metal2 2.06926800761
Rred_2206 vss.$127.Metal1 vss.$461.Metal2 2.6061656473
Rred_2207 vss.$127.Metal1 vss.$463.Metal2 9.21566959287
Rred_2208 vss.$127.Metal1 vss.$793.Metal3 514.869179601
Rred_2209 vss.$127.Metal1 vss.P0.GatPoly 575.585257501
Rred_2210 vss.$127.Metal1 vss.P0.pSD 1.2050918941
Rred_2211 vss.$1282.Metal5 vss.$1300.Metal5 0.0721908977999
Rred_2212 vss.$13.Metal1 vss.$136.Metal1 0.13455399662
Rred_2213 vss.$13.Metal1 vss.$467.Metal2 9.21249473047
Rred_2214 vss.$13.Metal1 vss.$469.Metal2 2.60592749965
Rred_2215 vss.$13.Metal1 vss.$473.Metal2 2.60626324174
Rred_2216 vss.$13.Metal1 vss.$475.Metal2 9.21338239481
Rred_2217 vss.$13.Metal1 vss.$805.Metal3 514.869179601
Rred_2218 vss.$13.Metal1 vss.P0.pSD 4.73467894859
Rred_2219 vss.$136.Metal1 vss.$138.Metal1 0.0883961537984
Rred_2220 vss.$136.Metal1 vss.$473.Metal2 9.21535783425
Rred_2221 vss.$136.Metal1 vss.$475.Metal2 2.60635479028
Rred_2222 vss.$136.Metal1 vss.$479.Metal2 3.0332974638
Rred_2223 vss.$136.Metal1 vss.$811.Metal3 514.965519391
Rred_2224 vss.$136.Metal1 vss.P0.pSD 5.7678802464
Rred_2225 vss.$136.Metal1 vss.P7.nSD 3520.07859317
Rred_2226 vss.$138.Metal1 vss.$141.Metal1 0.134551359086
Rred_2227 vss.$138.Metal1 vss.$479.Metal2 3.03081295291
Rred_2228 vss.$138.Metal1 vss.$483.Metal2 2.60619510061
Rred_2229 vss.$138.Metal1 vss.$485.Metal2 9.21306071311
Rred_2230 vss.$138.Metal1 vss.$815.Metal3 514.869179601
Rred_2231 vss.$138.Metal1 vss.P0.pSD 5.61221754303
Rred_2232 vss.$141.Metal1 vss.$143.Metal1 0.0883946546717
Rred_2233 vss.$141.Metal1 vss.$483.Metal2 9.2150641606
Rred_2234 vss.$141.Metal1 vss.$485.Metal2 2.60638435994
Rred_2235 vss.$141.Metal1 vss.$489.Metal2 3.03353557858
Rred_2236 vss.$141.Metal1 vss.$821.Metal3 514.988105384
Rred_2237 vss.$141.Metal1 vss.P0.pSD 5.78350760884
Rred_2238 vss.$141.Metal1 vss.P11.nSD 3168.53550554
Rred_2239 vss.$143.Metal1 vss.$146.Metal1 0.134537302287
Rred_2240 vss.$143.Metal1 vss.$489.Metal2 3.03079650983
Rred_2241 vss.$143.Metal1 vss.$493.Metal2 2.60589524409
Rred_2242 vss.$143.Metal1 vss.$495.Metal2 9.21209820967
Rred_2243 vss.$143.Metal1 vss.$825.Metal3 514.869179601
Rred_2244 vss.$143.Metal1 vss.P0.pSD 7.50179614844
Rred_2245 vss.$146.Metal1 vss.$148.Metal1 0.0883949469849
Rred_2246 vss.$146.Metal1 vss.$493.Metal2 9.21308576115
Rred_2247 vss.$146.Metal1 vss.$495.Metal2 2.60628807433
Rred_2248 vss.$146.Metal1 vss.$499.Metal2 3.03392302457
Rred_2249 vss.$146.Metal1 vss.$831.Metal3 515.013066347
Rred_2250 vss.$146.Metal1 vss.P0.pSD 5.74259719315
Rred_2251 vss.$146.Metal1 vss.P15.nSD 2880.89572544
Rred_2252 vss.$148.Metal1 vss.$150.Metal1 0.0883961537984
Rred_2253 vss.$148.Metal1 vss.$499.Metal2 3.03109437568
Rred_2254 vss.$148.Metal1 vss.$503.Metal2 3.03081295291
Rred_2255 vss.$148.Metal1 vss.$835.Metal3 514.869179601
Rred_2256 vss.$148.Metal1 vss.P0.pSD 6.96855884686
Rred_2257 vss.$150.Metal1 vss.$153.Metal1 0.13455399662
Rred_2258 vss.$150.Metal1 vss.$503.Metal2 3.0332974638
Rred_2259 vss.$150.Metal1 vss.$507.Metal2 2.60635479028
Rred_2260 vss.$150.Metal1 vss.$509.Metal2 9.21535783425
Rred_2261 vss.$150.Metal1 vss.$839.Metal3 514.965519391
Rred_2262 vss.$150.Metal1 vss.P0.pSD 5.7678802464
Rred_2263 vss.$150.Metal1 vss.P17.nSD 3520.07859317
Rred_2264 vss.$153.Metal1 vss.$156.Metal1 0.134538560711
Rred_2265 vss.$153.Metal1 vss.$507.Metal2 9.21338239481
Rred_2266 vss.$153.Metal1 vss.$509.Metal2 2.60626324174
Rred_2267 vss.$153.Metal1 vss.$513.Metal2 2.60592749965
Rred_2268 vss.$153.Metal1 vss.$515.Metal2 9.21249473047
Rred_2269 vss.$153.Metal1 vss.$845.Metal3 514.869179601
Rred_2270 vss.$153.Metal1 vss.P0.pSD 4.73467894859
Rred_2271 vss.$156.Metal1 vss.$159.Metal1 0.134556072844
Rred_2272 vss.$156.Metal1 vss.$513.Metal2 9.21269223899
Rred_2273 vss.$156.Metal1 vss.$515.Metal2 2.60638001377
Rred_2274 vss.$156.Metal1 vss.$519.Metal2 2.60867094883
Rred_2275 vss.$156.Metal1 vss.$521.Metal2 9.21369386944
Rred_2276 vss.$156.Metal1 vss.$851.Metal3 515.070113458
Rred_2277 vss.$156.Metal1 vss.P0.pSD 4.74580830545
Rred_2278 vss.$156.Metal1 vss.P23.nSD 2438.33841934
Rred_2279 vss.$159.Metal1 vss.$406.Metal1 4.29246196613
Rred_2280 vss.$159.Metal1 vss.$519.Metal2 9.21566959287
Rred_2281 vss.$159.Metal1 vss.$521.Metal2 2.6061656473
Rred_2282 vss.$159.Metal1 vss.$525.Metal2 2.07168750645
Rred_2283 vss.$159.Metal1 vss.$857.Metal3 514.869179601
Rred_2284 vss.$159.Metal1 vss.P0.pSD 1.56224438002
Rred_2285 vss.$159.Metal1 vss.P1.GatPoly 2810.6786005
Rred_2286 vss.$406.Metal1 vss.$457.Metal2 25657.6732202
Rred_2287 vss.$406.Metal1 vss.$525.Metal2 293.906370482
Rred_2288 vss.$406.Metal1 vss.P0.GatPoly 10481.5830669
Rred_2289 vss.$406.Metal1 vss.P0.pSD 0.864494745687
Rred_2290 vss.$406.Metal1 vss.P1.GatPoly 120.065604144
Rred_2291 vss.$457.Metal2 vss.$461.Metal2 0.0715792428553
Rred_2292 vss.$457.Metal2 vss.$793.Metal3 2.03924200009
Rred_2293 vss.$457.Metal2 vss.P0.GatPoly 39410.5236737
Rred_2294 vss.$457.Metal2 vss.P0.pSD 99.2208713675
Rred_2295 vss.$461.Metal2 vss.$463.Metal2 0.0353894398326
Rred_2296 vss.$461.Metal2 vss.$793.Metal3 6.07074509804
Rred_2297 vss.$461.Metal2 vss.$795.Metal3 3
Rred_2298 vss.$461.Metal2 vss.P0.nSD 4.85289602321
Rred_2299 vss.$461.Metal2 vss.P0.pSD 965.693169401
Rred_2300 vss.$463.Metal2 vss.$467.Metal2 0.0717291852966
Rred_2301 vss.$463.Metal2 vss.$795.Metal3 6.07074509804
Rred_2302 vss.$463.Metal2 vss.$799.Metal3 3.0385484346
Rred_2303 vss.$463.Metal2 vss.P0.nSD 61.4700162939
Rred_2304 vss.$463.Metal2 vss.P0.pSD 922.514354286
Rred_2305 vss.$463.Metal2 vss.P1.nSD 5.3653390732
Rred_2306 vss.$467.Metal2 vss.$469.Metal2 0.0354142727223
Rred_2307 vss.$467.Metal2 vss.$799.Metal3 6.07311427894
Rred_2308 vss.$467.Metal2 vss.$801.Metal3 3
Rred_2309 vss.$467.Metal2 vss.P0.pSD 1012.44644602
Rred_2310 vss.$467.Metal2 vss.P1.nSD 28.7500817548
Rred_2311 vss.$467.Metal2 vss.P3.nSD 23.0674325808
Rred_2312 vss.$469.Metal2 vss.$473.Metal2 0.0715792428553
Rred_2313 vss.$469.Metal2 vss.$801.Metal3 6.07074509804
Rred_2314 vss.$469.Metal2 vss.$805.Metal3 3.03537254902
Rred_2315 vss.$469.Metal2 vss.P0.pSD 1012.44892572
Rred_2316 vss.$469.Metal2 vss.P3.nSD 5.59210486807
Rred_2317 vss.$473.Metal2 vss.$475.Metal2 0.0354281800377
Rred_2318 vss.$473.Metal2 vss.$805.Metal3 3.03537254902
Rred_2319 vss.$473.Metal2 vss.$809.Metal3 6.07074509804
Rred_2320 vss.$473.Metal2 vss.P0.pSD 934.365403224
Rred_2321 vss.$473.Metal2 vss.P5.nSD 6.36592866327
Rred_2322 vss.$475.Metal2 vss.$479.Metal2 0.0716891504411
Rred_2323 vss.$475.Metal2 vss.$809.Metal3 3
Rred_2324 vss.$475.Metal2 vss.$811.Metal3 6.07188102602
Rred_2325 vss.$475.Metal2 vss.P0.pSD 972.100383861
Rred_2326 vss.$475.Metal2 vss.P5.nSD 15.3843276028
Rred_2327 vss.$475.Metal2 vss.P7.nSD 41.5047175299
Rred_2328 vss.$479.Metal2 vss.$483.Metal2 0.0715792428553
Rred_2329 vss.$479.Metal2 vss.$811.Metal3 3.03770111892
Rred_2330 vss.$479.Metal2 vss.$815.Metal3 3.03537254902
Rred_2331 vss.$479.Metal2 vss.P0.pSD 2007.27970237
Rred_2332 vss.$479.Metal2 vss.P7.nSD 5.06466559298
Rred_2333 vss.$483.Metal2 vss.$485.Metal2 0.0354251999204
Rred_2334 vss.$483.Metal2 vss.$815.Metal3 3.03537254902
Rred_2335 vss.$483.Metal2 vss.$819.Metal3 6.07074509804
Rred_2336 vss.$483.Metal2 vss.P0.pSD 946.526477048
Rred_2337 vss.$483.Metal2 vss.P10.nSD 6.1532133941
Rred_2338 vss.$485.Metal2 vss.$489.Metal2 0.071699667595
Rred_2339 vss.$485.Metal2 vss.$819.Metal3 3
Rred_2340 vss.$485.Metal2 vss.$821.Metal3 6.07214733407
Rred_2341 vss.$485.Metal2 vss.P0.pSD 978.593432028
Rred_2342 vss.$485.Metal2 vss.P10.nSD 16.7814910748
Rred_2343 vss.$485.Metal2 vss.P11.nSD 37.35972583
Rred_2344 vss.$489.Metal2 vss.$493.Metal2 0.0715792428553
Rred_2345 vss.$489.Metal2 vss.$821.Metal3 3.03792375455
Rred_2346 vss.$489.Metal2 vss.$825.Metal3 3.03537254902
Rred_2347 vss.$489.Metal2 vss.P0.pSD 2007.26961018
Rred_2348 vss.$489.Metal2 vss.P11.nSD 5.13669673776
Rred_2349 vss.$493.Metal2 vss.$495.Metal2 0.035421888356
Rred_2350 vss.$493.Metal2 vss.$825.Metal3 3.03537254902
Rred_2351 vss.$493.Metal2 vss.$829.Metal3 6.07074509804
Rred_2352 vss.$493.Metal2 vss.P0.pSD 1012.45104753
Rred_2353 vss.$493.Metal2 vss.P13.nSD 5.95416602971
Rred_2354 vss.$495.Metal2 vss.$499.Metal2 0.0717098457889
Rred_2355 vss.$495.Metal2 vss.$829.Metal3 3
Rred_2356 vss.$495.Metal2 vss.$831.Metal3 6.07244164503
Rred_2357 vss.$495.Metal2 vss.P0.pSD 1012.43864897
Rred_2358 vss.$495.Metal2 vss.P13.nSD 18.4579146921
Rred_2359 vss.$495.Metal2 vss.P15.nSD 33.9682084228
Rred_2360 vss.$499.Metal2 vss.$503.Metal2 0.0715792428553
Rred_2361 vss.$499.Metal2 vss.$831.Metal3 3.03813918368
Rred_2362 vss.$499.Metal2 vss.$835.Metal3 3.03537254902
Rred_2363 vss.$499.Metal2 vss.P0.pSD 1817.82155118
Rred_2364 vss.$499.Metal2 vss.P15.nSD 5.21075965667
Rred_2365 vss.$503.Metal2 vss.$507.Metal2 0.0716891504411
Rred_2366 vss.$503.Metal2 vss.$835.Metal3 3.03537254902
Rred_2367 vss.$503.Metal2 vss.$839.Metal3 3.03770111892
Rred_2368 vss.$503.Metal2 vss.P0.pSD 2007.27970237
Rred_2369 vss.$503.Metal2 vss.P17.nSD 5.06466559298
Rred_2370 vss.$507.Metal2 vss.$509.Metal2 0.0354281800377
Rred_2371 vss.$507.Metal2 vss.$839.Metal3 6.07188102602
Rred_2372 vss.$507.Metal2 vss.$841.Metal3 3
Rred_2373 vss.$507.Metal2 vss.P0.pSD 972.100383861
Rred_2374 vss.$507.Metal2 vss.P17.nSD 41.5047175299
Rred_2375 vss.$507.Metal2 vss.P19.nSD 15.3843276028
Rred_2376 vss.$509.Metal2 vss.$513.Metal2 0.0715792428553
Rred_2377 vss.$509.Metal2 vss.$841.Metal3 6.07074509804
Rred_2378 vss.$509.Metal2 vss.$845.Metal3 3.03537254902
Rred_2379 vss.$509.Metal2 vss.P0.pSD 934.365403224
Rred_2380 vss.$509.Metal2 vss.P19.nSD 6.36592866327
Rred_2381 vss.$513.Metal2 vss.$515.Metal2 0.0354142727223
Rred_2382 vss.$513.Metal2 vss.$845.Metal3 3.03537254902
Rred_2383 vss.$513.Metal2 vss.$849.Metal3 6.07074509804
Rred_2384 vss.$513.Metal2 vss.P0.pSD 1012.44892572
Rred_2385 vss.$513.Metal2 vss.P21.nSD 5.59210486807
Rred_2386 vss.$515.Metal2 vss.$519.Metal2 0.0717291852966
Rred_2387 vss.$515.Metal2 vss.$849.Metal3 3
Rred_2388 vss.$515.Metal2 vss.$851.Metal3 6.07311427894
Rred_2389 vss.$515.Metal2 vss.P0.pSD 1012.44644602
Rred_2390 vss.$515.Metal2 vss.P21.nSD 23.0674325808
Rred_2391 vss.$515.Metal2 vss.P23.nSD 28.7500817548
Rred_2392 vss.$519.Metal2 vss.$521.Metal2 0.0353894398326
Rred_2393 vss.$519.Metal2 vss.$851.Metal3 3.0385484346
Rred_2394 vss.$519.Metal2 vss.$855.Metal3 6.07074509804
Rred_2395 vss.$519.Metal2 vss.P0.pSD 922.514354286
Rred_2396 vss.$519.Metal2 vss.P23.nSD 5.3653390732
Rred_2397 vss.$519.Metal2 vss.P25.nSD 61.4700162939
Rred_2398 vss.$521.Metal2 vss.$525.Metal2 0.0715792428553
Rred_2399 vss.$521.Metal2 vss.$855.Metal3 3
Rred_2400 vss.$521.Metal2 vss.$857.Metal3 6.07074509804
Rred_2401 vss.$521.Metal2 vss.P0.pSD 965.693169401
Rred_2402 vss.$521.Metal2 vss.P25.nSD 4.85289602321
Rred_2403 vss.$525.Metal2 vss.$857.Metal3 2.03924200009
Rred_2404 vss.$525.Metal2 vss.P0.pSD 136.838729851
Rred_2405 vss.$525.Metal2 vss.P1.GatPoly 192448.145745
Rred_2406 vss.$793.Metal3 vss.$795.Metal3 0.0353725490196
Rred_2407 vss.$795.Metal3 vss.$799.Metal3 0.0715792428553
Rred_2408 vss.$799.Metal3 vss.$801.Metal3 0.0353725490196
Rred_2409 vss.$799.Metal3 vss.P1.nSD 2438.33841934
Rred_2410 vss.$801.Metal3 vss.$805.Metal3 0.0715792428553
Rred_2411 vss.$805.Metal3 vss.$809.Metal3 0.0715792428553
Rred_2412 vss.$809.Metal3 vss.$811.Metal3 0.0353725490196
Rred_2413 vss.$811.Metal3 vss.$815.Metal3 0.0715792428553
Rred_2414 vss.$811.Metal3 vss.P7.nSD 3520.07859317
Rred_2415 vss.$815.Metal3 vss.$819.Metal3 0.0715792428553
Rred_2416 vss.$819.Metal3 vss.$821.Metal3 0.0353725490196
Rred_2417 vss.$821.Metal3 vss.$825.Metal3 0.0715792428553
Rred_2418 vss.$821.Metal3 vss.P11.nSD 3168.53550554
Rred_2419 vss.$825.Metal3 vss.$829.Metal3 0.0715792428553
Rred_2420 vss.$829.Metal3 vss.$831.Metal3 0.0353725490196
Rred_2421 vss.$831.Metal3 vss.$835.Metal3 0.0715792428553
Rred_2422 vss.$831.Metal3 vss.P15.nSD 2880.89572544
Rred_2423 vss.$835.Metal3 vss.$839.Metal3 0.0715792428553
Rred_2424 vss.$839.Metal3 vss.$841.Metal3 0.0353725490196
Rred_2425 vss.$839.Metal3 vss.P17.nSD 3520.07859317
Rred_2426 vss.$841.Metal3 vss.$845.Metal3 0.0715792428553
Rred_2427 vss.$845.Metal3 vss.$849.Metal3 0.0715792428553
Rred_2428 vss.$849.Metal3 vss.$851.Metal3 0.0353725490196
Rred_2429 vss.$851.Metal3 vss.$855.Metal3 0.0715792428553
Rred_2430 vss.$851.Metal3 vss.P23.nSD 2438.33841934
Rred_2431 vss.$855.Metal3 vss.$857.Metal3 0.0353725490196
Rred_2432 vss.P0.GatPoly vss.P0.pSD 134.64715669
Rred_2433 vss.P0.pSD vss.P1.GatPoly 1551.37246751
.ENDS sparx_powdet_sbd_pex
