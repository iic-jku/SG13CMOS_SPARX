* NGSPICE file created from sparx_powdet_sbd_pex.ext - technology: ihp-sg13g2

.subckt sparx_powdet_sbd_pex vout vref vdd rfin vss
X0 vdd vss.t1 cap_cmim l=10u w=10u
X1 vss.t1 dw_8122_3287# vout vss.t13 sg13_lv_nmos ad=0.475p pd=2.88u as=0.475p ps=2.88u w=2.5u l=0.13u
X2 vout dw_8122_3287# vdd vdd sg13_lv_pmos ad=0.95p pd=5.38u as=0.95p ps=5.38u w=5u l=0.13u
X3 vss.t1 dw_8122_3287# vout vss.t21 sg13_lv_nmos ad=0.475p pd=2.88u as=0.475p ps=2.88u w=2.5u l=0.13u
X4 vdd vss.t1 cap_cmim l=10u w=10u
X5 a_8474_1965# vss.t1 cap_cmim l=10u w=10u
X6 vout dw_8122_3287# vdd vdd sg13_lv_pmos ad=0.95p pd=5.38u as=0.95p ps=5.38u w=5u l=0.13u
X7 vdd dw_9390_3287# vref vdd sg13_lv_pmos ad=0.95p pd=5.38u as=0.95p ps=5.38u w=5u l=0.13u
X8 vss.t1 dw_8122_3287# vout vss.t3 sg13_lv_nmos ad=0.475p pd=2.88u as=0.475p ps=2.88u w=2.5u l=0.13u
X9 a_9398_2535# dw_9390_3287# vss schottky_nbl1 l=1.2u w=2.655u
X10 vout dw_8122_3287# vdd vdd sg13_lv_pmos ad=0.95p pd=5.38u as=0.95p ps=5.38u w=5u l=0.13u
X11 a_8474_1965# vss.t1 cap_cmim l=10u w=10u
X12 vdd vss.t1 cap_cmim l=10u w=10u
X13 vdd vss.t1 cap_cmim l=10u w=10u
X14 vdd vss.t1 cap_cmim l=10u w=10u
X15 a_8474_1965# vss.t1 cap_cmim l=10u w=10u
X16 vout dw_8122_3287# vss.t1 vss.t12 sg13_lv_nmos ad=0.475p pd=2.88u as=0.475p ps=2.88u w=2.5u l=0.13u
X17 a_8474_1965# vss.t1 cap_cmim l=10u w=10u
X18 vout dw_8122_3287# vdd vdd sg13_lv_pmos ad=0.95p pd=5.38u as=0.95p ps=5.38u w=5u l=0.13u
X19 vdd vss.t1 cap_cmim l=10u w=10u
X20 vdd vss.t1 cap_cmim l=10u w=10u
X21 a_8474_1965# vss.t1 cap_cmim l=10u w=10u
X22 vout dw_8122_3287# vss.t1 vss.t10 sg13_lv_nmos ad=0.475p pd=2.88u as=0.475p ps=2.88u w=2.5u l=0.13u
X23 vdd vss.t1 cap_cmim l=9u w=6.8u
X24 vdd vss.t1 cap_cmim l=10u w=10u
X25 vdd vss.t1 cap_cmim l=10u w=10u
X26 vss.t1 dw_8122_3287# vout vss.t17 sg13_lv_nmos ad=0.475p pd=2.88u as=0.475p ps=2.88u w=2.5u l=0.13u
X27 a_8474_1965# vss.t1 cap_cmim l=10u w=10u
X28 a_8474_1965# vss.t1 cap_cmim l=10u w=10u
X29 a_8474_1965# vss.t1 cap_cmim l=10u w=10u
X30 vout dw_8122_3287# vdd vdd sg13_lv_pmos ad=0.95p pd=5.38u as=0.95p ps=5.38u w=5u l=0.13u
X31 a_8474_1965# vss.t1 cap_cmim l=10u w=10u
X32 vss.t1 vss.t1 vss.t1 vss.t26 sg13_lv_nmos ad=0.475p pd=2.88u as=0 ps=0 w=2.5u l=0.13u
X33 vdd vss.t1 cap_cmim l=9u w=6.8u
X34 vdd vss.t1 cap_cmim l=10u w=10u
X35 vdd vss.t1 cap_cmim l=10u w=10u
X36 vdd dw_8122_3287# vout vdd sg13_lv_pmos ad=0.95p pd=5.38u as=0.95p ps=5.38u w=5u l=0.13u
X37 vdd vss.t1 cap_cmim l=10u w=10u
X38 a_8474_1965# vss.t1 cap_cmim l=10u w=10u
X39 vss.t1 dw_8122_3287# vout vss.t7 sg13_lv_nmos ad=0.475p pd=2.88u as=0.475p ps=2.88u w=2.5u l=0.13u
X40 a_8474_1965# vdd vss.t28 rhigh l=2u w=0.5u
X41 vdd dw_8122_3287# vout vdd sg13_lv_pmos ad=0.95p pd=5.38u as=0.95p ps=5.38u w=5u l=0.13u
X42 vout dw_8122_3287# vss.t1 vss.t14 sg13_lv_nmos ad=0.475p pd=2.88u as=0.475p ps=2.88u w=2.5u l=0.13u
X43 a_8474_1965# vss.t1 cap_cmim l=10u w=10u
X44 vdd vss.t1 cap_cmim l=10u w=10u
X45 vdd vss.t1 cap_cmim l=10u w=10u
X46 vss.t1 dw_8122_3287# vout vss.t5 sg13_lv_nmos ad=0.475p pd=2.88u as=0.475p ps=2.88u w=2.5u l=0.13u
X47 a_8474_1965# vss.t1 cap_cmim l=10u w=10u
X48 vdd vss.t1 cap_cmim l=10u w=10u
X49 a_8474_1965# vss.t1 cap_cmim l=10u w=10u
X50 vref dw_9390_3287# vss.t1 vss.t2 sg13_lv_nmos ad=0.475p pd=2.88u as=0.475p ps=2.88u w=2.5u l=0.13u
X51 a_8474_1965# vss.t1 cap_cmim l=10u w=10u
X52 vdd vss.t1 cap_cmim l=10u w=10u
X53 vout dw_8122_3287# vss.t1 vss.t20 sg13_lv_nmos ad=0.475p pd=2.88u as=0.475p ps=2.88u w=2.5u l=0.13u
X54 rfin a_8232_3371# cap_cmim l=10u w=10u
X55 dw_9390_3287# vref vss.t23 rppd l=1.5u w=0.5u
X56 vdd vss.t1 cap_cmim l=10u w=10u
X57 vdd dw_8122_3287# vout vdd sg13_lv_pmos ad=0.95p pd=5.38u as=0.95p ps=5.38u w=5u l=0.13u
X58 a_9398_2535# a_8474_1965# vss.t59 rsil l=2.5u w=0.5u
X59 vss.t1 dw_8122_3287# vout vss.t19 sg13_lv_nmos ad=0.475p pd=2.88u as=0.475p ps=2.88u w=2.5u l=0.13u
X60 a_8474_1965# vss.t1 cap_cmim l=10u w=10u
X61 vdd vss.t1 cap_cmim l=10u w=10u
X62 vdd dw_8122_3287# vout vdd sg13_lv_pmos ad=0.95p pd=5.38u as=0.95p ps=5.38u w=5u l=0.13u
X63 vout dw_8122_3287# vdd vdd sg13_lv_pmos ad=0.95p pd=5.38u as=0.95p ps=5.38u w=5u l=0.13u
X64 vss.t1 vss.t1 vss.t1 vss.t24 sg13_lv_nmos ad=0.85p pd=5.68u as=0 ps=0 w=2.5u l=0.13u
X65 vdd vss.t1 cap_cmim l=10u w=10u
X66 vdd vss.t1 cap_cmim l=10u w=10u
X67 a_8232_3371# dw_8122_3287# vss schottky_nbl1 l=1.2u w=2.655u
X68 vout dw_8122_3287# vss.t23 rppd l=1.5u w=0.5u
X69 vout dw_8122_3287# vdd vdd sg13_lv_pmos ad=0.95p pd=5.38u as=0.95p ps=5.38u w=5u l=0.13u
X70 vss.t1 dw_8122_3287# vout vss.t11 sg13_lv_nmos ad=0.475p pd=2.88u as=0.475p ps=2.88u w=2.5u l=0.13u
X71 a_8474_1965# vss.t1 cap_cmim l=10u w=10u
X72 vdd dw_8122_3287# vout vdd sg13_lv_pmos ad=0.95p pd=5.38u as=0.95p ps=5.38u w=5u l=0.13u
X73 a_8474_1965# vss.t1 cap_cmim l=10u w=10u
X74 vss.t1 dw_8122_3287# vout vss.t9 sg13_lv_nmos ad=0.475p pd=2.88u as=0.475p ps=2.88u w=2.5u l=0.13u
X75 vout dw_8122_3287# vss.t1 vss.t16 sg13_lv_nmos ad=0.475p pd=2.88u as=0.475p ps=2.88u w=2.5u l=0.13u
X76 a_8474_1965# vss.t1 cap_cmim l=10u w=10u
X77 a_8474_1965# vss.t1 cap_cmim l=10u w=10u
X78 vdd vss.t1 cap_cmim l=10u w=10u
X79 a_8474_1965# vss.t1 cap_cmim l=10u w=10u
X80 a_8474_1965# vss.t1 cap_cmim l=10u w=10u
X81 vout dw_8122_3287# vss.t1 vss.t22 sg13_lv_nmos ad=0.475p pd=2.88u as=0.475p ps=2.88u w=2.5u l=0.13u
X82 vdd dw_8122_3287# vout vdd sg13_lv_pmos ad=0.95p pd=5.38u as=0.95p ps=5.38u w=5u l=0.13u
X83 vdd vss.t1 cap_cmim l=10u w=10u
X84 vout dw_8122_3287# vdd vdd sg13_lv_pmos ad=0.95p pd=5.38u as=0.95p ps=5.38u w=5u l=0.13u
X85 vout dw_8122_3287# vss.t1 vss.t6 sg13_lv_nmos ad=0.475p pd=2.88u as=0.475p ps=2.88u w=2.5u l=0.13u
X86 vdd dw_8122_3287# vout vdd sg13_lv_pmos ad=0.95p pd=5.38u as=0.95p ps=5.38u w=5u l=0.13u
X87 a_8474_1965# vss.t1 cap_cmim l=10u w=10u
X88 a_8474_1965# vss.t1 cap_cmim l=10u w=10u
X89 vref dw_9390_3287# vdd vdd sg13_lv_pmos ad=0.95p pd=5.38u as=0.95p ps=5.38u w=5u l=0.13u
X90 vout dw_8122_3287# vss.t1 vss.t4 sg13_lv_nmos ad=0.475p pd=2.88u as=0.475p ps=2.88u w=2.5u l=0.13u
X91 vdd vdd vdd vdd sg13_lv_pmos ad=0.95p pd=5.38u as=43.4451p ps=0.26832m w=5u l=0.13u
X92 vss.t1 dw_9390_3287# vref vss.t0 sg13_lv_nmos ad=0.475p pd=2.88u as=0.475p ps=2.88u w=2.5u l=0.13u
X93 vdd vss.t1 cap_cmim l=10u w=10u
X94 vdd dw_8122_3287# vout vdd sg13_lv_pmos ad=0.95p pd=5.38u as=0.95p ps=5.38u w=5u l=0.13u
X95 a_8474_1965# vss.t1 cap_cmim l=10u w=10u
X96 a_8474_1965# vss.t1 cap_cmim l=10u w=10u
X97 vdd vss.t1 cap_cmim l=10u w=10u
X98 a_8474_1965# vss.t1 cap_cmim l=10u w=10u
X99 a_8474_1965# vss.t1 cap_cmim l=10u w=10u
X100 a_8474_1965# vss.t1 cap_cmim l=10u w=10u
X101 vdd vss.t1 cap_cmim l=10u w=10u
X102 vdd vdd vdd vdd sg13_lv_pmos ad=1.7p pd=10.68u as=0 ps=0 w=5u l=0.13u
X103 vout dw_8122_3287# vdd vdd sg13_lv_pmos ad=0.95p pd=5.38u as=0.95p ps=5.38u w=5u l=0.13u
X104 vout dw_8122_3287# vss.t1 vss.t18 sg13_lv_nmos ad=0.475p pd=2.88u as=0.475p ps=2.88u w=2.5u l=0.13u
X105 vdd dw_8122_3287# vout vdd sg13_lv_pmos ad=0.95p pd=5.38u as=0.95p ps=5.38u w=5u l=0.13u
X106 vdd vss.t1 cap_cmim l=10u w=10u
X107 a_8474_1965# vss.t1 cap_cmim l=10u w=10u
X108 a_8232_3371# a_8474_1965# vss.t90 rsil l=2.5u w=0.5u
X109 vdd vss.t1 cap_cmim l=10u w=10u
X110 vdd dw_8122_3287# vout vdd sg13_lv_pmos ad=0.95p pd=5.38u as=0.95p ps=5.38u w=5u l=0.13u
X111 vout dw_8122_3287# vdd vdd sg13_lv_pmos ad=0.95p pd=5.38u as=0.95p ps=5.38u w=5u l=0.13u
X112 vout dw_8122_3287# vss.t1 vss.t8 sg13_lv_nmos ad=0.475p pd=2.88u as=0.475p ps=2.88u w=2.5u l=0.13u
X113 a_8474_1965# vss.t1 cap_cmim l=10u w=10u
X114 vdd vss.t1 cap_cmim l=10u w=10u
X115 vss.t1 dw_8122_3287# vout vss.t15 sg13_lv_nmos ad=0.475p pd=2.88u as=0.475p ps=2.88u w=2.5u l=0.13u
C0 vdd vref 2.17332f
C1 dw_9390_3287# dw_8122_3287# 2.48837f
C2 vref dw_9390_3287# 0.66034f
C3 dw_8122_3287# rfin 0.07528f
C4 a_8474_1965# a_9398_2535# 0.03586f
C5 a_8232_3371# a_8474_1965# 0.06382f
C6 vout a_8474_1965# 1.11736f
C7 vdd vout 33.1585f
C8 dw_9390_3287# a_9398_2535# 0.54686f
C9 a_8232_3371# dw_9390_3287# 0.10207f
C10 a_9398_2035# a_9398_2535# 0.02622f
C11 a_9398_2535# rfin 0.05177f
C12 vout dw_9390_3287# 0.24433f
C13 a_9398_2035# a_8232_3371# 0.01213f
C14 a_8232_3371# rfin 1.14761f
C15 a_9776_10932# dw_8122_3287# 0.03763f
C16 a_12042_5026# a_8474_1965# 0.01902f
C17 a_12042_5026# vdd 0.0653f
C18 vref dw_8122_3287# 0.77553f
C19 vdd a_8474_1965# 5.19837f
C20 a_9396_10932# dw_9390_3287# 0.03652f
C21 dw_9390_3287# a_8474_1965# 0.06199f
C22 vdd dw_9390_3287# 0.73047f
C23 a_9398_2035# a_8474_1965# 0.02416f
C24 a_8474_1965# rfin 0.01614f
C25 a_8232_3371# a_8474_2035# 0.05211f
C26 a_8232_3371# dw_8122_3287# 1.06735f
C27 a_9776_10932# vout 0.03993f
C28 dw_9390_3287# rfin 0.0415f
C29 vout dw_8122_3287# 4.29311f
C30 vref vout 2.97107f
C31 a_9776_10932# a_9396_10932# 0.01274f
C32 a_8232_3371# a_9398_2535# 0.1825f
C33 vref a_9396_10932# 0.04195f
C34 a_9776_10932# vdd 0.0126f
C35 a_8474_1965# a_8474_2035# 0.02075f
C36 dw_8122_3287# a_8474_1965# 0.11747f
C37 vdd dw_8122_3287# 6.31825f
C38 vref a_8474_1965# 0.19179f
R0 vss.n46 vss.t59 5876.96
R1 vss.n43 vss.n42 5537.89
R2 vss.n0 vss.t28 1640.15
R3 vss.t28 vss.n46 3087.21
R4 vss.n42 vss.t90 1588.69
R5 vss.n0 vss.n39 901.753
R6 vss.t90 vss.n41 931.034
R7 vss.t59 vss.n45 931.034
R8 vss.n7 vss.n46 446.897
R9 vss.n0 vss.t1 558.463
R10 vss.n43 vss.n7 446.913
R11 vss.n41 vss.n36 206.898
R12 vss.n45 vss.n36 206.898
R13 vss.n43 vss.n40 198.214
R14 vss.n37 vss.n36 192.857
R15 vss.n9 vss.n6 31.2294
R16 vss.n10 vss.n6 31.2294
R17 vss.n10 vss.n5 31.2294
R18 vss.n11 vss.n5 31.2294
R19 vss.n11 vss.n4 31.2294
R20 vss.n12 vss.n4 31.2294
R21 vss.n12 vss.n3 31.2294
R22 vss.n13 vss.n3 31.2294
R23 vss.n13 vss.n2 31.2294
R24 vss.t0 vss.t2 30.5029
R25 vss.n1 vss.t24 7.01143
R26 vss.n18 vss.t22 17.644
R27 vss.n26 vss.t20 17.644
R28 vss.n19 vss.t18 17.644
R29 vss.n27 vss.t16 17.644
R30 vss.t14 vss.n21 17.644
R31 vss.t9 vss.n23 17.644
R32 vss.t7 vss.n32 17.644
R33 vss.t5 vss.n25 17.644
R34 vss.n35 vss.t3 17.644
R35 vss.n14 vss.n44 8.50058
R36 vss.n14 vss.n40 17.0005
R37 vss.n7 vss.n37 17.0005
R38 vss.n40 vss.n2 15.6239
R39 vss.n9 vss.n37 15.6061
R40 vss.t23 vss.t11 14.6536
R41 vss.n18 vss.t21 12.8594
R42 vss.n26 vss.t19 12.8594
R43 vss.t17 vss.n19 12.8594
R44 vss.t15 vss.n27 12.8594
R45 vss.t13 vss.n21 12.8594
R46 vss.n31 vss.t12 12.8594
R47 vss.n23 vss.t10 12.8594
R48 vss.n32 vss.t8 12.8594
R49 vss.t6 vss.n25 12.8594
R50 vss.n35 vss.t4 12.8594
R51 vss.t19 vss.n16 12.1076
R52 vss.n29 vss.t13 12.1076
R53 vss.t10 vss.n22 12.1076
R54 vss.t8 vss.n24 12.1076
R55 vss.n33 vss.t6 12.1076
R56 vss.n28 vss.t15 12.1071
R57 vss.n20 vss.t17 12.1071
R58 vss.t21 vss.n17 12.1071
R59 vss.n15 vss.t26 7.01105
R60 vss.t12 vss.n30 12.1071
R61 vss.t4 vss.n34 12.1071
R62 vss.n44 vss.n43 10.168
R63 vss.n14 vss.n39 8.501
R64 vss.t1 vss.n35 8.5005
R65 vss.t1 vss.n32 8.5005
R66 vss.t1 vss.n31 8.5005
R67 vss.t1 vss.n27 8.5005
R68 vss.t1 vss.n26 8.5005
R69 vss.t1 vss.n18 8.5005
R70 vss.t1 vss.n19 8.5005
R71 vss.t1 vss.n21 8.5005
R72 vss.t1 vss.n23 8.5005
R73 vss.t1 vss.n25 8.5005
R74 vss.n14 vss.n8 1.6529
R75 vss.n7 vss.n8 0.0013302
R76 vss.t20 vss.n17 7.32294
R77 vss.n28 vss.t14 7.32294
R78 vss.n30 vss.t0 7.32294
R79 vss.n34 vss.t5 7.32294
R80 vss.t16 vss.n20 7.32294
R81 vss.t3 vss.n1 8.02555
R82 vss.n33 vss.t7 7.32242
R83 vss.n24 vss.t9 7.32242
R84 vss.t11 vss.n22 7.32242
R85 vss.t18 vss.n16 7.32242
R86 vss.t2 vss.n29 7.32242
R87 vss.n41 vss.n14 5.6686
R88 vss.n39 vss.n38 4.75145
R89 vss.n44 vss.n38 4.75092
R90 vss.n31 vss.t23 2.99093
R91 vss.t1 vss.n34 1.93648
R92 vss.t1 vss.n33 1.93648
R93 vss.t1 vss.n30 1.93648
R94 vss.t1 vss.n29 1.93648
R95 vss.t1 vss.n28 1.93648
R96 vss.t1 vss.n16 1.93648
R97 vss.t1 vss.n17 1.93648
R98 vss.n15 vss.t22 8.02608
R99 vss.t1 vss.n20 1.93648
R100 vss.t1 vss.n22 1.93648
R101 vss.t1 vss.n24 1.93648
R102 vss.t1 vss.n1 1.122
R103 vss.n7 vss.n38 1.87635
R104 vss.n42 vss.n14 1.21479
R105 vss.n14 vss.n9 0.701133
R106 vss.n14 vss.n10 0.698466
R107 vss.n14 vss.n11 0.698466
R108 vss.n14 vss.n12 0.698466
R109 vss.n14 vss.n13 0.698466
R110 vss.n7 vss.n2 0.689564
R111 vss.n7 vss.n3 0.689564
R112 vss.n7 vss.n4 0.689564
R113 vss.n7 vss.n5 0.689564
R114 vss.n7 vss.n6 0.689564
R115 vss.n45 vss.n8 5.67123
R116 vss.n15 vss.t1 1.12198
R117 vss vss.t1 0.0005
C39 rfin vss 2.00521f
C40 vref vss 4.17184f
C41 vout vss 31.95111f
C42 vdd vss 58.31918f
C43 a_9398_2535# vss 0.91017f ; **FLOATING
C44 a_8232_3371# vss 3.15782f ; **FLOATING
C45 a_8474_1965# vss 57.04807f ; **FLOATING
C46 dw_9390_3287# vss 5.52804f ; **FLOATING
C47 dw_8122_3287# vss 12.49111f ; **FLOATING
.ends
