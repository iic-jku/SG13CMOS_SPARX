* PEX produced on Wed Jul 22 11:36:01 AM CEST 2026 using /foss/tools/sak/sak-pex.sh with m=3 and s=1 (extresist threshold=10000 mOhm, minres=1000 mOhm, mindelay=1 ps)
* NGSPICE file created from sparx_powdet_sbd_pex.ext - technology: ihp-sg13g2

.subckt sparx_powdet_sbd_pex vout vref vdd rfin vss
X0 vdd vss.t1 cap_cmim l=10u w=10u
X1 vss.t1 dw_8122_3287# vout vss.t13 sg13_lv_nmos ad=0.475p pd=2.88u as=0.475p ps=2.88u w=2.5u l=0.13u
X2 vout dw_8122_3287# vdd vdd sg13_lv_pmos ad=0.95p pd=5.38u as=0.95p ps=5.38u w=5u l=0.13u
X3 vss.t1 dw_8122_3287# vout vss.t21 sg13_lv_nmos ad=0.475p pd=2.88u as=0.475p ps=2.88u w=2.5u l=0.13u
X4 vdd vss.t1 cap_cmim l=10u w=10u
X5 a_8474_1965# vss.t1 cap_cmim l=10u w=10u
X6 vout dw_8122_3287# vdd vdd sg13_lv_pmos ad=0.95p pd=5.38u as=0.95p ps=5.38u w=5u l=0.13u
X7 vdd dw_9390_3287# vref vdd sg13_lv_pmos ad=0.95p pd=5.38u as=0.95p ps=5.38u w=5u l=0.13u
X8 vss.t1 dw_8122_3287# vout vss.t3 sg13_lv_nmos ad=0.475p pd=2.88u as=0.475p ps=2.88u w=2.5u l=0.13u
X9 a_9398_2535# dw_9390_3287# vss schottky_nbl1 l=1.2u w=2.655u
X10 vout dw_8122_3287# vdd vdd sg13_lv_pmos ad=0.95p pd=5.38u as=0.95p ps=5.38u w=5u l=0.13u
X11 a_8474_1965# vss.t1 cap_cmim l=10u w=10u
X12 vdd vss.t1 cap_cmim l=10u w=10u
X13 vdd vss.t1 cap_cmim l=10u w=10u
X14 vdd vss.t1 cap_cmim l=10u w=10u
X15 a_8474_1965# vss.t1 cap_cmim l=10u w=10u
X16 vout dw_8122_3287# vss.t1 vss.t12 sg13_lv_nmos ad=0.475p pd=2.88u as=0.475p ps=2.88u w=2.5u l=0.13u
X17 a_8474_1965# vss.t1 cap_cmim l=10u w=10u
X18 vout dw_8122_3287# vdd vdd sg13_lv_pmos ad=0.95p pd=5.38u as=0.95p ps=5.38u w=5u l=0.13u
X19 vdd vss.t1 cap_cmim l=10u w=10u
X20 vdd vss.t1 cap_cmim l=10u w=10u
X21 a_8474_1965# vss.t1 cap_cmim l=10u w=10u
X22 vout dw_8122_3287# vss.t1 vss.t10 sg13_lv_nmos ad=0.475p pd=2.88u as=0.475p ps=2.88u w=2.5u l=0.13u
X23 vdd vss.t1 cap_cmim l=9u w=6.8u
X24 vdd vss.t1 cap_cmim l=10u w=10u
X25 vdd vss.t1 cap_cmim l=10u w=10u
X26 vss.t1 dw_8122_3287# vout vss.t17 sg13_lv_nmos ad=0.475p pd=2.88u as=0.475p ps=2.88u w=2.5u l=0.13u
X27 a_8474_1965# vss.t1 cap_cmim l=10u w=10u
X28 a_8474_1965# vss.t1 cap_cmim l=10u w=10u
X29 a_8474_1965# vss.t1 cap_cmim l=10u w=10u
X30 vout dw_8122_3287# vdd vdd sg13_lv_pmos ad=0.95p pd=5.38u as=0.95p ps=5.38u w=5u l=0.13u
X31 a_8474_1965# vss.t1 cap_cmim l=10u w=10u
X32 vss.t1 vss.t26 vss.t1 vss.t27 sg13_lv_nmos ad=0.475p pd=2.88u as=0 ps=0 w=2.5u l=0.13u
X33 vdd vss.t1 cap_cmim l=9u w=6.8u
X34 vdd vss.t1 cap_cmim l=10u w=10u
X35 vdd vss.t1 cap_cmim l=10u w=10u
X36 vdd dw_8122_3287# vout vdd sg13_lv_pmos ad=0.95p pd=5.38u as=0.95p ps=5.38u w=5u l=0.13u
X37 vdd vss.t1 cap_cmim l=10u w=10u
X38 a_8474_1965# vss.t1 cap_cmim l=10u w=10u
X39 vss.t1 dw_8122_3287# vout vss.t7 sg13_lv_nmos ad=0.475p pd=2.88u as=0.475p ps=2.88u w=2.5u l=0.13u
X40 a_8474_1965# vdd vss.t28 rhigh l=2u w=0.5u
X41 vdd dw_8122_3287# vout vdd sg13_lv_pmos ad=0.95p pd=5.38u as=0.95p ps=5.38u w=5u l=0.13u
X42 vout dw_8122_3287# vss.t1 vss.t14 sg13_lv_nmos ad=0.475p pd=2.88u as=0.475p ps=2.88u w=2.5u l=0.13u
X43 a_8474_1965# vss.t1 cap_cmim l=10u w=10u
X44 vdd vss.t1 cap_cmim l=10u w=10u
X45 vdd vss.t1 cap_cmim l=10u w=10u
X46 vss.t1 dw_8122_3287# vout vss.t5 sg13_lv_nmos ad=0.475p pd=2.88u as=0.475p ps=2.88u w=2.5u l=0.13u
X47 a_8474_1965# vss.t1 cap_cmim l=10u w=10u
X48 vdd vss.t1 cap_cmim l=10u w=10u
X49 a_8474_1965# vss.t1 cap_cmim l=10u w=10u
X50 vref dw_9390_3287# vss.t1 vss.t2 sg13_lv_nmos ad=0.475p pd=2.88u as=0.475p ps=2.88u w=2.5u l=0.13u
X51 a_8474_1965# vss.t1 cap_cmim l=10u w=10u
X52 vdd vss.t1 cap_cmim l=10u w=10u
X53 vout dw_8122_3287# vss.t1 vss.t20 sg13_lv_nmos ad=0.475p pd=2.88u as=0.475p ps=2.88u w=2.5u l=0.13u
X54 rfin a_8232_3371# cap_cmim l=10u w=10u
X55 dw_9390_3287# vref vss.t23 rppd l=1.5u w=0.5u
X56 vdd vss.t1 cap_cmim l=10u w=10u
X57 vdd dw_8122_3287# vout vdd sg13_lv_pmos ad=0.95p pd=5.38u as=0.95p ps=5.38u w=5u l=0.13u
X58 a_9398_2535# a_8474_1965# vss.t59 rsil l=2.5u w=0.5u
X59 vss.t1 dw_8122_3287# vout vss.t19 sg13_lv_nmos ad=0.475p pd=2.88u as=0.475p ps=2.88u w=2.5u l=0.13u
X60 a_8474_1965# vss.t1 cap_cmim l=10u w=10u
X61 vdd vss.t1 cap_cmim l=10u w=10u
X62 vdd dw_8122_3287# vout vdd sg13_lv_pmos ad=0.95p pd=5.38u as=0.95p ps=5.38u w=5u l=0.13u
X63 vout dw_8122_3287# vdd vdd sg13_lv_pmos ad=0.95p pd=5.38u as=0.95p ps=5.38u w=5u l=0.13u
X64 vss.t1 vss.t24 vss.t1 vss.t25 sg13_lv_nmos ad=0.85p pd=5.68u as=0 ps=0 w=2.5u l=0.13u
X65 vdd vss.t1 cap_cmim l=10u w=10u
X66 vdd vss.t1 cap_cmim l=10u w=10u
X67 a_8232_3371# dw_8122_3287# vss schottky_nbl1 l=1.2u w=2.655u
X68 vout dw_8122_3287# vss.t23 rppd l=1.5u w=0.5u
X69 vout dw_8122_3287# vdd vdd sg13_lv_pmos ad=0.95p pd=5.38u as=0.95p ps=5.38u w=5u l=0.13u
X70 vss.t1 dw_8122_3287# vout vss.t11 sg13_lv_nmos ad=0.475p pd=2.88u as=0.475p ps=2.88u w=2.5u l=0.13u
X71 a_8474_1965# vss.t1 cap_cmim l=10u w=10u
X72 vdd dw_8122_3287# vout vdd sg13_lv_pmos ad=0.95p pd=5.38u as=0.95p ps=5.38u w=5u l=0.13u
X73 a_8474_1965# vss.t1 cap_cmim l=10u w=10u
X74 vss.t1 dw_8122_3287# vout vss.t9 sg13_lv_nmos ad=0.475p pd=2.88u as=0.475p ps=2.88u w=2.5u l=0.13u
X75 vout dw_8122_3287# vss.t1 vss.t16 sg13_lv_nmos ad=0.475p pd=2.88u as=0.475p ps=2.88u w=2.5u l=0.13u
X76 a_8474_1965# vss.t1 cap_cmim l=10u w=10u
X77 a_8474_1965# vss.t1 cap_cmim l=10u w=10u
X78 vdd vss.t1 cap_cmim l=10u w=10u
X79 a_8474_1965# vss.t1 cap_cmim l=10u w=10u
X80 a_8474_1965# vss.t1 cap_cmim l=10u w=10u
X81 vout dw_8122_3287# vss.t1 vss.t22 sg13_lv_nmos ad=0.475p pd=2.88u as=0.475p ps=2.88u w=2.5u l=0.13u
X82 vdd dw_8122_3287# vout vdd sg13_lv_pmos ad=0.95p pd=5.38u as=0.95p ps=5.38u w=5u l=0.13u
X83 vdd vss.t1 cap_cmim l=10u w=10u
X84 vout dw_8122_3287# vdd vdd sg13_lv_pmos ad=0.95p pd=5.38u as=0.95p ps=5.38u w=5u l=0.13u
X85 vout dw_8122_3287# vss.t1 vss.t6 sg13_lv_nmos ad=0.475p pd=2.88u as=0.475p ps=2.88u w=2.5u l=0.13u
X86 vdd dw_8122_3287# vout vdd sg13_lv_pmos ad=0.95p pd=5.38u as=0.95p ps=5.38u w=5u l=0.13u
X87 a_8474_1965# vss.t1 cap_cmim l=10u w=10u
X88 a_8474_1965# vss.t1 cap_cmim l=10u w=10u
X89 vref dw_9390_3287# vdd vdd sg13_lv_pmos ad=0.95p pd=5.38u as=0.95p ps=5.38u w=5u l=0.13u
X90 vout dw_8122_3287# vss.t1 vss.t4 sg13_lv_nmos ad=0.475p pd=2.88u as=0.475p ps=2.88u w=2.5u l=0.13u
X91 vdd vdd vdd vdd sg13_lv_pmos ad=0.95p pd=5.38u as=43.4451p ps=0.26832m w=5u l=0.13u
X92 vss.t1 dw_9390_3287# vref vss.t0 sg13_lv_nmos ad=0.475p pd=2.88u as=0.475p ps=2.88u w=2.5u l=0.13u
X93 vdd vss.t1 cap_cmim l=10u w=10u
X94 vdd dw_8122_3287# vout vdd sg13_lv_pmos ad=0.95p pd=5.38u as=0.95p ps=5.38u w=5u l=0.13u
X95 a_8474_1965# vss.t1 cap_cmim l=10u w=10u
X96 a_8474_1965# vss.t1 cap_cmim l=10u w=10u
X97 vdd vss.t1 cap_cmim l=10u w=10u
X98 a_8474_1965# vss.t1 cap_cmim l=10u w=10u
X99 a_8474_1965# vss.t1 cap_cmim l=10u w=10u
X100 a_8474_1965# vss.t1 cap_cmim l=10u w=10u
X101 vdd vss.t1 cap_cmim l=10u w=10u
X102 vdd vdd vdd vdd sg13_lv_pmos ad=1.7p pd=10.68u as=0 ps=0 w=5u l=0.13u
X103 vout dw_8122_3287# vdd vdd sg13_lv_pmos ad=0.95p pd=5.38u as=0.95p ps=5.38u w=5u l=0.13u
X104 vout dw_8122_3287# vss.t1 vss.t18 sg13_lv_nmos ad=0.475p pd=2.88u as=0.475p ps=2.88u w=2.5u l=0.13u
X105 vdd dw_8122_3287# vout vdd sg13_lv_pmos ad=0.95p pd=5.38u as=0.95p ps=5.38u w=5u l=0.13u
X106 vdd vss.t1 cap_cmim l=10u w=10u
X107 a_8474_1965# vss.t1 cap_cmim l=10u w=10u
X108 a_8232_3371# a_8474_1965# vss.t90 rsil l=2.5u w=0.5u
X109 vdd vss.t1 cap_cmim l=10u w=10u
X110 vdd dw_8122_3287# vout vdd sg13_lv_pmos ad=0.95p pd=5.38u as=0.95p ps=5.38u w=5u l=0.13u
X111 vout dw_8122_3287# vdd vdd sg13_lv_pmos ad=0.95p pd=5.38u as=0.95p ps=5.38u w=5u l=0.13u
X112 vout dw_8122_3287# vss.t1 vss.t8 sg13_lv_nmos ad=0.475p pd=2.88u as=0.475p ps=2.88u w=2.5u l=0.13u
X113 a_8474_1965# vss.t1 cap_cmim l=10u w=10u
X114 vdd vss.t1 cap_cmim l=10u w=10u
X115 vss.t1 dw_8122_3287# vout vss.t15 sg13_lv_nmos ad=0.475p pd=2.88u as=0.475p ps=2.88u w=2.5u l=0.13u
R0 vss.n37 vss.t59 5876.96
R1 vss.n35 vss.n34 5537.89
R2 vss.n0 vss.n38 4910.48
R3 vss.t28 vss.n37 3087.21
R4 vss.n34 vss.t90 1588.69
R5 vss.n38 vss.n29 1457.85
R6 vss.t90 vss.n33 931.034
R7 vss.t59 vss.n6 931.034
R8 vss.n3 vss.n37 446.897
R9 vss.n29 vss.t1 817.217
R10 vss.n32 vss.n29 735.946
R11 vss.n38 vss.t28 643.895
R12 vss.n35 vss.n4 140.827
R13 vss.n33 vss.n30 206.898
R14 vss.n6 vss.n30 206.898
R15 vss.t2 vss.t0 30.5029
R16 vss.n8 vss.t1 1.12193
R17 vss.n5 vss.t25 7.01004
R18 vss.n11 vss.t22 17.644
R19 vss.n20 vss.t20 17.644
R20 vss.n14 vss.t18 17.644
R21 vss.n22 vss.t16 17.644
R22 vss.t14 vss.n15 17.644
R23 vss.n18 vss.t9 17.644
R24 vss.t7 vss.n25 17.644
R25 vss.t5 vss.n19 17.644
R26 vss.n28 vss.t3 17.644
R27 vss.n36 vss.n7 8.50058
R28 vss.n7 vss.n4 1.05859
R29 vss.n2 vss.n30 200.322
R30 vss.t23 vss.t11 14.6536
R31 vss.t21 vss.n11 12.8594
R32 vss.n20 vss.t19 12.8594
R33 vss.t17 vss.n14 12.8594
R34 vss.t15 vss.n22 12.8594
R35 vss.t13 vss.n15 12.8594
R36 vss.n24 vss.t12 12.8594
R37 vss.n18 vss.t10 12.8594
R38 vss.n25 vss.t8 12.8594
R39 vss.t6 vss.n19 12.8594
R40 vss.n28 vss.t4 12.8594
R41 vss.n21 vss.t17 12.1076
R42 vss.t12 vss.n10 12.1076
R43 vss.t10 vss.n17 12.1076
R44 vss.t8 vss.n9 12.1076
R45 vss.n26 vss.t6 12.1076
R46 vss.n16 vss.t13 12.1071
R47 vss.n23 vss.t15 12.1071
R48 vss.t19 vss.n13 12.1071
R49 vss.n12 vss.t21 12.1071
R50 vss.n8 vss.t27 7.01074
R51 vss.t4 vss.n27 12.1071
R52 vss.n36 vss.n35 10.168
R53 vss.n7 vss.n32 8.501
R54 vss.t1 vss.n28 8.5005
R55 vss.t1 vss.n25 8.5005
R56 vss.t1 vss.n24 8.5005
R57 vss.t1 vss.n22 8.5005
R58 vss.t1 vss.n20 8.5005
R59 vss.t1 vss.n11 8.5005
R60 vss.t1 vss.n14 8.5005
R61 vss.t1 vss.n15 8.5005
R62 vss.t1 vss.n18 8.5005
R63 vss.t1 vss.n19 8.5005
R64 vss.n3 vss.n4 0.516348
R65 vss.n3 vss.n6 5.67123
R66 vss.n0 vss.t1 0.069017
R67 vss.n23 vss.t14 7.32294
R68 vss.n27 vss.t5 7.32294
R69 vss.t20 vss.n12 7.32294
R70 vss.t18 vss.n13 7.32294
R71 vss.n16 vss.t2 7.32294
R72 vss.t3 vss.n5 8.02574
R73 vss.n26 vss.t7 7.32242
R74 vss.t9 vss.n9 7.32242
R75 vss.t11 vss.n17 7.32242
R76 vss.t0 vss.n10 7.32242
R77 vss.t16 vss.n21 7.32242
R78 vss.n33 vss.n7 5.6686
R79 vss.n32 vss.n31 4.75145
R80 vss.n36 vss.n31 4.75092
R81 vss.n24 vss.t23 2.99093
R82 vss.t1 vss.n27 1.93648
R83 vss.t1 vss.n26 1.93648
R84 vss.t1 vss.n9 1.93648
R85 vss.t1 vss.n10 1.93648
R86 vss.t1 vss.n23 1.93648
R87 vss.t1 vss.n21 1.93648
R88 vss.n8 vss.t22 8.02612
R89 vss.t1 vss.n12 1.93648
R90 vss.t1 vss.n13 1.93648
R91 vss.t1 vss.n16 1.93648
R92 vss.t1 vss.n17 1.93648
R93 vss.t1 vss.n5 1.12177
R94 vss.n3 vss.n31 1.87635
R95 vss.t24 vss.n1 1.67784
R96 vss.n1 vss.t26 0.693955
R97 vss.t1 vss.n1 0.0215888
R98 vss.n34 vss.n7 1.21479
R99 vss.n7 vss.n2 1.70928
R100 vss.n3 vss.n2 1.7086
R101 vss.n0 vss.t24 1.10694
R102 vss vss.t1 0.0005
C0 a_8474_1965# dw_8122_3287# 0.11747f
C1 a_8474_1965# a_8474_2035# 0.02075f
C2 a_9776_10932# vout 0.03993f
C3 dw_8122_3287# dw_9390_3287# 2.48837f
C4 vout vref 2.97107f
C5 a_8474_1965# vref 0.19179f
C6 a_8474_1965# vout 1.11736f
C7 dw_9390_3287# vref 0.66034f
C8 dw_9390_3287# vout 0.24433f
C9 a_8474_1965# a_9398_2035# 0.02416f
C10 dw_8122_3287# a_8232_3371# 1.06735f
C11 a_8474_1965# dw_9390_3287# 0.06199f
C12 a_8232_3371# a_8474_2035# 0.05211f
C13 dw_8122_3287# rfin 0.07528f
C14 a_8474_1965# a_12042_5026# 0.01902f
C15 a_8232_3371# a_9398_2035# 0.01213f
C16 a_8474_1965# a_8232_3371# 0.06382f
C17 dw_8122_3287# vdd 6.31825f
C18 a_9398_2035# a_9398_2535# 0.02622f
C19 a_8474_1965# a_9398_2535# 0.03586f
C20 dw_9390_3287# a_8232_3371# 0.10207f
C21 dw_9390_3287# a_9398_2535# 0.54686f
C22 a_8474_1965# rfin 0.01614f
C23 a_9776_10932# vdd 0.0126f
C24 vdd vref 2.17332f
C25 dw_9390_3287# rfin 0.0415f
C26 vout vdd 33.1585f
C27 a_9776_10932# a_9396_10932# 0.01274f
C28 a_9396_10932# vref 0.04195f
C29 a_8474_1965# vdd 5.19837f
C30 a_8232_3371# a_9398_2535# 0.1825f
C31 dw_9390_3287# vdd 0.73047f
C32 a_8232_3371# rfin 1.14761f
C33 a_9396_10932# dw_9390_3287# 0.03652f
C34 rfin a_9398_2535# 0.05177f
C35 a_12042_5026# vdd 0.0653f
C36 a_9776_10932# dw_8122_3287# 0.03763f
C37 dw_8122_3287# vref 0.77553f
C38 dw_8122_3287# vout 4.29311f
C39 vref vss 7.35578f
C40 vout vss 41.11438f
C41 a_9398_2535# vss 0.1611f
C42 a_8232_3371# vss 0.1611f
C43 vss.t1 vss 0.12736p
.ends
