* PEX produced on Wed Jul 22 12:03:55 PM CEST 2026 using /foss/tools/sak/sak-pex.sh with m=3 and s=1 (extresist threshold=10000 mOhm, minres=1000 mOhm, mindelay=1 ps)
* NGSPICE file created from sparx_powdet_sbd_pex.ext - technology: ihp-sg13g2

.subckt sparx_powdet_sbd_pex vout vref vdd rfin vss
X0 vdd vss.t1 cap_cmim l=10u w=10u
X1 vss.t1 dw_8122_3287# vout vss.t13 sg13_lv_nmos ad=0.475p pd=2.88u as=0.475p ps=2.88u w=2.5u l=0.13u
X2 vout dw_8122_3287# vdd vdd sg13_lv_pmos ad=0.95p pd=5.38u as=0.95p ps=5.38u w=5u l=0.13u
X3 vss.t1 dw_8122_3287# vout vss.t21 sg13_lv_nmos ad=0.475p pd=2.88u as=0.475p ps=2.88u w=2.5u l=0.13u
X4 vdd vss.t1 cap_cmim l=10u w=10u
X5 a_8474_1965# vss.t1 cap_cmim l=10u w=10u
X6 vout dw_8122_3287# vdd vdd sg13_lv_pmos ad=0.95p pd=5.38u as=0.95p ps=5.38u w=5u l=0.13u
X7 vdd dw_9390_3287# vref vdd sg13_lv_pmos ad=0.95p pd=5.38u as=0.95p ps=5.38u w=5u l=0.13u
X8 vss.t1 dw_8122_3287# vout vss.t3 sg13_lv_nmos ad=0.475p pd=2.88u as=0.475p ps=2.88u w=2.5u l=0.13u
X9 a_9398_2535# dw_9390_3287# vss schottky_nbl1 l=1.2u w=2.655u
X10 vout dw_8122_3287# vdd vdd sg13_lv_pmos ad=0.95p pd=5.38u as=0.95p ps=5.38u w=5u l=0.13u
X11 a_8474_1965# vss.t1 cap_cmim l=10u w=10u
X12 vdd vss.t1 cap_cmim l=10u w=10u
X13 vdd vss.t1 cap_cmim l=10u w=10u
X14 vdd vss.t1 cap_cmim l=10u w=10u
X15 a_8474_1965# vss.t1 cap_cmim l=10u w=10u
X16 vout dw_8122_3287# vss.t1 vss.t12 sg13_lv_nmos ad=0.475p pd=2.88u as=0.475p ps=2.88u w=2.5u l=0.13u
X17 a_8474_1965# vss.t1 cap_cmim l=10u w=10u
X18 vout dw_8122_3287# vdd vdd sg13_lv_pmos ad=0.95p pd=5.38u as=0.95p ps=5.38u w=5u l=0.13u
X19 vdd vss.t1 cap_cmim l=10u w=10u
X20 vdd vss.t1 cap_cmim l=10u w=10u
X21 a_8474_1965# vss.t1 cap_cmim l=10u w=10u
X22 vout dw_8122_3287# vss.t1 vss.t10 sg13_lv_nmos ad=0.475p pd=2.88u as=0.475p ps=2.88u w=2.5u l=0.13u
X23 vdd vss.t1 cap_cmim l=9u w=6.8u
X24 vdd vss.t1 cap_cmim l=10u w=10u
X25 vdd vss.t1 cap_cmim l=10u w=10u
X26 vss.t1 dw_8122_3287# vout vss.t17 sg13_lv_nmos ad=0.475p pd=2.88u as=0.475p ps=2.88u w=2.5u l=0.13u
X27 a_8474_1965# vss.t1 cap_cmim l=10u w=10u
X28 a_8474_1965# vss.t1 cap_cmim l=10u w=10u
X29 a_8474_1965# vss.t1 cap_cmim l=10u w=10u
X30 vout dw_8122_3287# vdd vdd sg13_lv_pmos ad=0.95p pd=5.38u as=0.95p ps=5.38u w=5u l=0.13u
X31 a_8474_1965# vss.t1 cap_cmim l=10u w=10u
X32 vss.t1 vss.t1 vss.t1 vss.t26 sg13_lv_nmos ad=0.475p pd=2.88u as=0 ps=0 w=2.5u l=0.13u
X33 vdd vss.t1 cap_cmim l=9u w=6.8u
X34 vdd vss.t1 cap_cmim l=10u w=10u
X35 vdd vss.t1 cap_cmim l=10u w=10u
X36 vdd dw_8122_3287# vout vdd sg13_lv_pmos ad=0.95p pd=5.38u as=0.95p ps=5.38u w=5u l=0.13u
X37 vdd vss.t1 cap_cmim l=10u w=10u
X38 a_8474_1965# vss.t1 cap_cmim l=10u w=10u
X39 vss.t1 dw_8122_3287# vout vss.t7 sg13_lv_nmos ad=0.475p pd=2.88u as=0.475p ps=2.88u w=2.5u l=0.13u
X40 a_8474_1965# vdd vss.t28 rhigh l=2u w=0.5u
X41 vdd dw_8122_3287# vout vdd sg13_lv_pmos ad=0.95p pd=5.38u as=0.95p ps=5.38u w=5u l=0.13u
X42 vout dw_8122_3287# vss.t1 vss.t14 sg13_lv_nmos ad=0.475p pd=2.88u as=0.475p ps=2.88u w=2.5u l=0.13u
X43 a_8474_1965# vss.t1 cap_cmim l=10u w=10u
X44 vdd vss.t1 cap_cmim l=10u w=10u
X45 vdd vss.t1 cap_cmim l=10u w=10u
X46 vss.t1 dw_8122_3287# vout vss.t5 sg13_lv_nmos ad=0.475p pd=2.88u as=0.475p ps=2.88u w=2.5u l=0.13u
X47 a_8474_1965# vss.t1 cap_cmim l=10u w=10u
X48 vdd vss.t1 cap_cmim l=10u w=10u
X49 a_8474_1965# vss.t1 cap_cmim l=10u w=10u
X50 vref dw_9390_3287# vss.t1 vss.t2 sg13_lv_nmos ad=0.475p pd=2.88u as=0.475p ps=2.88u w=2.5u l=0.13u
X51 a_8474_1965# vss.t1 cap_cmim l=10u w=10u
X52 vdd vss.t1 cap_cmim l=10u w=10u
X53 vout dw_8122_3287# vss.t1 vss.t20 sg13_lv_nmos ad=0.475p pd=2.88u as=0.475p ps=2.88u w=2.5u l=0.13u
X54 rfin a_8232_3371# cap_cmim l=10u w=10u
X55 dw_9390_3287# vref vss.t23 rppd l=1.5u w=0.5u
X56 vdd vss.t1 cap_cmim l=10u w=10u
X57 vdd dw_8122_3287# vout vdd sg13_lv_pmos ad=0.95p pd=5.38u as=0.95p ps=5.38u w=5u l=0.13u
X58 a_9398_2535# a_8474_1965# vss.t59 rsil l=2.5u w=0.5u
X59 vss.t1 dw_8122_3287# vout vss.t19 sg13_lv_nmos ad=0.475p pd=2.88u as=0.475p ps=2.88u w=2.5u l=0.13u
X60 a_8474_1965# vss.t1 cap_cmim l=10u w=10u
X61 vdd vss.t1 cap_cmim l=10u w=10u
X62 vdd dw_8122_3287# vout vdd sg13_lv_pmos ad=0.95p pd=5.38u as=0.95p ps=5.38u w=5u l=0.13u
X63 vout dw_8122_3287# vdd vdd sg13_lv_pmos ad=0.95p pd=5.38u as=0.95p ps=5.38u w=5u l=0.13u
X64 vss.t1 vss.t24 vss.t1 vss.t25 sg13_lv_nmos ad=0.85p pd=5.68u as=0 ps=0 w=2.5u l=0.13u
X65 vdd vss.t1 cap_cmim l=10u w=10u
X66 vdd vss.t1 cap_cmim l=10u w=10u
X67 a_8232_3371# dw_8122_3287# vss schottky_nbl1 l=1.2u w=2.655u
X68 vout dw_8122_3287# vss.t23 rppd l=1.5u w=0.5u
X69 vout dw_8122_3287# vdd vdd sg13_lv_pmos ad=0.95p pd=5.38u as=0.95p ps=5.38u w=5u l=0.13u
X70 vss.t1 dw_8122_3287# vout vss.t11 sg13_lv_nmos ad=0.475p pd=2.88u as=0.475p ps=2.88u w=2.5u l=0.13u
X71 a_8474_1965# vss.t1 cap_cmim l=10u w=10u
X72 vdd dw_8122_3287# vout vdd sg13_lv_pmos ad=0.95p pd=5.38u as=0.95p ps=5.38u w=5u l=0.13u
X73 a_8474_1965# vss.t1 cap_cmim l=10u w=10u
X74 vss.t1 dw_8122_3287# vout vss.t9 sg13_lv_nmos ad=0.475p pd=2.88u as=0.475p ps=2.88u w=2.5u l=0.13u
X75 vout dw_8122_3287# vss.t1 vss.t16 sg13_lv_nmos ad=0.475p pd=2.88u as=0.475p ps=2.88u w=2.5u l=0.13u
X76 a_8474_1965# vss.t1 cap_cmim l=10u w=10u
X77 a_8474_1965# vss.t1 cap_cmim l=10u w=10u
X78 vdd vss.t1 cap_cmim l=10u w=10u
X79 a_8474_1965# vss.t1 cap_cmim l=10u w=10u
X80 a_8474_1965# vss.t1 cap_cmim l=10u w=10u
X81 vout dw_8122_3287# vss.t1 vss.t22 sg13_lv_nmos ad=0.475p pd=2.88u as=0.475p ps=2.88u w=2.5u l=0.13u
X82 vdd dw_8122_3287# vout vdd sg13_lv_pmos ad=0.95p pd=5.38u as=0.95p ps=5.38u w=5u l=0.13u
X83 vdd vss.t1 cap_cmim l=10u w=10u
X84 vout dw_8122_3287# vdd vdd sg13_lv_pmos ad=0.95p pd=5.38u as=0.95p ps=5.38u w=5u l=0.13u
X85 vout dw_8122_3287# vss.t1 vss.t6 sg13_lv_nmos ad=0.475p pd=2.88u as=0.475p ps=2.88u w=2.5u l=0.13u
X86 vdd dw_8122_3287# vout vdd sg13_lv_pmos ad=0.95p pd=5.38u as=0.95p ps=5.38u w=5u l=0.13u
X87 a_8474_1965# vss.t1 cap_cmim l=10u w=10u
X88 a_8474_1965# vss.t1 cap_cmim l=10u w=10u
X89 vref dw_9390_3287# vdd vdd sg13_lv_pmos ad=0.95p pd=5.38u as=0.95p ps=5.38u w=5u l=0.13u
X90 vout dw_8122_3287# vss.t1 vss.t4 sg13_lv_nmos ad=0.475p pd=2.88u as=0.475p ps=2.88u w=2.5u l=0.13u
X91 vdd vdd vdd vdd sg13_lv_pmos ad=0.95p pd=5.38u as=43.4451p ps=0.26832m w=5u l=0.13u
X92 vss.t1 dw_9390_3287# vref vss.t0 sg13_lv_nmos ad=0.475p pd=2.88u as=0.475p ps=2.88u w=2.5u l=0.13u
X93 vdd vss.t1 cap_cmim l=10u w=10u
X94 vdd dw_8122_3287# vout vdd sg13_lv_pmos ad=0.95p pd=5.38u as=0.95p ps=5.38u w=5u l=0.13u
X95 a_8474_1965# vss.t1 cap_cmim l=10u w=10u
X96 a_8474_1965# vss.t1 cap_cmim l=10u w=10u
X97 vdd vss.t1 cap_cmim l=10u w=10u
X98 a_8474_1965# vss.t1 cap_cmim l=10u w=10u
X99 a_8474_1965# vss.t1 cap_cmim l=10u w=10u
X100 a_8474_1965# vss.t1 cap_cmim l=10u w=10u
X101 vdd vss.t1 cap_cmim l=10u w=10u
X102 vdd vdd vdd vdd sg13_lv_pmos ad=1.7p pd=10.68u as=0 ps=0 w=5u l=0.13u
X103 vout dw_8122_3287# vdd vdd sg13_lv_pmos ad=0.95p pd=5.38u as=0.95p ps=5.38u w=5u l=0.13u
X104 vout dw_8122_3287# vss.t1 vss.t18 sg13_lv_nmos ad=0.475p pd=2.88u as=0.475p ps=2.88u w=2.5u l=0.13u
X105 vdd dw_8122_3287# vout vdd sg13_lv_pmos ad=0.95p pd=5.38u as=0.95p ps=5.38u w=5u l=0.13u
X106 vdd vss.t1 cap_cmim l=10u w=10u
X107 a_8474_1965# vss.t1 cap_cmim l=10u w=10u
X108 a_8232_3371# a_8474_1965# vss.t90 rsil l=2.5u w=0.5u
X109 vdd vss.t1 cap_cmim l=10u w=10u
X110 vdd dw_8122_3287# vout vdd sg13_lv_pmos ad=0.95p pd=5.38u as=0.95p ps=5.38u w=5u l=0.13u
X111 vout dw_8122_3287# vdd vdd sg13_lv_pmos ad=0.95p pd=5.38u as=0.95p ps=5.38u w=5u l=0.13u
X112 vout dw_8122_3287# vss.t1 vss.t8 sg13_lv_nmos ad=0.475p pd=2.88u as=0.475p ps=2.88u w=2.5u l=0.13u
X113 a_8474_1965# vss.t1 cap_cmim l=10u w=10u
X114 vdd vss.t1 cap_cmim l=10u w=10u
X115 vss.t1 dw_8122_3287# vout vss.t15 sg13_lv_nmos ad=0.475p pd=2.88u as=0.475p ps=2.88u w=2.5u l=0.13u
R0 vss.n35 vss.t59 5876.96
R1 vss.n32 vss.n31 5537.89
R2 vss.t1 vss.n3 558.463
R3 vss.t28 vss.n35 3087.21
R4 vss.n31 vss.t90 1588.69
R5 vss.t28 vss.n3 1640.15
R6 vss.t90 vss.n30 931.034
R7 vss.t59 vss.n34 931.034
R8 vss.n29 vss.n3 901.753
R9 vss.n35 vss.n1 446.897
R10 vss.n30 vss.n27 206.898
R11 vss.n34 vss.n27 206.898
R12 vss.n32 vss.n2 140.827
R13 vss.t0 vss.t2 30.5029
R14 vss.t26 vss.n6 7.01097
R15 vss.t1 vss.n4 1.12214
R16 vss.n10 vss.t22 17.644
R17 vss.n19 vss.t20 17.644
R18 vss.n12 vss.t18 17.644
R19 vss.n20 vss.t16 17.644
R20 vss.n14 vss.t14 17.644
R21 vss.t9 vss.n16 17.644
R22 vss.n25 vss.t7 17.644
R23 vss.t5 vss.n17 17.644
R24 vss.n26 vss.t3 17.644
R25 vss.n33 vss.n5 8.50058
R26 vss.n0 vss.n27 200.322
R27 vss.n2 vss.n1 0.515994
R28 vss.t11 vss.t23 14.6536
R29 vss.n10 vss.t21 12.8594
R30 vss.n19 vss.t19 12.8594
R31 vss.t17 vss.n12 12.8594
R32 vss.n20 vss.t15 12.8594
R33 vss.t13 vss.n14 12.8594
R34 vss.n22 vss.t12 12.8594
R35 vss.t10 vss.n16 12.8594
R36 vss.n25 vss.t8 12.8594
R37 vss.n17 vss.t6 12.8594
R38 vss.n26 vss.t4 12.8594
R39 vss.t15 vss.n8 12.1076
R40 vss.n23 vss.t10 12.1076
R41 vss.t4 vss.n18 12.1076
R42 vss.t25 vss.n4 7.01235
R43 vss.n15 vss.t13 12.1071
R44 vss.n13 vss.t17 12.1071
R45 vss.t19 vss.n11 12.1071
R46 vss.t21 vss.n9 12.1071
R47 vss.t22 vss.n6 8.02609
R48 vss.t12 vss.n21 12.1071
R49 vss.t8 vss.n24 12.1071
R50 vss.t6 vss.n7 12.1071
R51 vss.n33 vss.n32 10.168
R52 vss.n5 vss.n29 8.501
R53 vss.t1 vss.n26 8.5005
R54 vss.t1 vss.n25 8.5005
R55 vss.t1 vss.n22 8.5005
R56 vss.t1 vss.n20 8.5005
R57 vss.t1 vss.n19 8.5005
R58 vss.t1 vss.n10 8.5005
R59 vss.t1 vss.n12 8.5005
R60 vss.t1 vss.n14 8.5005
R61 vss.t1 vss.n16 8.5005
R62 vss.t1 vss.n17 8.5005
R63 vss.n5 vss.n2 1.05788
R64 vss.t20 vss.n9 7.32294
R65 vss.n21 vss.t0 7.32294
R66 vss.n24 vss.t9 7.32294
R67 vss.t7 vss.n7 7.32294
R68 vss.t18 vss.n11 7.32294
R69 vss.t16 vss.n13 7.32294
R70 vss.t2 vss.n15 7.32294
R71 vss.t3 vss.n4 8.02543
R72 vss.n18 vss.t5 7.32242
R73 vss.n23 vss.t11 7.32242
R74 vss.t14 vss.n8 7.32242
R75 vss.n30 vss.n5 5.6686
R76 vss.n34 vss.n1 5.66767
R77 vss.n29 vss.n28 4.75145
R78 vss.n33 vss.n28 4.75092
R79 vss.t23 vss.n22 2.99093
R80 vss.t1 vss.n7 1.93648
R81 vss.t1 vss.n24 1.93648
R82 vss.t1 vss.n23 1.93648
R83 vss.t1 vss.n21 1.93648
R84 vss.t1 vss.n8 1.93648
R85 vss.t1 vss.n9 1.93648
R86 vss.t1 vss.n6 1.12197
R87 vss.t1 vss.n11 1.93648
R88 vss.t1 vss.n13 1.93648
R89 vss.t1 vss.n15 1.93648
R90 vss.t1 vss.n18 1.93648
R91 vss.n1 vss.n28 1.87635
R92 vss.n31 vss.n5 1.21479
R93 vss.t24 vss.t1 0.808336
R94 vss.n5 vss.n0 1.70935
R95 vss.n1 vss.n0 1.70867
R96 vss vss.n0 0.0005
C0 a_8232_3371# dw_8122_3287# 1.06735f
C1 vout a_8474_1965# 1.11736f
C2 a_8232_3371# dw_9390_3287# 0.10207f
C3 a_9776_10932# a_9396_10932# 0.01274f
C4 vref dw_8122_3287# 0.77553f
C5 a_9398_2035# a_8474_1965# 0.02416f
C6 vref dw_9390_3287# 0.66034f
C7 a_8232_3371# rfin 1.14761f
C8 dw_9390_3287# dw_8122_3287# 2.48837f
C9 a_8474_1965# a_8232_3371# 0.06382f
C10 vref vdd 2.17332f
C11 a_8474_2035# a_8232_3371# 0.05211f
C12 vdd dw_8122_3287# 6.31825f
C13 vout a_9776_10932# 0.03993f
C14 vdd dw_9390_3287# 0.73047f
C15 vref a_8474_1965# 0.19179f
C16 dw_8122_3287# rfin 0.07528f
C17 a_8474_1965# dw_8122_3287# 0.11747f
C18 dw_9390_3287# rfin 0.0415f
C19 a_9398_2035# a_9398_2535# 0.02622f
C20 a_8474_1965# dw_9390_3287# 0.06199f
C21 a_9398_2535# a_8232_3371# 0.1825f
C22 a_8474_1965# vdd 5.19837f
C23 vref a_9396_10932# 0.04195f
C24 a_8474_1965# rfin 0.01614f
C25 a_9396_10932# dw_9390_3287# 0.03652f
C26 a_12042_5026# vdd 0.0653f
C27 a_8474_1965# a_8474_2035# 0.02075f
C28 a_9398_2535# dw_9390_3287# 0.54686f
C29 a_8474_1965# a_12042_5026# 0.01902f
C30 a_9776_10932# dw_8122_3287# 0.03763f
C31 vref vout 2.97107f
C32 vout dw_8122_3287# 4.29311f
C33 a_9398_2035# a_8232_3371# 0.01213f
C34 a_9398_2535# rfin 0.05177f
C35 vout dw_9390_3287# 0.24433f
C36 a_8474_1965# a_9398_2535# 0.03586f
C37 vdd a_9776_10932# 0.0126f
C38 vout vdd 33.1585f
C39 vref vss 7.35578f
C40 vout vss 41.11438f
C41 a_9398_2535# vss 0.1611f
C42 a_8232_3371# vss 0.1611f
C43 vss.t1 vss 3.58749f
.ends
