* PEX produced on Mon Aug 24 03:25:22 PM CEST 2026 using /foss/tools/sak/sak-pex.sh with m=3 and s=1 (extresist threshold=10000 mOhm, minres=1000 mOhm, mindelay=1 ps)
* NGSPICE file created from sparx_powdet_sbd_pex.ext - technology: ihp-sg13g2

.subckt sparx_powdet_sbd_pex vout vref vdd rfin vss
X0 vout dw_8122_4047# vdd vdd sg13_lv_pmos ad=0.95p pd=5.38u as=0.95p ps=5.38u w=5u l=0.13u
X1 a_8474_2725# vss.t29 cap_cmim l=10u w=10u
X2 vout dw_8122_4047# vss.t1 vss.t8 sg13_lv_nmos ad=0.475p pd=2.88u as=0.475p ps=2.88u w=2.5u l=0.13u
X3 vdd vss.t29 cap_cmim l=10u w=10u
X4 vdd vss.t29 cap_cmim l=10u w=10u
X5 vss.t1 dw_8122_4047# vout vss.t15 sg13_lv_nmos ad=0.475p pd=2.88u as=0.475p ps=2.88u w=2.5u l=0.13u
X6 a_8474_2725# vss.t29 cap_cmim l=10u w=10u
X7 vdd vdd vdd vdd sg13_lv_pmos ad=0.95p pd=5.38u as=43.4451p ps=0.26832m w=5u l=0.13u
X8 a_8474_2725# vss.t29 cap_cmim l=10u w=10u
X9 a_8474_2725# vss.t29 cap_cmim l=10u w=10u
X10 vss.t1 dw_8122_4047# vout vss.t13 sg13_lv_nmos ad=0.475p pd=2.88u as=0.475p ps=2.88u w=2.5u l=0.13u
X11 vout dw_8122_4047# vdd vdd sg13_lv_pmos ad=0.95p pd=5.38u as=0.95p ps=5.38u w=5u l=0.13u
X12 vdd vss.t29 cap_cmim l=10u w=10u
X13 vdd vss.t29 cap_cmim l=10u w=10u
X14 a_8474_2725# vss.t29 cap_cmim l=10u w=10u
X15 a_8474_2725# vss.t29 cap_cmim l=10u w=10u
X16 vout dw_8122_4047# vss.t1 vss.t22 sg13_lv_nmos ad=0.475p pd=2.88u as=0.475p ps=2.88u w=2.5u l=0.13u
X17 vout dw_8122_4047# vdd vdd sg13_lv_pmos ad=0.95p pd=5.38u as=0.95p ps=5.38u w=5u l=0.13u
X18 vdd dw_9390_4047# vref vdd sg13_lv_pmos ad=0.95p pd=5.38u as=0.95p ps=5.38u w=5u l=0.13u
X19 vout dw_8122_4047# vdd vdd sg13_lv_pmos ad=0.95p pd=5.38u as=0.95p ps=5.38u w=5u l=0.13u
X20 vss.t1 dw_8122_4047# vout vss.t3 sg13_lv_nmos ad=0.475p pd=2.88u as=0.475p ps=2.88u w=2.5u l=0.13u
X21 vout dw_8122_4047# vss.t1 vss.t12 sg13_lv_nmos ad=0.475p pd=2.88u as=0.475p ps=2.88u w=2.5u l=0.13u
X22 vdd vss.t29 cap_cmim l=9u w=6.8u
X23 vdd vss.t29 cap_cmim l=10u w=10u
X24 vdd vss.t29 cap_cmim l=10u w=10u
X25 a_8474_2725# vss.t29 cap_cmim l=10u w=10u
X26 vout dw_8122_4047# vdd vdd sg13_lv_pmos ad=0.95p pd=5.38u as=0.95p ps=5.38u w=5u l=0.13u
X27 a_8474_2725# vss.t29 cap_cmim l=10u w=10u
X28 vss.t1 dw_8122_4047# vout vss.t19 sg13_lv_nmos ad=0.475p pd=2.88u as=0.475p ps=2.88u w=2.5u l=0.13u
X29 vout dw_8122_4047# vss.t1 vss.t10 sg13_lv_nmos ad=0.475p pd=2.88u as=0.475p ps=2.88u w=2.5u l=0.13u
X30 a_8474_2725# vss.t29 cap_cmim l=10u w=10u
X31 vdd vss.t29 cap_cmim l=10u w=10u
X32 a_8474_2725# vss.t29 cap_cmim l=10u w=10u
X33 a_8474_2725# vss.t29 cap_cmim l=10u w=10u
X34 vss.t1 dw_8122_4047# vout vss.t17 sg13_lv_nmos ad=0.475p pd=2.88u as=0.475p ps=2.88u w=2.5u l=0.13u
X35 vdd vss.t29 cap_cmim l=10u w=10u
X36 a_8474_2725# vss.t29 cap_cmim l=10u w=10u
X37 a_8474_2725# vss.t29 cap_cmim l=10u w=10u
X38 rfin a_8232_4131# cap_cmim l=10u w=10u
X39 a_8474_2725# vss.t29 cap_cmim l=10u w=10u
X40 vdd vss.t29 cap_cmim l=10u w=10u
X41 a_8474_2725# vdd vss.t28 rhigh l=2u w=0.5u
X42 vout dw_8122_4047# vdd vdd sg13_lv_pmos ad=0.95p pd=5.38u as=0.95p ps=5.38u w=5u l=0.13u
X43 a_8232_4131# dw_8122_4047# vss schottky_nbl1 l=1.2u w=2.655u
X44 vdd dw_8122_4047# vout vdd sg13_lv_pmos ad=0.95p pd=5.38u as=0.95p ps=5.38u w=5u l=0.13u
X45 vss.t1 dw_8122_4047# vout vss.t7 sg13_lv_nmos ad=0.475p pd=2.88u as=0.475p ps=2.88u w=2.5u l=0.13u
X46 vdd vss.t29 cap_cmim l=10u w=10u
X47 vdd dw_8122_4047# vout vdd sg13_lv_pmos ad=0.95p pd=5.38u as=0.95p ps=5.38u w=5u l=0.13u
X48 a_8474_2725# vss.t29 cap_cmim l=10u w=10u
X49 vout dw_8122_4047# vss.t1 vss.t14 sg13_lv_nmos ad=0.475p pd=2.88u as=0.475p ps=2.88u w=2.5u l=0.13u
X50 vss.t1 dw_8122_4047# vout vss.t5 sg13_lv_nmos ad=0.475p pd=2.88u as=0.475p ps=2.88u w=2.5u l=0.13u
X51 vout dw_8122_4047# vdd vdd sg13_lv_pmos ad=0.95p pd=5.38u as=0.95p ps=5.38u w=5u l=0.13u
X52 a_9398_3295# a_8474_2725# vss.t60 rsil l=2.5u w=0.5u
X53 vref dw_9390_4047# vss.t1 vss.t2 sg13_lv_nmos ad=0.475p pd=2.88u as=0.475p ps=2.88u w=2.5u l=0.13u
X54 vdd vss.t29 cap_cmim l=10u w=10u
X55 vss.t1 dw_8122_4047# vout vss.t21 sg13_lv_nmos ad=0.475p pd=2.88u as=0.475p ps=2.88u w=2.5u l=0.13u
X56 dw_9390_4047# vref vss.t23 rppd l=1.5u w=0.5u
X57 vdd vss.t29 cap_cmim l=10u w=10u
X58 vdd dw_8122_4047# vout vdd sg13_lv_pmos ad=0.95p pd=5.38u as=0.95p ps=5.38u w=5u l=0.13u
X59 vdd vss.t29 cap_cmim l=10u w=10u
X60 vout dw_8122_4047# vdd vdd sg13_lv_pmos ad=0.95p pd=5.38u as=0.95p ps=5.38u w=5u l=0.13u
X61 vss.t1 vss.t1 vss.t1 vss.t24 sg13_lv_nmos ad=0.85p pd=5.68u as=0 ps=0 w=2.5u l=0.13u
X62 a_8474_2725# vss.t29 cap_cmim l=10u w=10u
X63 vdd dw_8122_4047# vout vdd sg13_lv_pmos ad=0.95p pd=5.38u as=0.95p ps=5.38u w=5u l=0.13u
X64 vout dw_8122_4047# vdd vdd sg13_lv_pmos ad=0.95p pd=5.38u as=0.95p ps=5.38u w=5u l=0.13u
X65 vss.t1 dw_8122_4047# vout vss.t11 sg13_lv_nmos ad=0.475p pd=2.88u as=0.475p ps=2.88u w=2.5u l=0.13u
X66 vdd vss.t29 cap_cmim l=10u w=10u
X67 vout dw_8122_4047# vss.t23 rppd l=1.5u w=0.5u
X68 vdd vss.t29 cap_cmim l=10u w=10u
X69 a_8474_2725# vss.t29 cap_cmim l=10u w=10u
X70 vdd vss.t29 cap_cmim l=10u w=10u
X71 a_8474_2725# vss.t29 cap_cmim l=10u w=10u
X72 vdd dw_8122_4047# vout vdd sg13_lv_pmos ad=0.95p pd=5.38u as=0.95p ps=5.38u w=5u l=0.13u
X73 a_8474_2725# vss.t29 cap_cmim l=10u w=10u
X74 vss.t1 dw_8122_4047# vout vss.t9 sg13_lv_nmos ad=0.475p pd=2.88u as=0.475p ps=2.88u w=2.5u l=0.13u
X75 a_8474_2725# vss.t29 cap_cmim l=10u w=10u
X76 vdd vss.t29 cap_cmim l=10u w=10u
X77 a_8474_2725# vss.t29 cap_cmim l=10u w=10u
X78 vout dw_8122_4047# vss.t1 vss.t16 sg13_lv_nmos ad=0.475p pd=2.88u as=0.475p ps=2.88u w=2.5u l=0.13u
X79 a_8474_2725# vss.t29 cap_cmim l=10u w=10u
X80 vdd vss.t29 cap_cmim l=10u w=10u
X81 vdd dw_8122_4047# vout vdd sg13_lv_pmos ad=0.95p pd=5.38u as=0.95p ps=5.38u w=5u l=0.13u
X82 vdd vss.t29 cap_cmim l=10u w=10u
X83 vss.t1 vss.t1 vss.t1 vss.t26 sg13_lv_nmos ad=0.475p pd=2.88u as=0 ps=0 w=2.5u l=0.13u
X84 a_8474_2725# vss.t29 cap_cmim l=10u w=10u
X85 vdd vss.t29 cap_cmim l=9u w=6.8u
X86 vout dw_8122_4047# vdd vdd sg13_lv_pmos ad=0.95p pd=5.38u as=0.95p ps=5.38u w=5u l=0.13u
X87 vdd vss.t29 cap_cmim l=10u w=10u
X88 vdd dw_8122_4047# vout vdd sg13_lv_pmos ad=0.95p pd=5.38u as=0.95p ps=5.38u w=5u l=0.13u
X89 vout dw_8122_4047# vss.t1 vss.t6 sg13_lv_nmos ad=0.475p pd=2.88u as=0.475p ps=2.88u w=2.5u l=0.13u
X90 a_8474_2725# vss.t29 cap_cmim l=10u w=10u
X91 vref dw_9390_4047# vdd vdd sg13_lv_pmos ad=0.95p pd=5.38u as=0.95p ps=5.38u w=5u l=0.13u
X92 vout dw_8122_4047# vss.t1 vss.t4 sg13_lv_nmos ad=0.475p pd=2.88u as=0.475p ps=2.88u w=2.5u l=0.13u
X93 vdd dw_8122_4047# vout vdd sg13_lv_pmos ad=0.95p pd=5.38u as=0.95p ps=5.38u w=5u l=0.13u
X94 vdd vss.t29 cap_cmim l=10u w=10u
X95 vdd vss.t29 cap_cmim l=10u w=10u
X96 vdd vss.t29 cap_cmim l=10u w=10u
X97 vdd vss.t29 cap_cmim l=10u w=10u
X98 vss.t1 dw_9390_4047# vref vss.t0 sg13_lv_nmos ad=0.475p pd=2.88u as=0.475p ps=2.88u w=2.5u l=0.13u
X99 a_8474_2725# vss.t29 cap_cmim l=10u w=10u
X100 a_8474_2725# vss.t29 cap_cmim l=10u w=10u
X101 vout dw_8122_4047# vss.t1 vss.t20 sg13_lv_nmos ad=0.475p pd=2.88u as=0.475p ps=2.88u w=2.5u l=0.13u
X102 a_8474_2725# vss.t29 cap_cmim l=10u w=10u
X103 a_8474_2725# vss.t29 cap_cmim l=10u w=10u
X104 vdd vss.t29 cap_cmim l=10u w=10u
X105 vdd vdd vdd vdd sg13_lv_pmos ad=1.7p pd=10.68u as=0 ps=0 w=5u l=0.13u
X106 a_8474_2725# vss.t29 cap_cmim l=10u w=10u
X107 vdd vss.t29 cap_cmim l=10u w=10u
X108 vdd vss.t29 cap_cmim l=10u w=10u
X109 vout dw_8122_4047# vss.t1 vss.t18 sg13_lv_nmos ad=0.475p pd=2.88u as=0.475p ps=2.88u w=2.5u l=0.13u
X110 vdd dw_8122_4047# vout vdd sg13_lv_pmos ad=0.95p pd=5.38u as=0.95p ps=5.38u w=5u l=0.13u
X111 a_8232_4131# a_8474_2725# vss.t91 rsil l=2.5u w=0.5u
X112 a_9398_3295# dw_9390_4047# vss schottky_nbl1 l=1.2u w=2.655u
X113 a_8474_2725# vss.t29 cap_cmim l=10u w=10u
X114 vdd vss.t29 cap_cmim l=10u w=10u
X115 vdd dw_8122_4047# vout vdd sg13_lv_pmos ad=0.95p pd=5.38u as=0.95p ps=5.38u w=5u l=0.13u
R0 vss.t1 vss.n36 5244.95
R1 vss.n35 vss.t60 5004.79
R2 vss.n36 vss.n35 3732.56
R3 vss.n33 vss.n32 2460.47
R4 vss.n29 vss.t28 2101.74
R5 vss.n36 vss.t28 1178.78
R6 vss.n1 vss.n35 15039.9
R7 vss.n29 vss.t1 817.216
R8 vss.n30 vss.n29 735.946
R9 vss.n32 vss.t91 553.63
R10 vss.n33 vss.n2 140.827
R11 vss.t91 vss.n31 304.267
R12 vss.t60 vss.n4 304.267
R13 vss.n31 vss.n27 67.6152
R14 vss.n4 vss.n27 67.6152
R15 vss.t2 vss.t0 30.5029
R16 vss.n6 vss.t26 7.0111
R17 vss.t1 vss.n3 1.12211
R18 vss.n12 vss.t22 17.644
R19 vss.n18 vss.t20 17.644
R20 vss.t18 vss.n13 17.644
R21 vss.n21 vss.t16 17.644
R22 vss.n14 vss.t14 17.644
R23 vss.t9 vss.n15 17.644
R24 vss.n25 vss.t7 17.644
R25 vss.t5 vss.n16 17.644
R26 vss.t3 vss.n26 17.644
R27 vss.n2 vss.n1 0.516325
R28 vss.n34 vss.n5 8.50058
R29 vss.n5 vss.n2 1.05855
R30 vss.n0 vss.n27 200.322
R31 vss.t23 vss.t11 14.6536
R32 vss.n12 vss.t21 12.8594
R33 vss.t19 vss.n18 12.8594
R34 vss.t17 vss.n13 12.8594
R35 vss.n21 vss.t15 12.8594
R36 vss.t13 vss.n14 12.8594
R37 vss.n23 vss.t12 12.8594
R38 vss.n15 vss.t10 12.8594
R39 vss.n25 vss.t8 12.8594
R40 vss.n16 vss.t6 12.8594
R41 vss.n26 vss.t4 12.8594
R42 vss.n6 vss.t22 8.0256
R43 vss.n20 vss.t17 12.1076
R44 vss.t15 vss.n10 12.1076
R45 vss.n22 vss.t13 12.1076
R46 vss.t12 vss.n9 12.1076
R47 vss.t4 vss.n17 12.1076
R48 vss.t24 vss.n3 7.01214
R49 vss.n19 vss.t19 12.1071
R50 vss.t21 vss.n11 12.1071
R51 vss.t10 vss.n8 12.1071
R52 vss.t8 vss.n24 12.1071
R53 vss.t6 vss.n7 12.1071
R54 vss.n34 vss.n33 10.168
R55 vss.n5 vss.n30 8.501
R56 vss.t1 vss.n26 8.5005
R57 vss.t1 vss.n25 8.5005
R58 vss.t1 vss.n23 8.5005
R59 vss.t1 vss.n21 8.5005
R60 vss.t1 vss.n18 8.5005
R61 vss.t1 vss.n12 8.5005
R62 vss.t1 vss.n13 8.5005
R63 vss.t1 vss.n14 8.5005
R64 vss.t1 vss.n15 8.5005
R65 vss.t1 vss.n16 8.5005
R66 vss.n1 vss.n4 5.67123
R67 vss.t20 vss.n11 7.32294
R68 vss.n19 vss.t18 7.32294
R69 vss.t11 vss.n8 7.32294
R70 vss.n24 vss.t9 7.32294
R71 vss.t7 vss.n7 7.32294
R72 vss.n3 vss.t3 8.02545
R73 vss.n17 vss.t5 7.32242
R74 vss.t0 vss.n9 7.32242
R75 vss.t16 vss.n20 7.32242
R76 vss.t14 vss.n10 7.32242
R77 vss.n22 vss.t2 7.32242
R78 vss.n31 vss.n5 5.6686
R79 vss.n30 vss.n28 4.75145
R80 vss.n34 vss.n28 4.75092
R81 vss.n23 vss.t23 2.99093
R82 vss.t1 vss.n7 1.93648
R83 vss.t1 vss.n24 1.93648
R84 vss.t1 vss.n8 1.93648
R85 vss.t1 vss.n9 1.93648
R86 vss.t1 vss.n22 1.93648
R87 vss.t1 vss.n10 1.93648
R88 vss.t1 vss.n20 1.93648
R89 vss.t1 vss.n19 1.93648
R90 vss.t1 vss.n11 1.93648
R91 vss.t1 vss.n6 1.12194
R92 vss.t1 vss.n17 1.93648
R93 vss.n1 vss.n28 1.87635
R94 vss.n32 vss.n5 1.21479
R95 vss.t29 vss.t1 0.894927
R96 vss.n5 vss.n0 1.70928
R97 vss.n1 vss.n0 1.7086
R98 vss vss.n0 0.0005
C0 a_8474_2725# a_9398_3295# 0.03586f
C1 a_8232_4131# a_9398_2795# 0.01213f
C2 a_8232_4131# dw_8122_4047# 1.06735f
C3 a_8232_4131# dw_9390_4047# 0.10207f
C4 rfin dw_8122_4047# 0.07528f
C5 dw_9390_4047# rfin 0.0415f
C6 a_8474_2795# a_8474_2725# 0.02075f
C7 a_8232_4131# a_8474_2725# 0.06382f
C8 a_8474_2725# a_12042_5786# 0.01902f
C9 a_8474_2725# rfin 0.0265f
C10 a_9776_11692# vdd 0.0126f
C11 a_8232_4131# a_9398_3295# 0.1825f
C12 vdd dw_8122_4047# 6.31825f
C13 rfin a_9398_3295# 0.05178f
C14 dw_9390_4047# vdd 0.73047f
C15 a_9776_11692# a_9396_11692# 0.01274f
C16 vdd vout 33.1585f
C17 dw_9390_4047# a_9396_11692# 0.03652f
C18 a_8474_2795# a_8232_4131# 0.05211f
C19 vdd vref 2.17332f
C20 a_8474_2725# vdd 5.19837f
C21 a_9396_11692# vref 0.04195f
C22 a_8232_4131# rfin 1.20466f
C23 a_9776_11692# dw_8122_4047# 0.03763f
C24 dw_9390_4047# dw_8122_4047# 2.48837f
C25 a_9776_11692# vout 0.03993f
C26 dw_8122_4047# vout 4.29311f
C27 dw_9390_4047# vout 0.24433f
C28 a_8474_2725# a_9398_2795# 0.02416f
C29 vdd a_12042_5786# 0.0653f
C30 a_9398_2795# a_9398_3295# 0.02622f
C31 dw_8122_4047# vref 0.77553f
C32 dw_9390_4047# vref 0.66034f
C33 a_8474_2725# dw_8122_4047# 0.11747f
C34 a_8474_2725# dw_9390_4047# 0.06199f
C35 dw_9390_4047# a_9398_3295# 0.54686f
C36 vref vout 2.97107f
C37 a_8474_2725# vout 1.11736f
C38 a_8474_2725# vref 0.19179f
C39 vref vss 6.97315f
C40 vout vss 41.71201f
C41 a_8232_4131# vss 0.1611f
C42 dw_9390_4047# vss 0.92636f
C43 vss.t29 vss 0.12762p
.ends
