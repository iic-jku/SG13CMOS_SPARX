** sch_path: /foss/designs/SG13CMOS_SPARX/schematic/sparx_powdet_sbd.sch
.subckt sparx_powdet_sbd vout vref vdd rfin vss
*.PININFO rfin:I vout:O vss:B vdd:B vref:O
RR1 bias1 rfin_int 52.314 $SUB=vss $[rsil] w=0.5e-6 l=2.5e-6
DD1 rfin_int bb_int vss schottky_nbl1
CC2 bias1 vss cap_cmim w=10e-6 l=10e-6 m=30
MM4 vout bb_int vdd vdd sg13_lv_pmos w=100u l=0.13u ng=20
MM3 vout bb_int vss vss sg13_lv_nmos w=50u l=0.13u ng=20
RR2 vout bb_int 910.75 $SUB=vss $[rppd] w=0.5e-6 l=1.5e-6 b=0
MM2 vref bias2 vdd vdd sg13_lv_pmos w=10u l=0.13u ng=2
MM1 vref bias2 vss vss sg13_lv_nmos w=5u l=0.13u ng=2
CC3 vdd vss cap_cmim w=10e-6 l=10e-6 m=28
DD2 net1 bias2 vss schottky_nbl1
RR3 bias1 vdd 6.233k $SUB=vss $[rhigh] w=0.5e-6 l=2e-6 b=0
RR4 vref bias2 910.75 $SUB=vss $[rppd] w=0.5e-6 l=1.5e-6 b=0
RR5 bias1 net1 52.314 $SUB=vss $[rsil] w=0.5e-6 l=2.5e-6
MMdummy1 vss vss vss vss sg13_lv_nmos w=5u l=0.13u ng=2
MMdummy2 vdd vdd vdd vdd sg13_lv_pmos w=10u l=0.13u ng=2
CC1 rfin rfin_int cap_cmim w=10e-6 l=10e-6
CC4 vdd vss cap_cmim w=6.8e-6 l=9e-6 m=2
.ends
