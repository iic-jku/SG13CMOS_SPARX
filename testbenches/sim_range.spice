* auto-generated by snp2le from the loaded Touchstone, overwritten on each run
.csparam f_min=120.000000e+9
.csparam f_max=200.000000e+9
